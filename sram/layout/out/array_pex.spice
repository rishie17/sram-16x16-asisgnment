* NGSPICE file created from array.ext - technology: sky130A

.subckt bitcell BL BLB WL VDD GND Q QB
X0 QB Q VDD VDD sky130_fd_pr__pfet_01v8 ad=0.1848 pd=1.72 as=0.1155 ps=0.97 w=0.42 l=0.15
X1 VDD QB Q VDD sky130_fd_pr__pfet_01v8 ad=0.1155 pd=0.97 as=0.1848 ps=1.72 w=0.42 l=0.15
X2 GND QB Q GND sky130_fd_pr__nfet_01v8 ad=0.17325 pd=1.18 as=0.14437 ps=1.18 w=0.63 l=0.15
X3 Q WL BL GND sky130_fd_pr__nfet_01v8 ad=0.14437 pd=1.18 as=0.1848 ps=1.72 w=0.42 l=0.15
X4 QB Q GND GND sky130_fd_pr__nfet_01v8 ad=0.14437 pd=1.18 as=0.17325 ps=1.18 w=0.63 l=0.15
X5 BLB WL QB GND sky130_fd_pr__nfet_01v8 ad=0.1848 pd=1.72 as=0.14437 ps=1.18 w=0.42 l=0.15
C0 BLB VDD 0.06361f
C1 BL BLB 0.03241f
C2 QB VDD 0.1111f
C3 BL QB 0.01314f
C4 WL Q 0.01804f
C5 WL VDD 0.01593f
C6 Q VDD 0.08548f
C7 BLB QB 0.0343f
C8 WL BL 0.01664f
C9 BL Q 0.0343f
C10 BL VDD 0.06361f
C11 WL BLB 0.01664f
C12 BLB Q 0.01314f
C13 WL QB 0.01626f
C14 QB Q 0.14815f
C15 BLB GND 0.26233f
C16 BL GND 0.54984f
C17 QB GND 0.246f
C18 VDD GND 1.10678f
.ends

.subckt array
Xc_11_1 c_9_1/BL c_9_1/BLB c_11_9/WL c_11_9/VDD VSUBS c_11_1/Q c_11_1/QB bitcell
Xc_3_14 c_9_14/BL c_9_14/BLB c_3_9/WL c_3_9/VDD VSUBS c_3_14/Q c_3_14/QB bitcell
Xc_0_15 c_9_15/BL c_9_15/BLB c_0_9/WL c_1_9/VDD VSUBS c_0_15/Q c_0_15/QB bitcell
Xc_15_8 c_9_8/BL c_9_8/BLB c_15_9/WL c_15_9/VDD VSUBS c_15_8/Q c_15_8/QB bitcell
Xc_9_13 c_9_13/BL c_9_13/BLB c_9_9/WL c_9_9/VDD VSUBS c_9_13/Q c_9_13/QB bitcell
Xc_3_7 c_9_7/BL c_9_7/BLB c_3_9/WL c_3_9/VDD VSUBS c_3_7/Q c_3_7/QB bitcell
Xc_13_5 c_9_5/BL c_9_5/BLB c_13_9/WL c_13_9/VDD VSUBS c_13_5/Q c_13_5/QB bitcell
Xc_11_2 c_9_2/BL c_9_2/BLB c_11_9/WL c_11_9/VDD VSUBS c_11_2/Q c_11_2/QB bitcell
Xc_6_14 c_9_14/BL c_9_14/BLB c_6_9/WL c_7_9/VDD VSUBS c_6_14/Q c_6_14/QB bitcell
Xc_1_4 c_9_4/BL c_9_4/BLB c_1_9/WL c_1_9/VDD VSUBS c_1_4/Q c_1_4/QB bitcell
Xc_3_15 c_9_15/BL c_9_15/BLB c_3_9/WL c_3_9/VDD VSUBS c_3_15/Q c_3_15/QB bitcell
Xc_11_10 c_9_10/BL c_9_10/BLB c_11_9/WL c_11_9/VDD VSUBS c_11_10/Q c_11_10/QB bitcell
Xc_9_14 c_9_14/BL c_9_14/BLB c_9_9/WL c_9_9/VDD VSUBS c_9_14/Q c_9_14/QB bitcell
Xc_15_9 c_9_9/BL c_9_9/BLB c_15_9/WL c_15_9/VDD VSUBS c_15_9/Q c_15_9/QB bitcell
Xc_13_6 c_9_6/BL c_9_6/BLB c_13_9/WL c_13_9/VDD VSUBS c_13_6/Q c_13_6/QB bitcell
Xc_6_15 c_9_15/BL c_9_15/BLB c_6_9/WL c_7_9/VDD VSUBS c_6_15/Q c_6_15/QB bitcell
Xc_1_5 c_9_5/BL c_9_5/BLB c_1_9/WL c_1_9/VDD VSUBS c_1_5/Q c_1_5/QB bitcell
Xc_3_8 c_9_8/BL c_9_8/BLB c_3_9/WL c_3_9/VDD VSUBS c_3_8/Q c_3_8/QB bitcell
Xc_14_10 c_9_10/BL c_9_10/BLB c_14_9/WL c_15_9/VDD VSUBS c_14_10/Q c_14_10/QB bitcell
Xc_11_3 c_9_3/BL c_9_3/BLB c_11_9/WL c_11_9/VDD VSUBS c_11_3/Q c_11_3/QB bitcell
Xc_11_11 c_9_11/BL c_9_11/BLB c_11_9/WL c_11_9/VDD VSUBS c_11_11/Q c_11_11/QB bitcell
Xc_9_15 c_9_15/BL c_9_15/BLB c_9_9/WL c_9_9/VDD VSUBS c_9_15/Q c_9_15/QB bitcell
Xc_3_9 c_9_9/BL c_9_9/BLB c_3_9/WL c_3_9/VDD VSUBS c_3_9/Q c_3_9/QB bitcell
Xc_13_7 c_9_7/BL c_9_7/BLB c_13_9/WL c_13_9/VDD VSUBS c_13_7/Q c_13_7/QB bitcell
Xc_1_6 c_9_6/BL c_9_6/BLB c_1_9/WL c_1_9/VDD VSUBS c_1_6/Q c_1_6/QB bitcell
Xc_14_11 c_9_11/BL c_9_11/BLB c_14_9/WL c_15_9/VDD VSUBS c_14_11/Q c_14_11/QB bitcell
Xc_11_4 c_9_4/BL c_9_4/BLB c_11_9/WL c_11_9/VDD VSUBS c_11_4/Q c_11_4/QB bitcell
Xc_11_12 c_9_12/BL c_9_12/BLB c_11_9/WL c_11_9/VDD VSUBS c_11_12/Q c_11_12/QB bitcell
Xc_13_8 c_9_8/BL c_9_8/BLB c_13_9/WL c_13_9/VDD VSUBS c_13_8/Q c_13_8/QB bitcell
Xc_8_0 c_9_0/BL c_9_0/BLB c_8_9/WL c_9_9/VDD VSUBS c_8_0/Q c_8_0/QB bitcell
Xc_1_7 c_9_7/BL c_9_7/BLB c_1_9/WL c_1_9/VDD VSUBS c_1_7/Q c_1_7/QB bitcell
Xc_14_12 c_9_12/BL c_9_12/BLB c_14_9/WL c_15_9/VDD VSUBS c_14_12/Q c_14_12/QB bitcell
Xc_11_5 c_9_5/BL c_9_5/BLB c_11_9/WL c_11_9/VDD VSUBS c_11_5/Q c_11_5/QB bitcell
Xc_11_13 c_9_13/BL c_9_13/BLB c_11_9/WL c_11_9/VDD VSUBS c_11_13/Q c_11_13/QB bitcell
Xc_8_1 c_9_1/BL c_9_1/BLB c_8_9/WL c_9_9/VDD VSUBS c_8_1/Q c_8_1/QB bitcell
Xc_13_9 c_9_9/BL c_9_9/BLB c_13_9/WL c_13_9/VDD VSUBS c_13_9/Q c_13_9/QB bitcell
Xc_1_8 c_9_8/BL c_9_8/BLB c_1_9/WL c_1_9/VDD VSUBS c_1_8/Q c_1_8/QB bitcell
Xc_14_13 c_9_13/BL c_9_13/BLB c_14_9/WL c_15_9/VDD VSUBS c_14_13/Q c_14_13/QB bitcell
Xc_11_6 c_9_6/BL c_9_6/BLB c_11_9/WL c_11_9/VDD VSUBS c_11_6/Q c_11_6/QB bitcell
Xc_11_14 c_9_14/BL c_9_14/BLB c_11_9/WL c_11_9/VDD VSUBS c_11_14/Q c_11_14/QB bitcell
Xc_8_2 c_9_2/BL c_9_2/BLB c_8_9/WL c_9_9/VDD VSUBS c_8_2/Q c_8_2/QB bitcell
Xc_1_9 c_9_9/BL c_9_9/BLB c_1_9/WL c_1_9/VDD VSUBS c_1_9/Q c_1_9/QB bitcell
Xc_14_14 c_9_14/BL c_9_14/BLB c_14_9/WL c_15_9/VDD VSUBS c_14_14/Q c_14_14/QB bitcell
Xc_11_7 c_9_7/BL c_9_7/BLB c_11_9/WL c_11_9/VDD VSUBS c_11_7/Q c_11_7/QB bitcell
Xc_11_15 c_9_15/BL c_9_15/BLB c_11_9/WL c_11_9/VDD VSUBS c_11_15/Q c_11_15/QB bitcell
Xc_8_3 c_9_3/BL c_9_3/BLB c_8_9/WL c_9_9/VDD VSUBS c_8_3/Q c_8_3/QB bitcell
Xc_6_0 c_9_0/BL c_9_0/BLB c_6_9/WL c_7_9/VDD VSUBS c_6_0/Q c_6_0/QB bitcell
Xc_14_15 c_9_15/BL c_9_15/BLB c_14_9/WL c_15_9/VDD VSUBS c_14_15/Q c_14_15/QB bitcell
Xc_11_8 c_9_8/BL c_9_8/BLB c_11_9/WL c_11_9/VDD VSUBS c_11_8/Q c_11_8/QB bitcell
Xc_8_4 c_9_4/BL c_9_4/BLB c_8_9/WL c_9_9/VDD VSUBS c_8_4/Q c_8_4/QB bitcell
Xc_1_10 c_9_10/BL c_9_10/BLB c_1_9/WL c_1_9/VDD VSUBS c_1_10/Q c_1_10/QB bitcell
Xc_11_9 c_9_9/BL c_9_9/BLB c_11_9/WL c_11_9/VDD VSUBS c_11_9/Q c_11_9/QB bitcell
Xc_6_1 c_9_1/BL c_9_1/BLB c_6_9/WL c_7_9/VDD VSUBS c_6_1/Q c_6_1/QB bitcell
Xc_4_10 c_9_10/BL c_9_10/BLB c_4_9/WL c_5_9/VDD VSUBS c_4_10/Q c_4_10/QB bitcell
Xc_8_5 c_9_5/BL c_9_5/BLB c_8_9/WL c_9_9/VDD VSUBS c_8_5/Q c_8_5/QB bitcell
Xc_1_11 c_9_11/BL c_9_11/BLB c_1_9/WL c_1_9/VDD VSUBS c_1_11/Q c_1_11/QB bitcell
Xc_6_2 c_9_2/BL c_9_2/BLB c_6_9/WL c_7_9/VDD VSUBS c_6_2/Q c_6_2/QB bitcell
Xc_7_10 c_9_10/BL c_9_10/BLB c_7_9/WL c_7_9/VDD VSUBS c_7_10/Q c_7_10/QB bitcell
Xc_4_11 c_9_11/BL c_9_11/BLB c_4_9/WL c_5_9/VDD VSUBS c_4_11/Q c_4_11/QB bitcell
Xc_8_6 c_9_6/BL c_9_6/BLB c_8_9/WL c_9_9/VDD VSUBS c_8_6/Q c_8_6/QB bitcell
Xc_1_12 c_9_12/BL c_9_12/BLB c_1_9/WL c_1_9/VDD VSUBS c_1_12/Q c_1_12/QB bitcell
Xc_6_3 c_9_3/BL c_9_3/BLB c_6_9/WL c_7_9/VDD VSUBS c_6_3/Q c_6_3/QB bitcell
Xc_7_11 c_9_11/BL c_9_11/BLB c_7_9/WL c_7_9/VDD VSUBS c_7_11/Q c_7_11/QB bitcell
Xc_4_0 c_9_0/BL c_9_0/BLB c_4_9/WL c_5_9/VDD VSUBS c_4_0/Q c_4_0/QB bitcell
Xc_4_12 c_9_12/BL c_9_12/BLB c_4_9/WL c_5_9/VDD VSUBS c_4_12/Q c_4_12/QB bitcell
Xc_8_7 c_9_7/BL c_9_7/BLB c_8_9/WL c_9_9/VDD VSUBS c_8_7/Q c_8_7/QB bitcell
Xc_1_13 c_9_13/BL c_9_13/BLB c_1_9/WL c_1_9/VDD VSUBS c_1_13/Q c_1_13/QB bitcell
Xc_6_4 c_9_4/BL c_9_4/BLB c_6_9/WL c_7_9/VDD VSUBS c_6_4/Q c_6_4/QB bitcell
Xc_7_12 c_9_12/BL c_9_12/BLB c_7_9/WL c_7_9/VDD VSUBS c_7_12/Q c_7_12/QB bitcell
Xc_4_1 c_9_1/BL c_9_1/BLB c_4_9/WL c_5_9/VDD VSUBS c_4_1/Q c_4_1/QB bitcell
Xc_4_13 c_9_13/BL c_9_13/BLB c_4_9/WL c_5_9/VDD VSUBS c_4_13/Q c_4_13/QB bitcell
Xc_8_8 c_9_8/BL c_9_8/BLB c_8_9/WL c_9_9/VDD VSUBS c_8_8/Q c_8_8/QB bitcell
Xc_1_14 c_9_14/BL c_9_14/BLB c_1_9/WL c_1_9/VDD VSUBS c_1_14/Q c_1_14/QB bitcell
Xc_6_5 c_9_5/BL c_9_5/BLB c_6_9/WL c_7_9/VDD VSUBS c_6_5/Q c_6_5/QB bitcell
Xc_14_0 c_9_0/BL c_9_0/BLB c_14_9/WL c_15_9/VDD VSUBS c_14_0/Q c_14_0/QB bitcell
Xc_7_13 c_9_13/BL c_9_13/BLB c_7_9/WL c_7_9/VDD VSUBS c_7_13/Q c_7_13/QB bitcell
Xc_4_2 c_9_2/BL c_9_2/BLB c_4_9/WL c_5_9/VDD VSUBS c_4_2/Q c_4_2/QB bitcell
Xc_4_14 c_9_14/BL c_9_14/BLB c_4_9/WL c_5_9/VDD VSUBS c_4_14/Q c_4_14/QB bitcell
Xc_8_9 c_9_9/BL c_9_9/BLB c_8_9/WL c_9_9/VDD VSUBS c_8_9/Q c_8_9/QB bitcell
Xc_1_15 c_9_15/BL c_9_15/BLB c_1_9/WL c_1_9/VDD VSUBS c_1_15/Q c_1_15/QB bitcell
Xc_7_14 c_9_14/BL c_9_14/BLB c_7_9/WL c_7_9/VDD VSUBS c_7_14/Q c_7_14/QB bitcell
Xc_6_6 c_9_6/BL c_9_6/BLB c_6_9/WL c_7_9/VDD VSUBS c_6_6/Q c_6_6/QB bitcell
Xc_4_3 c_9_3/BL c_9_3/BLB c_4_9/WL c_5_9/VDD VSUBS c_4_3/Q c_4_3/QB bitcell
Xc_14_1 c_9_1/BL c_9_1/BLB c_14_9/WL c_15_9/VDD VSUBS c_14_1/Q c_14_1/QB bitcell
Xc_2_0 c_9_0/BL c_9_0/BLB c_2_9/WL c_3_9/VDD VSUBS c_2_0/Q c_2_0/QB bitcell
Xc_4_15 c_9_15/BL c_9_15/BLB c_4_9/WL c_5_9/VDD VSUBS c_4_15/Q c_4_15/QB bitcell
Xc_12_10 c_9_10/BL c_9_10/BLB c_12_9/WL c_13_9/VDD VSUBS c_12_10/Q c_12_10/QB bitcell
Xc_6_7 c_9_7/BL c_9_7/BLB c_6_9/WL c_7_9/VDD VSUBS c_6_7/Q c_6_7/QB bitcell
Xc_14_2 c_9_2/BL c_9_2/BLB c_14_9/WL c_15_9/VDD VSUBS c_14_2/Q c_14_2/QB bitcell
Xc_7_15 c_9_15/BL c_9_15/BLB c_7_9/WL c_7_9/VDD VSUBS c_7_15/Q c_7_15/QB bitcell
Xc_2_1 c_9_1/BL c_9_1/BLB c_2_9/WL c_3_9/VDD VSUBS c_2_1/Q c_2_1/QB bitcell
Xc_4_4 c_9_4/BL c_9_4/BLB c_4_9/WL c_5_9/VDD VSUBS c_4_4/Q c_4_4/QB bitcell
Xc_15_10 c_9_10/BL c_9_10/BLB c_15_9/WL c_15_9/VDD VSUBS c_15_10/Q c_15_10/QB bitcell
Xc_12_11 c_9_11/BL c_9_11/BLB c_12_9/WL c_13_9/VDD VSUBS c_12_11/Q c_12_11/QB bitcell
Xc_6_8 c_9_8/BL c_9_8/BLB c_6_9/WL c_7_9/VDD VSUBS c_6_8/Q c_6_8/QB bitcell
Xc_4_5 c_9_5/BL c_9_5/BLB c_4_9/WL c_5_9/VDD VSUBS c_4_5/Q c_4_5/QB bitcell
Xc_15_11 c_9_11/BL c_9_11/BLB c_15_9/WL c_15_9/VDD VSUBS c_15_11/Q c_15_11/QB bitcell
Xc_14_3 c_9_3/BL c_9_3/BLB c_14_9/WL c_15_9/VDD VSUBS c_14_3/Q c_14_3/QB bitcell
Xc_2_2 c_9_2/BL c_9_2/BLB c_2_9/WL c_3_9/VDD VSUBS c_2_2/Q c_2_2/QB bitcell
Xc_12_12 c_9_12/BL c_9_12/BLB c_12_9/WL c_13_9/VDD VSUBS c_12_12/Q c_12_12/QB bitcell
Xc_12_0 c_9_0/BL c_9_0/BLB c_12_9/WL c_13_9/VDD VSUBS c_12_0/Q c_12_0/QB bitcell
Xc_6_9 c_9_9/BL c_9_9/BLB c_6_9/WL c_7_9/VDD VSUBS c_6_9/Q c_6_9/QB bitcell
Xc_4_6 c_9_6/BL c_9_6/BLB c_4_9/WL c_5_9/VDD VSUBS c_4_6/Q c_4_6/QB bitcell
Xc_15_12 c_9_12/BL c_9_12/BLB c_15_9/WL c_15_9/VDD VSUBS c_15_12/Q c_15_12/QB bitcell
Xc_14_4 c_9_4/BL c_9_4/BLB c_14_9/WL c_15_9/VDD VSUBS c_14_4/Q c_14_4/QB bitcell
Xc_12_1 c_9_1/BL c_9_1/BLB c_12_9/WL c_13_9/VDD VSUBS c_12_1/Q c_12_1/QB bitcell
Xc_0_0 c_9_0/BL c_9_0/BLB c_0_9/WL c_1_9/VDD VSUBS c_0_0/Q c_0_0/QB bitcell
Xc_2_3 c_9_3/BL c_9_3/BLB c_2_9/WL c_3_9/VDD VSUBS c_2_3/Q c_2_3/QB bitcell
Xc_12_13 c_9_13/BL c_9_13/BLB c_12_9/WL c_13_9/VDD VSUBS c_12_13/Q c_12_13/QB bitcell
Xc_4_7 c_9_7/BL c_9_7/BLB c_4_9/WL c_5_9/VDD VSUBS c_4_7/Q c_4_7/QB bitcell
Xc_15_13 c_9_13/BL c_9_13/BLB c_15_9/WL c_15_9/VDD VSUBS c_15_13/Q c_15_13/QB bitcell
Xc_14_5 c_9_5/BL c_9_5/BLB c_14_9/WL c_15_9/VDD VSUBS c_14_5/Q c_14_5/QB bitcell
Xc_2_4 c_9_4/BL c_9_4/BLB c_2_9/WL c_3_9/VDD VSUBS c_2_4/Q c_2_4/QB bitcell
Xc_12_14 c_9_14/BL c_9_14/BLB c_12_9/WL c_13_9/VDD VSUBS c_12_14/Q c_12_14/QB bitcell
Xc_12_2 c_9_2/BL c_9_2/BLB c_12_9/WL c_13_9/VDD VSUBS c_12_2/Q c_12_2/QB bitcell
Xc_0_1 c_9_1/BL c_9_1/BLB c_0_9/WL c_1_9/VDD VSUBS c_0_1/Q c_0_1/QB bitcell
Xc_4_8 c_9_8/BL c_9_8/BLB c_4_9/WL c_5_9/VDD VSUBS c_4_8/Q c_4_8/QB bitcell
Xc_15_14 c_9_14/BL c_9_14/BLB c_15_9/WL c_15_9/VDD VSUBS c_15_14/Q c_15_14/QB bitcell
Xc_14_6 c_9_6/BL c_9_6/BLB c_14_9/WL c_15_9/VDD VSUBS c_14_6/Q c_14_6/QB bitcell
Xc_12_3 c_9_3/BL c_9_3/BLB c_12_9/WL c_13_9/VDD VSUBS c_12_3/Q c_12_3/QB bitcell
Xc_0_2 c_9_2/BL c_9_2/BLB c_0_9/WL c_1_9/VDD VSUBS c_0_2/Q c_0_2/QB bitcell
Xc_2_5 c_9_5/BL c_9_5/BLB c_2_9/WL c_3_9/VDD VSUBS c_2_5/Q c_2_5/QB bitcell
Xc_12_15 c_9_15/BL c_9_15/BLB c_12_9/WL c_13_9/VDD VSUBS c_12_15/Q c_12_15/QB bitcell
Xc_10_0 c_9_0/BL c_9_0/BLB c_10_9/WL c_11_9/VDD VSUBS c_10_0/Q c_10_0/QB bitcell
Xc_15_15 c_9_15/BL c_9_15/BLB c_15_9/WL c_15_9/VDD VSUBS c_15_15/Q c_15_15/QB bitcell
Xc_14_7 c_9_7/BL c_9_7/BLB c_14_9/WL c_15_9/VDD VSUBS c_14_7/Q c_14_7/QB bitcell
Xc_2_6 c_9_6/BL c_9_6/BLB c_2_9/WL c_3_9/VDD VSUBS c_2_6/Q c_2_6/QB bitcell
Xc_4_9 c_9_9/BL c_9_9/BLB c_4_9/WL c_5_9/VDD VSUBS c_4_9/Q c_4_9/QB bitcell
Xc_12_4 c_9_4/BL c_9_4/BLB c_12_9/WL c_13_9/VDD VSUBS c_12_4/Q c_12_4/QB bitcell
Xc_0_3 c_9_3/BL c_9_3/BLB c_0_9/WL c_1_9/VDD VSUBS c_0_3/Q c_0_3/QB bitcell
Xc_10_1 c_9_1/BL c_9_1/BLB c_10_9/WL c_11_9/VDD VSUBS c_10_1/Q c_10_1/QB bitcell
Xc_9_0 c_9_0/BL c_9_0/BLB c_9_9/WL c_9_9/VDD VSUBS c_9_0/Q c_9_0/QB bitcell
Xc_2_10 c_9_10/BL c_9_10/BLB c_2_9/WL c_3_9/VDD VSUBS c_2_10/Q c_2_10/QB bitcell
Xc_14_8 c_9_8/BL c_9_8/BLB c_14_9/WL c_15_9/VDD VSUBS c_14_8/Q c_14_8/QB bitcell
Xc_12_5 c_9_5/BL c_9_5/BLB c_12_9/WL c_13_9/VDD VSUBS c_12_5/Q c_12_5/QB bitcell
Xc_0_4 c_9_4/BL c_9_4/BLB c_0_9/WL c_1_9/VDD VSUBS c_0_4/Q c_0_4/QB bitcell
Xc_2_7 c_9_7/BL c_9_7/BLB c_2_9/WL c_3_9/VDD VSUBS c_2_7/Q c_2_7/QB bitcell
Xc_10_2 c_9_2/BL c_9_2/BLB c_10_9/WL c_11_9/VDD VSUBS c_10_2/Q c_10_2/QB bitcell
Xc_5_10 c_9_10/BL c_9_10/BLB c_5_9/WL c_5_9/VDD VSUBS c_5_10/Q c_5_10/QB bitcell
Xc_2_11 c_9_11/BL c_9_11/BLB c_2_9/WL c_3_9/VDD VSUBS c_2_11/Q c_2_11/QB bitcell
Xc_14_9 c_9_9/BL c_9_9/BLB c_14_9/WL c_15_9/VDD VSUBS c_14_9/Q c_14_9/QB bitcell
Xc_8_10 c_9_10/BL c_9_10/BLB c_8_9/WL c_9_9/VDD VSUBS c_8_10/Q c_8_10/QB bitcell
Xc_9_1 c_9_1/BL c_9_1/BLB c_9_9/WL c_9_9/VDD VSUBS c_9_1/Q c_9_1/QB bitcell
Xc_2_8 c_9_8/BL c_9_8/BLB c_2_9/WL c_3_9/VDD VSUBS c_2_8/Q c_2_8/QB bitcell
Xc_12_6 c_9_6/BL c_9_6/BLB c_12_9/WL c_13_9/VDD VSUBS c_12_6/Q c_12_6/QB bitcell
Xc_0_5 c_9_5/BL c_9_5/BLB c_0_9/WL c_1_9/VDD VSUBS c_0_5/Q c_0_5/QB bitcell
Xc_10_3 c_9_3/BL c_9_3/BLB c_10_9/WL c_11_9/VDD VSUBS c_10_3/Q c_10_3/QB bitcell
Xc_5_11 c_9_11/BL c_9_11/BLB c_5_9/WL c_5_9/VDD VSUBS c_5_11/Q c_5_11/QB bitcell
Xc_9_2 c_9_2/BL c_9_2/BLB c_9_9/WL c_9_9/VDD VSUBS c_9_2/Q c_9_2/QB bitcell
Xc_2_12 c_9_12/BL c_9_12/BLB c_2_9/WL c_3_9/VDD VSUBS c_2_12/Q c_2_12/QB bitcell
Xc_8_11 c_9_11/BL c_9_11/BLB c_8_9/WL c_9_9/VDD VSUBS c_8_11/Q c_8_11/QB bitcell
Xc_0_6 c_9_6/BL c_9_6/BLB c_0_9/WL c_1_9/VDD VSUBS c_0_6/Q c_0_6/QB bitcell
Xc_2_9 c_9_9/BL c_9_9/BLB c_2_9/WL c_3_9/VDD VSUBS c_2_9/Q c_2_9/QB bitcell
Xc_12_7 c_9_7/BL c_9_7/BLB c_12_9/WL c_13_9/VDD VSUBS c_12_7/Q c_12_7/QB bitcell
Xc_10_4 c_9_4/BL c_9_4/BLB c_10_9/WL c_11_9/VDD VSUBS c_10_4/Q c_10_4/QB bitcell
Xc_5_12 c_9_12/BL c_9_12/BLB c_5_9/WL c_5_9/VDD VSUBS c_5_12/Q c_5_12/QB bitcell
Xc_2_13 c_9_13/BL c_9_13/BLB c_2_9/WL c_3_9/VDD VSUBS c_2_13/Q c_2_13/QB bitcell
Xc_9_3 c_9_3/BL c_9_3/BLB c_9_9/WL c_9_9/VDD VSUBS c_9_3/Q c_9_3/QB bitcell
Xc_12_8 c_9_8/BL c_9_8/BLB c_12_9/WL c_13_9/VDD VSUBS c_12_8/Q c_12_8/QB bitcell
Xc_8_12 c_9_12/BL c_9_12/BLB c_8_9/WL c_9_9/VDD VSUBS c_8_12/Q c_8_12/QB bitcell
Xc_0_7 c_9_7/BL c_9_7/BLB c_0_9/WL c_1_9/VDD VSUBS c_0_7/Q c_0_7/QB bitcell
Xc_7_0 c_9_0/BL c_9_0/BLB c_7_9/WL c_7_9/VDD VSUBS c_7_0/Q c_7_0/QB bitcell
Xc_10_5 c_9_5/BL c_9_5/BLB c_10_9/WL c_11_9/VDD VSUBS c_10_5/Q c_10_5/QB bitcell
Xc_5_13 c_9_13/BL c_9_13/BLB c_5_9/WL c_5_9/VDD VSUBS c_5_13/Q c_5_13/QB bitcell
Xc_9_4 c_9_4/BL c_9_4/BLB c_9_9/WL c_9_9/VDD VSUBS c_9_4/Q c_9_4/QB bitcell
Xc_2_14 c_9_14/BL c_9_14/BLB c_2_9/WL c_3_9/VDD VSUBS c_2_14/Q c_2_14/QB bitcell
Xc_8_13 c_9_13/BL c_9_13/BLB c_8_9/WL c_9_9/VDD VSUBS c_8_13/Q c_8_13/QB bitcell
Xc_7_1 c_9_1/BL c_9_1/BLB c_7_9/WL c_7_9/VDD VSUBS c_7_1/Q c_7_1/QB bitcell
Xc_12_9 c_9_9/BL c_9_9/BLB c_12_9/WL c_13_9/VDD VSUBS c_12_9/Q c_12_9/QB bitcell
Xc_10_6 c_9_6/BL c_9_6/BLB c_10_9/WL c_11_9/VDD VSUBS c_10_6/Q c_10_6/QB bitcell
Xc_5_14 c_9_14/BL c_9_14/BLB c_5_9/WL c_5_9/VDD VSUBS c_5_14/Q c_5_14/QB bitcell
Xc_0_8 c_9_8/BL c_9_8/BLB c_0_9/WL c_1_9/VDD VSUBS c_0_8/Q c_0_8/QB bitcell
Xc_2_15 c_9_15/BL c_9_15/BLB c_2_9/WL c_3_9/VDD VSUBS c_2_15/Q c_2_15/QB bitcell
Xc_10_10 c_9_10/BL c_9_10/BLB c_10_9/WL c_11_9/VDD VSUBS c_10_10/Q c_10_10/QB bitcell
Xc_9_5 c_9_5/BL c_9_5/BLB c_9_9/WL c_9_9/VDD VSUBS c_9_5/Q c_9_5/QB bitcell
Xc_8_14 c_9_14/BL c_9_14/BLB c_8_9/WL c_9_9/VDD VSUBS c_8_14/Q c_8_14/QB bitcell
Xc_0_9 c_9_9/BL c_9_9/BLB c_0_9/WL c_1_9/VDD VSUBS c_0_9/Q c_0_9/QB bitcell
Xc_7_2 c_9_2/BL c_9_2/BLB c_7_9/WL c_7_9/VDD VSUBS c_7_2/Q c_7_2/QB bitcell
Xc_10_7 c_9_7/BL c_9_7/BLB c_10_9/WL c_11_9/VDD VSUBS c_10_7/Q c_10_7/QB bitcell
Xc_5_15 c_9_15/BL c_9_15/BLB c_5_9/WL c_5_9/VDD VSUBS c_5_15/Q c_5_15/QB bitcell
Xc_13_10 c_9_10/BL c_9_10/BLB c_13_9/WL c_13_9/VDD VSUBS c_13_10/Q c_13_10/QB bitcell
Xc_10_11 c_9_11/BL c_9_11/BLB c_10_9/WL c_11_9/VDD VSUBS c_10_11/Q c_10_11/QB bitcell
Xc_8_15 c_9_15/BL c_9_15/BLB c_8_9/WL c_9_9/VDD VSUBS c_8_15/Q c_8_15/QB bitcell
Xc_9_6 c_9_6/BL c_9_6/BLB c_9_9/WL c_9_9/VDD VSUBS c_9_6/Q c_9_6/QB bitcell
Xc_7_3 c_9_3/BL c_9_3/BLB c_7_9/WL c_7_9/VDD VSUBS c_7_3/Q c_7_3/QB bitcell
Xc_10_8 c_9_8/BL c_9_8/BLB c_10_9/WL c_11_9/VDD VSUBS c_10_8/Q c_10_8/QB bitcell
Xc_5_0 c_9_0/BL c_9_0/BLB c_5_9/WL c_5_9/VDD VSUBS c_5_0/Q c_5_0/QB bitcell
Xc_13_11 c_9_11/BL c_9_11/BLB c_13_9/WL c_13_9/VDD VSUBS c_13_11/Q c_13_11/QB bitcell
Xc_10_12 c_9_12/BL c_9_12/BLB c_10_9/WL c_11_9/VDD VSUBS c_10_12/Q c_10_12/QB bitcell
Xc_9_7 c_9_7/BL c_9_7/BLB c_9_9/WL c_9_9/VDD VSUBS c_9_7/Q c_9_7/QB bitcell
Xc_5_1 c_9_1/BL c_9_1/BLB c_5_9/WL c_5_9/VDD VSUBS c_5_1/Q c_5_1/QB bitcell
Xc_7_4 c_9_4/BL c_9_4/BLB c_7_9/WL c_7_9/VDD VSUBS c_7_4/Q c_7_4/QB bitcell
Xc_10_9 c_9_9/BL c_9_9/BLB c_10_9/WL c_11_9/VDD VSUBS c_10_9/Q c_10_9/QB bitcell
Xc_13_12 c_9_12/BL c_9_12/BLB c_13_9/WL c_13_9/VDD VSUBS c_13_12/Q c_13_12/QB bitcell
Xc_10_13 c_9_13/BL c_9_13/BLB c_10_9/WL c_11_9/VDD VSUBS c_10_13/Q c_10_13/QB bitcell
Xc_9_8 c_9_8/BL c_9_8/BLB c_9_9/WL c_9_9/VDD VSUBS c_9_8/Q c_9_8/QB bitcell
Xc_7_5 c_9_5/BL c_9_5/BLB c_7_9/WL c_7_9/VDD VSUBS c_7_5/Q c_7_5/QB bitcell
Xc_5_2 c_9_2/BL c_9_2/BLB c_5_9/WL c_5_9/VDD VSUBS c_5_2/Q c_5_2/QB bitcell
Xc_15_0 c_9_0/BL c_9_0/BLB c_15_9/WL c_15_9/VDD VSUBS c_15_0/Q c_15_0/QB bitcell
Xc_13_13 c_9_13/BL c_9_13/BLB c_13_9/WL c_13_9/VDD VSUBS c_13_13/Q c_13_13/QB bitcell
Xc_9_9 c_9_9/BL c_9_9/BLB c_9_9/WL c_9_9/VDD VSUBS c_9_9/Q c_9_9/QB bitcell
Xc_10_14 c_9_14/BL c_9_14/BLB c_10_9/WL c_11_9/VDD VSUBS c_10_14/Q c_10_14/QB bitcell
Xc_7_6 c_9_6/BL c_9_6/BLB c_7_9/WL c_7_9/VDD VSUBS c_7_6/Q c_7_6/QB bitcell
Xc_15_1 c_9_1/BL c_9_1/BLB c_15_9/WL c_15_9/VDD VSUBS c_15_1/Q c_15_1/QB bitcell
Xc_3_0 c_9_0/BL c_9_0/BLB c_3_9/WL c_3_9/VDD VSUBS c_3_0/Q c_3_0/QB bitcell
Xc_5_3 c_9_3/BL c_9_3/BLB c_5_9/WL c_5_9/VDD VSUBS c_5_3/Q c_5_3/QB bitcell
Xc_13_14 c_9_14/BL c_9_14/BLB c_13_9/WL c_13_9/VDD VSUBS c_13_14/Q c_13_14/QB bitcell
Xc_10_15 c_9_15/BL c_9_15/BLB c_10_9/WL c_11_9/VDD VSUBS c_10_15/Q c_10_15/QB bitcell
Xc_7_7 c_9_7/BL c_9_7/BLB c_7_9/WL c_7_9/VDD VSUBS c_7_7/Q c_7_7/QB bitcell
Xc_5_4 c_9_4/BL c_9_4/BLB c_5_9/WL c_5_9/VDD VSUBS c_5_4/Q c_5_4/QB bitcell
Xc_15_2 c_9_2/BL c_9_2/BLB c_15_9/WL c_15_9/VDD VSUBS c_15_2/Q c_15_2/QB bitcell
Xc_13_15 c_9_15/BL c_9_15/BLB c_13_9/WL c_13_9/VDD VSUBS c_13_15/Q c_13_15/QB bitcell
Xc_3_1 c_9_1/BL c_9_1/BLB c_3_9/WL c_3_9/VDD VSUBS c_3_1/Q c_3_1/QB bitcell
Xc_7_8 c_9_8/BL c_9_8/BLB c_7_9/WL c_7_9/VDD VSUBS c_7_8/Q c_7_8/QB bitcell
Xc_15_3 c_9_3/BL c_9_3/BLB c_15_9/WL c_15_9/VDD VSUBS c_15_3/Q c_15_3/QB bitcell
Xc_5_5 c_9_5/BL c_9_5/BLB c_5_9/WL c_5_9/VDD VSUBS c_5_5/Q c_5_5/QB bitcell
Xc_0_10 c_9_10/BL c_9_10/BLB c_0_9/WL c_1_9/VDD VSUBS c_0_10/Q c_0_10/QB bitcell
Xc_3_2 c_9_2/BL c_9_2/BLB c_3_9/WL c_3_9/VDD VSUBS c_3_2/Q c_3_2/QB bitcell
Xc_13_0 c_9_0/BL c_9_0/BLB c_13_9/WL c_13_9/VDD VSUBS c_13_0/Q c_13_0/QB bitcell
Xc_3_10 c_9_10/BL c_9_10/BLB c_3_9/WL c_3_9/VDD VSUBS c_3_10/Q c_3_10/QB bitcell
Xc_7_9 c_9_9/BL c_9_9/BLB c_7_9/WL c_7_9/VDD VSUBS c_7_9/Q c_7_9/QB bitcell
Xc_5_6 c_9_6/BL c_9_6/BLB c_5_9/WL c_5_9/VDD VSUBS c_5_6/Q c_5_6/QB bitcell
Xc_0_11 c_9_11/BL c_9_11/BLB c_0_9/WL c_1_9/VDD VSUBS c_0_11/Q c_0_11/QB bitcell
Xc_15_4 c_9_4/BL c_9_4/BLB c_15_9/WL c_15_9/VDD VSUBS c_15_4/Q c_15_4/QB bitcell
Xc_3_3 c_9_3/BL c_9_3/BLB c_3_9/WL c_3_9/VDD VSUBS c_3_3/Q c_3_3/QB bitcell
Xc_13_1 c_9_1/BL c_9_1/BLB c_13_9/WL c_13_9/VDD VSUBS c_13_1/Q c_13_1/QB bitcell
Xc_6_10 c_9_10/BL c_9_10/BLB c_6_9/WL c_7_9/VDD VSUBS c_6_10/Q c_6_10/QB bitcell
Xc_1_0 c_9_0/BL c_9_0/BLB c_1_9/WL c_1_9/VDD VSUBS c_1_0/Q c_1_0/QB bitcell
Xc_3_11 c_9_11/BL c_9_11/BLB c_3_9/WL c_3_9/VDD VSUBS c_3_11/Q c_3_11/QB bitcell
Xc_15_5 c_9_5/BL c_9_5/BLB c_15_9/WL c_15_9/VDD VSUBS c_15_5/Q c_15_5/QB bitcell
Xc_9_10 c_9_10/BL c_9_10/BLB c_9_9/WL c_9_9/VDD VSUBS c_9_10/Q c_9_10/QB bitcell
Xc_5_7 c_9_7/BL c_9_7/BLB c_5_9/WL c_5_9/VDD VSUBS c_5_7/Q c_5_7/QB bitcell
Xc_0_12 c_9_12/BL c_9_12/BLB c_0_9/WL c_1_9/VDD VSUBS c_0_12/Q c_0_12/QB bitcell
Xc_3_4 c_9_4/BL c_9_4/BLB c_3_9/WL c_3_9/VDD VSUBS c_3_4/Q c_3_4/QB bitcell
Xc_13_2 c_9_2/BL c_9_2/BLB c_13_9/WL c_13_9/VDD VSUBS c_13_2/Q c_13_2/QB bitcell
Xc_6_11 c_9_11/BL c_9_11/BLB c_6_9/WL c_7_9/VDD VSUBS c_6_11/Q c_6_11/QB bitcell
Xc_1_1 c_9_1/BL c_9_1/BLB c_1_9/WL c_1_9/VDD VSUBS c_1_1/Q c_1_1/QB bitcell
Xc_3_12 c_9_12/BL c_9_12/BLB c_3_9/WL c_3_9/VDD VSUBS c_3_12/Q c_3_12/QB bitcell
Xc_9_11 c_9_11/BL c_9_11/BLB c_9_9/WL c_9_9/VDD VSUBS c_9_11/Q c_9_11/QB bitcell
Xc_5_8 c_9_8/BL c_9_8/BLB c_5_9/WL c_5_9/VDD VSUBS c_5_8/Q c_5_8/QB bitcell
Xc_0_13 c_9_13/BL c_9_13/BLB c_0_9/WL c_1_9/VDD VSUBS c_0_13/Q c_0_13/QB bitcell
Xc_15_6 c_9_6/BL c_9_6/BLB c_15_9/WL c_15_9/VDD VSUBS c_15_6/Q c_15_6/QB bitcell
Xc_3_5 c_9_5/BL c_9_5/BLB c_3_9/WL c_3_9/VDD VSUBS c_3_5/Q c_3_5/QB bitcell
Xc_13_3 c_9_3/BL c_9_3/BLB c_13_9/WL c_13_9/VDD VSUBS c_13_3/Q c_13_3/QB bitcell
Xc_11_0 c_9_0/BL c_9_0/BLB c_11_9/WL c_11_9/VDD VSUBS c_11_0/Q c_11_0/QB bitcell
Xc_6_12 c_9_12/BL c_9_12/BLB c_6_9/WL c_7_9/VDD VSUBS c_6_12/Q c_6_12/QB bitcell
Xc_1_2 c_9_2/BL c_9_2/BLB c_1_9/WL c_1_9/VDD VSUBS c_1_2/Q c_1_2/QB bitcell
Xc_3_13 c_9_13/BL c_9_13/BLB c_3_9/WL c_3_9/VDD VSUBS c_3_13/Q c_3_13/QB bitcell
Xc_9_12 c_9_12/BL c_9_12/BLB c_9_9/WL c_9_9/VDD VSUBS c_9_12/Q c_9_12/QB bitcell
Xc_5_9 c_9_9/BL c_9_9/BLB c_5_9/WL c_5_9/VDD VSUBS c_5_9/Q c_5_9/QB bitcell
Xc_0_14 c_9_14/BL c_9_14/BLB c_0_9/WL c_1_9/VDD VSUBS c_0_14/Q c_0_14/QB bitcell
Xc_15_7 c_9_7/BL c_9_7/BLB c_15_9/WL c_15_9/VDD VSUBS c_15_7/Q c_15_7/QB bitcell
Xc_13_4 c_9_4/BL c_9_4/BLB c_13_9/WL c_13_9/VDD VSUBS c_13_4/Q c_13_4/QB bitcell
Xc_6_13 c_9_13/BL c_9_13/BLB c_6_9/WL c_7_9/VDD VSUBS c_6_13/Q c_6_13/QB bitcell
Xc_1_3 c_9_3/BL c_9_3/BLB c_1_9/WL c_1_9/VDD VSUBS c_1_3/Q c_1_3/QB bitcell
Xc_3_6 c_9_6/BL c_9_6/BLB c_3_9/WL c_3_9/VDD VSUBS c_3_6/Q c_3_6/QB bitcell
C0 c_9_8/BL c_8_7/QB 0.00303f
C1 c_7_5/Q c_7_9/WL 0
C2 c_8_9/WL c_8_13/Q 0
C3 c_11_9/VDD c_11_2/QB 0.00969f
C4 c_11_1/QB c_12_1/Q 0
C5 c_5_6/Q c_4_9/WL 0
C6 c_14_12/Q c_15_12/Q 0.00654f
C7 c_9_12/BL c_0_11/QB 0.00303f
C8 c_9_8/BLB c_7_9/QB 0
C9 c_9_3/BL c_9_2/Q 0
C10 c_7_0/QB c_7_9/WL 0
C11 c_8_9/WL c_8_4/QB 0
C12 c_12_13/Q c_12_14/Q 0
C13 c_5_12/QB c_9_11/BLB 0
C14 c_8_15/Q c_9_9/VDD 0.00565f
C15 c_7_10/QB c_9_9/BLB 0
C16 c_5_4/Q c_5_9/VDD 0.00756f
C17 c_10_3/QB c_9_3/QB 0.0025f
C18 c_8_9/WL c_9_15/BLB 0
C19 c_15_10/Q c_15_9/WL 0
C20 c_6_7/Q c_9_8/BL 0
C21 c_1_9/Q c_0_9/WL 0
C22 c_13_8/Q c_12_9/WL 0
C23 c_3_0/Q c_4_0/QB 0
C24 c_5_11/Q c_5_10/Q 0
C25 c_8_12/QB c_8_11/QB 0
C26 c_3_14/Q c_2_9/WL 0
C27 c_5_9/WL c_9_4/BLB 0.00159f
C28 c_6_3/Q c_6_2/QB 0.01135f
C29 c_9_2/BL c_12_1/QB 0.00303f
C30 c_0_8/QB c_0_7/Q 0.00377f
C31 c_5_7/Q c_5_8/Q 0
C32 c_14_9/WL c_15_4/Q 0
C33 c_0_9/WL c_9_10/BL 0.00122f
C34 c_2_7/QB c_3_7/QB 0.01281f
C35 c_4_12/QB c_3_9/WL 0
C36 c_9_4/BLB c_13_5/Q 0.00303f
C37 c_11_13/Q c_10_13/Q 0.00654f
C38 c_3_9/Q c_4_9/Q 0.00634f
C39 c_5_3/Q c_5_2/Q 0
C40 c_14_9/Q c_9_10/BL 0
C41 c_5_14/QB c_6_14/Q 0
C42 c_4_3/Q c_5_3/Q 0.00654f
C43 c_7_7/Q c_7_9/WL 0
C44 c_5_8/QB c_5_7/Q 0.00377f
C45 c_11_9/WL c_9_8/BL 0.00159f
C46 c_3_11/QB c_3_9/WL 0
C47 c_9_10/BL c_4_9/Q 0
C48 c_10_7/Q c_9_8/BL 0
C49 c_9_9/QB c_9_10/QB 0
C50 c_11_9/WL c_11_5/QB 0
C51 c_0_9/QB c_1_9/QB 0.01281f
C52 c_0_9/WL c_9_8/BLB 0.00122f
C53 c_5_9/WL c_9_7/BL 0.00159f
C54 c_2_10/QB c_2_9/WL 0
C55 c_6_3/Q c_7_9/WL 0
C56 c_9_3/BL c_1_9/VDD -0.004f
C57 c_9_4/BL c_2_9/WL 0.00159f
C58 c_13_5/Q c_12_5/QB 0
C59 c_13_5/QB c_12_5/Q 0
C60 c_13_9/WL c_13_0/QB 0
C61 c_9_6/BL c_8_5/QB 0.00303f
C62 c_7_6/QB c_8_6/Q 0
C63 c_14_9/Q c_9_8/BLB 0.00303f
C64 c_9_3/BL c_9_3/BLB -0
C65 c_11_9/WL c_12_12/QB 0
C66 c_9_4/Q c_9_9/WL 0
C67 c_11_9/VDD c_9_12/BLB -0.004f
C68 c_7_9/VDD c_7_11/Q 0.00756f
C69 c_7_9/VDD c_9_3/BLB -0.004f
C70 c_15_14/QB c_15_15/QB 0
C71 c_14_9/Q c_14_10/Q 0
C72 c_3_9/WL c_2_15/Q 0
C73 c_1_9/VDD c_0_4/QB 0.00969f
C74 c_4_9/Q c_9_8/BLB 0.00303f
C75 c_14_9/WL c_13_10/QB 0
C76 c_9_0/BLB c_3_1/Q 0.00303f
C77 c_8_1/Q c_8_9/WL 0
C78 c_9_3/BLB c_0_4/QB 0
C79 c_5_9/WL c_5_3/Q 0
C80 c_13_9/WL c_12_6/Q 0
C81 c_6_9/Q c_7_9/Q 0.00654f
C82 c_10_2/Q c_9_9/WL 0
C83 c_13_14/Q c_14_14/QB 0
C84 c_13_14/QB c_14_14/Q 0
C85 c_13_11/QB c_12_11/Q 0
C86 c_3_11/Q c_9_10/BLB 0.00303f
C87 c_13_7/QB c_13_9/VDD 0.00969f
C88 c_13_6/QB c_14_6/QB 0.0025f
C89 c_7_3/Q c_6_3/Q 0.00654f
C90 c_7_7/QB c_6_7/QB 0.01281f
C91 c_11_3/Q c_9_4/BL 0
C92 c_10_9/WL c_9_9/BLB 0.00159f
C93 c_1_5/QB c_1_4/QB 0
C94 c_5_0/Q c_4_0/QB 0
C95 c_9_6/Q c_9_5/Q 0
C96 c_15_9/VDD c_15_9/WL 0.04545f
C97 c_11_9/WL c_11_11/Q 0
C98 c_9_9/BL c_9_9/BLB -0
C99 c_9_12/BL c_3_11/QB 0.00303f
C100 c_3_9/VDD c_3_11/QB 0.00969f
C101 c_14_4/Q c_14_5/QB 0.00377f
C102 c_7_12/Q c_6_12/QB 0
C103 c_9_4/BLB c_11_9/VDD -0.004f
C104 c_14_2/Q c_14_3/Q 0
C105 c_10_12/Q c_11_12/QB 0
C106 c_2_14/QB c_2_15/QB 0
C107 c_5_3/Q c_9_2/BLB 0.00303f
C108 c_9_1/BLB c_5_2/Q 0.00303f
C109 c_7_12/Q c_7_11/QB 0.01135f
C110 c_13_3/QB c_12_9/WL 0
C111 c_8_9/WL c_9_9/Q 0
C112 c_5_1/Q c_4_1/QB 0
C113 c_9_9/WL c_9_10/BLB 0.00159f
C114 c_7_12/Q c_7_9/VDD 0.00756f
C115 c_1_3/QB c_1_9/VDD 0.00969f
C116 c_1_6/QB c_1_5/QB 0
C117 c_3_9/VDD c_2_15/Q 0.00565f
C118 c_2_9/Q c_2_8/QB 0.01135f
C119 c_4_7/Q c_4_9/WL 0
C120 c_11_9/WL c_11_7/Q 0
C121 c_15_12/QB c_15_9/VDD 0.00969f
C122 c_9_14/BLB c_10_15/Q 0.00303f
C123 c_3_1/QB c_4_1/QB 0.0025f
C124 c_11_7/Q c_10_7/Q 0.00654f
C125 c_6_2/QB c_9_3/BL 0.00303f
C126 c_14_4/Q c_9_3/BLB 0.00303f
C127 c_6_2/QB c_7_9/VDD 0.00969f
C128 c_11_7/QB c_9_6/BLB 0
C129 c_11_9/WL c_11_13/Q 0
C130 c_13_13/QB c_14_13/QB 0.0025f
C131 c_9_4/BL c_14_3/Q 0
C132 c_11_9/VDD c_9_7/BL -0.004f
C133 c_8_14/Q c_9_14/Q 0.00654f
C134 c_9_5/Q c_9_9/WL 0
C135 c_13_3/Q c_9_4/BL 0
C136 c_10_9/WL c_9_7/BLB 0.00159f
C137 c_7_8/Q c_7_9/QB 0.00377f
C138 c_4_11/Q c_5_11/Q 0.00654f
C139 c_15_4/QB c_15_9/WL 0
C140 c_15_1/QB c_15_9/WL 0
C141 c_2_9/Q c_3_9/WL 0
C142 c_6_12/QB c_7_9/WL 0
C143 c_12_8/Q c_13_8/Q 0.00654f
C144 c_12_6/QB c_9_5/BLB 0
C145 c_4_2/QB c_3_2/Q 0
C146 c_0_13/QB c_1_9/VDD 0.00969f
C147 c_9_9/WL c_10_13/Q 0
C148 c_9_9/QB c_9_10/BL 0.00303f
C149 c_5_9/WL c_9_1/BLB 0.00159f
C150 c_4_14/QB c_4_9/WL 0
C151 c_10_9/WL c_9_11/BLB 0.00159f
C152 c_7_13/QB c_7_14/Q 0.01135f
C153 c_15_8/QB c_15_9/WL 0
C154 c_9_12/BLB c_6_13/Q 0.00303f
C155 c_12_4/Q c_11_4/Q 0.00634f
C156 c_9_3/BL c_7_9/WL 0.00159f
C157 c_14_15/Q c_9_14/BLB 0.00303f
C158 c_7_11/QB c_7_9/WL 0
C159 c_9_14/BL c_2_13/Q 0
C160 c_9_4/BL c_8_3/Q 0
C161 c_7_9/VDD c_7_9/WL 0.04545f
C162 c_11_0/Q c_12_9/WL 0
C163 c_9_12/QB c_10_9/WL 0
C164 c_14_2/Q c_15_2/QB 0
C165 c_10_10/QB c_9_9/WL 0
C166 c_5_5/Q c_5_6/QB 0.00377f
C167 c_6_4/Q c_7_4/Q 0.00654f
C168 c_11_5/Q c_11_6/Q 0
C169 c_9_9/QB c_9_8/BLB 0
C170 c_13_9/WL c_12_11/Q 0
C171 c_0_9/WL c_0_14/QB 0
C172 c_3_5/QB c_3_6/QB 0
C173 c_11_9/WL c_11_6/QB 0
C174 c_7_6/Q c_7_9/WL 0
C175 c_15_12/Q c_9_13/BL 0
C176 c_8_8/Q c_8_9/QB 0.00377f
C177 c_10_9/WL c_9_3/QB 0
C178 c_11_15/QB c_10_15/Q 0
C179 c_3_6/QB c_2_9/WL 0
C180 c_6_9/WL c_6_6/QB 0
C181 c_8_14/Q c_8_15/QB 0.00377f
C182 c_9_1/BL c_2_9/WL 0.00159f
C183 c_9_14/QB c_10_14/QB 0.0025f
C184 c_1_2/Q c_0_2/Q 0.00654f
C185 c_13_2/Q c_9_3/BL 0
C186 c_8_12/Q c_9_9/VDD 0.00756f
C187 c_6_6/Q c_7_6/QB 0
C188 c_7_3/Q c_7_9/VDD 0.00756f
C189 c_9_8/QB c_9_9/Q 0.01135f
C190 c_15_6/QB c_14_6/Q 0
C191 c_0_9/WL c_1_8/Q 0
C192 c_2_9/Q c_3_9/VDD 0.00756f
C193 c_5_12/QB c_9_13/BL 0.00303f
C194 c_9_9/WL c_8_7/QB 0
C195 c_7_5/QB c_8_5/Q 0
C196 c_7_5/Q c_8_5/QB 0
C197 c_10_3/QB c_10_2/QB 0
C198 c_3_15/Q c_2_15/QB 0
C199 c_3_15/QB c_2_15/Q 0
C200 c_8_1/QB c_9_1/Q 0
C201 c_8_1/Q c_9_1/QB 0
C202 c_6_9/WL c_9_14/BL 0.00159f
C203 c_9_11/BL c_13_10/Q 0
C204 c_13_5/Q c_12_9/WL 0
C205 c_9_7/Q c_9_9/VDD 0.00756f
C206 c_4_4/Q c_5_9/VDD 0.00756f
C207 c_4_3/QB c_5_9/VDD 0.00969f
C208 c_0_1/Q c_0_9/WL 0
C209 c_13_9/VDD c_9_4/BL -0.004f
C210 c_11_5/QB c_12_5/Q 0
C211 c_10_3/Q c_9_3/Q 0.00634f
C212 c_3_5/QB c_2_9/WL 0
C213 c_13_9/WL c_9_14/BL 0.00159f
C214 c_12_11/Q c_12_10/Q 0
C215 c_10_9/QB c_9_9/QB 0.0025f
C216 c_4_7/QB c_4_8/QB 0
C217 c_13_6/Q c_12_6/Q 0.00654f
C218 c_14_9/WL c_15_8/Q 0
C219 c_8_5/QB c_9_9/VDD 0.00969f
C220 c_15_9/VDD c_14_6/QB 0.00969f
C221 c_9_2/BLB c_12_9/WL 0.00159f
C222 c_2_6/Q c_3_9/WL 0
C223 c_11_9/WL c_9_15/BL 0.00159f
C224 c_1_9/VDD c_1_0/Q 0.00266f
C225 c_9_2/BLB c_1_9/WL 0.00159f
C226 c_11_9/VDD c_9_1/BLB -0.004f
C227 c_12_13/Q c_9_14/BL 0
C228 c_0_7/QB c_1_9/WL 0
C229 c_12_0/QB c_13_0/QB 0.01281f
C230 c_9_4/BL c_6_3/QB 0.00303f
C231 c_15_1/Q c_15_2/Q 0
C232 c_10_6/QB c_10_7/QB 0
C233 c_10_5/QB c_10_9/WL 0
C234 c_14_0/Q c_15_9/VDD 0.00266f
C235 c_8_15/QB c_7_9/WL 0
C236 c_9_2/BL c_4_1/QB 0.00303f
C237 c_7_8/Q c_8_8/QB 0
C238 c_9_13/BLB c_5_9/VDD -0.004f
C239 c_14_9/WL c_9_3/BL 0.00159f
C240 c_5_9/WL c_4_7/QB 0
C241 c_8_14/Q c_7_14/QB 0
C242 c_9_8/Q c_8_8/Q 0.00654f
C243 c_10_7/Q c_9_9/WL 0
C244 c_8_3/QB c_9_3/QB 0.01281f
C245 c_14_2/QB c_15_9/VDD 0.00969f
C246 c_8_13/Q c_9_9/WL 0
C247 c_5_11/QB c_5_12/Q 0.01135f
C248 c_7_1/Q c_7_9/WL 0
C249 c_15_6/Q c_15_9/WL 0
C250 c_14_9/WL c_14_14/QB 0
C251 c_10_9/WL c_10_8/QB 0
C252 c_4_3/QB c_3_9/WL 0
C253 c_4_4/Q c_3_9/WL 0
C254 c_13_14/QB c_14_9/WL 0
C255 c_9_15/BL c_9_15/BLB -0
C256 c_1_7/QB c_9_6/BLB 0
C257 c_9_15/BL c_15_14/Q 0
C258 c_14_9/WL c_15_11/QB 0
C259 c_9_9/WL c_8_4/QB 0
C260 c_15_13/Q c_9_14/BL 0
C261 c_9_9/BL c_10_8/QB 0.00303f
C262 c_9_0/BLB c_2_1/Q 0.00303f
C263 c_11_0/Q c_11_1/Q 0
C264 c_5_14/QB c_9_13/BLB 0
C265 c_9_7/BLB c_13_8/QB 0
C266 c_9_12/Q c_8_12/Q 0.00654f
C267 c_8_6/Q c_9_5/BLB 0.00303f
C268 c_9_4/Q c_10_4/Q 0.00634f
C269 c_13_11/Q c_13_12/Q 0
C270 c_9_9/WL c_9_15/BLB 0
C271 c_5_10/QB c_5_9/VDD 0.00969f
C272 c_11_12/QB c_9_11/BLB 0
C273 c_10_1/QB c_9_2/BL 0.00303f
C274 c_2_6/Q c_3_9/VDD 0.00756f
C275 c_4_4/QB c_9_5/BL 0.00303f
C276 c_7_3/QB c_7_9/WL 0
C277 c_0_15/Q c_9_14/BLB 0.00303f
C278 c_9_14/BLB c_9_9/VDD -0.004f
C279 c_14_11/QB c_14_10/Q 0.00377f
C280 c_1_6/QB c_1_7/QB 0
C281 c_9_13/BLB c_3_9/WL 0.00159f
C282 c_5_12/Q c_9_11/BLB 0.00303f
C283 c_0_9/WL c_0_8/QB 0
C284 c_6_5/Q c_5_9/WL 0
C285 c_7_9/VDD c_6_14/QB 0.00969f
C286 c_5_4/QB c_4_4/Q 0
C287 c_7_4/QB c_6_4/Q 0
C288 c_7_14/QB c_7_9/WL 0
C289 c_0_0/QB c_1_9/VDD 0.00777f
C290 c_1_9/VDD c_0_9/QB 0.00969f
C291 c_2_10/QB c_2_11/QB 0
C292 c_8_6/Q c_9_6/BL 0
C293 c_4_9/WL c_5_1/Q 0
C294 c_15_5/Q c_9_6/BL 0
C295 c_13_10/Q c_13_9/QB 0.01135f
C296 c_9_4/QB c_8_4/Q 0
C297 c_1_15/QB c_2_15/QB 0.0025f
C298 c_14_9/WL c_13_11/Q 0
C299 c_14_4/Q c_14_9/WL 0
C300 c_1_9/Q c_1_9/WL 0
C301 c_3_1/QB c_4_9/WL 0
C302 c_3_1/Q c_4_1/Q 0.00634f
C303 c_13_4/QB c_9_3/BLB 0
C304 c_9_6/BLB c_1_9/VDD -0.004f
C305 c_7_11/Q c_6_11/Q 0.00654f
C306 c_1_4/QB c_1_9/VDD 0.00969f
C307 c_5_6/QB c_9_7/BL 0.00303f
C308 c_4_7/Q c_3_7/Q 0.00634f
C309 c_14_1/QB c_15_9/WL 0
C310 c_6_11/QB c_5_11/Q 0
C311 c_9_10/BL c_12_9/WL 0.00159f
C312 c_1_4/QB c_9_3/BLB 0
C313 c_9_10/BL c_1_9/WL 0.00159f
C314 c_5_9/WL c_9_10/BLB 0.00159f
C315 c_6_9/WL c_5_0/Q 0
C316 c_8_3/Q c_8_4/Q 0
C317 c_4_9/WL c_9_14/BLB 0.00159f
C318 c_7_0/QB c_6_0/Q 0
C319 c_0_9/WL c_9_4/BL 0.00122f
C320 c_5_9/QB c_5_10/QB 0
C321 c_8_1/Q c_8_2/Q 0
C322 c_8_1/Q c_9_9/WL 0
C323 c_13_9/VDD c_9_1/BL -0.004f
C324 c_9_7/BL c_11_6/Q 0
C325 c_6_9/WL c_5_7/QB 0
C326 c_12_9/WL c_12_3/QB 0
C327 c_10_9/WL c_9_13/BL 0.00159f
C328 c_2_6/Q c_3_6/Q 0.00654f
C329 c_3_9/VDD c_9_13/BLB -0.004f
C330 c_1_1/QB c_1_9/VDD 0.00969f
C331 c_9_8/BLB c_12_9/WL 0.00159f
C332 c_9_0/BL c_10_9/WL 0
C333 c_8_9/WL c_7_10/Q 0
C334 c_9_8/BLB c_1_9/WL 0.00159f
C335 c_14_9/Q c_14_8/QB 0.01135f
C336 c_1_6/QB c_1_9/VDD 0.00969f
C337 c_7_2/Q c_9_1/BLB 0.00303f
C338 c_6_12/Q c_6_9/WL 0
C339 c_0_1/Q c_0_2/QB 0.00377f
C340 c_5_9/Q c_4_9/Q 0.00654f
C341 c_12_15/Q c_11_15/Q 0.00634f
C342 c_10_9/WL c_10_2/QB 0
C343 c_0_10/Q c_9_9/BLB 0.00303f
C344 c_11_9/VDD c_10_2/Q 0.00756f
C345 c_11_3/QB c_11_2/QB 0
C346 c_3_13/QB c_4_13/Q 0
C347 c_14_11/Q c_14_10/Q 0
C348 c_1_9/VDD c_1_9/QB 0.00969f
C349 c_13_2/QB c_14_9/WL 0
C350 c_12_9/Q c_9_10/BL 0
C351 c_9_11/BL c_1_9/VDD -0.004f
C352 c_8_0/QB c_8_1/Q 0.01135f
C353 c_1_13/QB c_1_9/VDD 0.00969f
C354 c_13_11/Q c_13_12/QB 0.00377f
C355 c_13_3/Q c_14_3/Q 0.00634f
C356 c_11_9/VDD c_11_1/Q 0.00756f
C357 c_9_9/Q c_9_9/WL 0
C358 c_14_4/Q c_13_4/Q 0.00634f
C359 c_1_5/QB c_1_9/VDD 0.00969f
C360 c_1_5/QB c_2_5/QB 0.0025f
C361 c_10_15/QB c_9_14/BLB 0
C362 c_9_2/BL c_9_9/VDD -0.004f
C363 c_15_6/Q c_14_6/QB 0
C364 c_1_4/QB c_1_3/Q 0.00377f
C365 c_14_8/Q c_14_7/Q 0
C366 c_9_9/BL c_7_8/QB 0.00303f
C367 c_10_9/WL c_9_11/QB 0
C368 c_4_13/QB c_4_12/Q 0.00377f
C369 c_15_5/Q c_15_4/Q 0
C370 c_3_13/Q c_3_12/QB 0.01135f
C371 c_10_6/QB c_9_7/BL 0.00303f
C372 c_9_8/BL c_5_9/VDD -0.004f
C373 c_4_11/QB c_5_9/VDD 0.00969f
C374 c_6_6/Q c_9_5/BLB 0.00303f
C375 c_12_9/Q c_9_8/BLB 0.00303f
C376 c_3_2/QB c_3_1/QB 0
C377 c_6_2/Q c_6_9/WL 0
C378 c_5_7/QB c_5_8/Q 0.01135f
C379 c_11_9/VDD c_9_10/BLB -0.004f
C380 c_14_9/WL c_15_0/QB 0
C381 c_12_12/Q c_11_12/Q 0.00634f
C382 c_12_9/QB c_12_8/QB 0
C383 c_10_10/QB c_9_10/QB 0.0025f
C384 c_3_9/QB c_3_9/WL 0
C385 c_15_13/Q c_15_9/WL 0
C386 c_13_6/QB c_13_5/QB 0
C387 c_13_14/QB c_12_14/QB 0.01281f
C388 c_6_11/Q c_7_9/WL 0
C389 c_10_1/Q c_10_0/QB 0.01135f
C390 c_2_11/Q c_2_12/QB 0.00377f
C391 c_5_8/QB c_5_7/QB 0
C392 c_9_6/BLB c_7_9/WL 0.00159f
C393 c_7_9/VDD c_9_14/BLB -0.004f
C394 c_13_14/Q c_13_15/Q 0
C395 c_8_9/WL c_9_13/QB 0
C396 c_5_9/WL c_6_7/Q 0
C397 c_11_10/QB c_11_11/Q 0.01135f
C398 c_5_15/Q c_5_9/VDD 0.00565f
C399 c_13_9/VDD c_12_9/QB 0.00969f
C400 c_9_2/BL c_4_9/WL 0.00159f
C401 c_9_5/BL c_15_9/WL 0.00122f
C402 c_9_0/BLB c_15_9/WL 0.00122f
C403 c_11_9/VDD c_10_13/Q 0.00756f
C404 c_12_12/QB c_12_13/QB 0
C405 c_12_6/QB c_12_7/Q 0.01135f
C406 c_7_13/QB c_9_14/BL 0.00303f
C407 c_8_9/WL c_9_12/BL 0.00159f
C408 c_15_13/Q c_15_12/QB 0.01135f
C409 c_6_9/Q c_6_8/QB 0.01135f
C410 c_2_0/Q c_2_1/QB 0.00377f
C411 c_3_10/Q c_3_11/QB 0.00377f
C412 c_3_3/QB c_4_3/Q 0
C413 c_3_3/Q c_4_3/QB 0
C414 c_9_8/BL c_14_7/QB 0.00303f
C415 c_10_15/QB c_11_15/QB 0.01281f
C416 c_7_14/QB c_6_14/QB 0.01281f
C417 c_4_11/QB c_3_9/WL 0
C418 c_9_8/BL c_3_9/WL 0.00159f
C419 c_10_9/WL c_9_5/BLB 0.00159f
C420 c_5_14/QB c_5_15/Q 0.01135f
C421 c_9_10/BL c_9_10/BLB -0
C422 c_13_3/Q c_13_9/VDD 0.00756f
C423 c_11_9/VDD c_10_10/QB 0.00969f
C424 c_11_9/WL c_10_4/Q 0
C425 c_4_8/Q c_4_9/Q 0
C426 c_9_4/BL c_9_4/BLB -0
C427 c_3_9/QB c_3_9/VDD 0.00969f
C428 c_13_1/QB c_13_0/QB 0
C429 c_9_4/QB c_9_5/QB 0
C430 c_1_13/QB c_1_14/QB 0
C431 c_0_9/WL c_9_1/BL 0.00122f
C432 c_14_13/Q c_14_14/QB 0.00377f
C433 c_3_14/Q c_2_14/Q 0.00654f
C434 c_14_0/Q c_14_1/QB 0.00377f
C435 c_8_11/QB c_9_11/QB 0.01281f
C436 c_9_13/BL c_11_12/QB 0.00303f
C437 c_1_13/Q c_0_13/QB 0
C438 c_1_13/QB c_0_13/Q 0
C439 c_0_14/QB c_1_9/WL 0
C440 c_4_7/Q c_9_6/BLB 0.00303f
C441 c_9_12/BL c_1_11/QB 0.00303f
C442 c_2_8/Q c_3_8/Q 0.00654f
C443 c_2_9/WL c_2_11/QB 0
C444 c_8_6/Q c_9_9/VDD 0.00756f
C445 c_9_11/BL c_7_9/WL 0.00159f
C446 c_3_2/QB c_2_2/Q 0
C447 c_4_11/Q c_9_10/BLB 0.00303f
C448 c_10_9/WL c_9_6/BL 0.00159f
C449 c_15_13/QB c_14_13/QB 0.01281f
C450 c_14_12/QB c_14_11/QB 0
C451 c_0_0/Q c_1_0/Q 0.00654f
C452 c_14_2/QB c_14_1/QB 0
C453 c_11_6/Q c_12_9/WL 0
C454 c_0_6/QB c_0_7/QB 0
C455 c_4_5/Q c_5_5/QB 0
C456 c_5_12/Q c_9_13/BL 0
C457 c_9_3/BL c_2_2/Q 0
C458 c_5_9/WL c_9_15/BLB 0
C459 c_10_9/WL c_10_15/Q 0
C460 c_11_9/WL c_9_2/BLB 0.00159f
C461 c_1_9/WL c_1_8/Q 0
C462 c_4_5/QB c_4_4/Q 0.00377f
C463 c_6_9/WL c_6_10/QB 0
C464 c_9_12/BL c_4_11/QB 0.00303f
C465 c_4_15/Q c_5_9/VDD 0.00565f
C466 c_13_7/QB c_12_9/WL 0
C467 c_3_9/VDD c_9_8/BL -0.004f
C468 c_7_9/VDD c_6_0/Q 0.00266f
C469 c_13_9/WL c_14_6/QB 0
C470 c_9_7/QB c_8_9/WL 0
C471 c_8_15/QB c_9_14/BLB 0
C472 c_14_9/WL c_13_4/QB 0
C473 c_11_13/QB c_11_12/Q 0.00377f
C474 c_0_9/WL c_0_7/Q 0
C475 c_8_10/Q c_9_10/Q 0.00654f
C476 c_11_13/Q c_12_13/QB 0
C477 c_10_10/QB c_9_10/BL 0
C478 c_3_3/QB c_9_2/BLB 0
C479 c_0_1/Q c_1_9/WL 0
C480 c_9_4/BL c_5_3/Q 0
C481 c_13_9/VDD c_12_8/QB 0.00969f
C482 c_14_9/WL c_9_6/BLB 0.00159f
C483 c_14_0/Q c_13_9/WL 0
C484 c_6_10/Q c_7_10/Q 0.00654f
C485 c_2_5/Q c_2_4/Q 0
C486 c_2_14/QB c_1_14/Q 0
C487 c_11_4/Q c_9_5/BL 0
C488 c_3_0/QB c_2_0/Q 0
C489 c_5_9/WL c_4_13/Q 0
C490 c_6_9/QB c_6_10/QB 0
C491 c_1_1/Q c_1_0/Q 0
C492 c_14_2/QB c_13_9/WL 0
C493 c_7_9/VDD c_9_2/BL -0.004f
C494 c_8_11/Q c_8_10/QB 0.01135f
C495 c_0_5/QB c_9_6/BL 0.00303f
C496 c_11_9/WL c_11_9/VDD 0.04545f
C497 c_14_6/Q c_14_7/QB 0.00377f
C498 c_11_9/WL c_10_8/Q 0
C499 c_2_7/QB c_3_7/Q 0
C500 c_6_9/Q c_5_9/QB 0
C501 c_5_13/QB c_5_12/QB 0
C502 c_9_10/BL c_7_9/Q 0
C503 c_11_9/VDD c_10_7/Q 0.00756f
C504 c_10_7/Q c_10_8/Q 0
C505 c_10_1/QB c_10_9/WL 0
C506 c_10_1/Q c_10_0/Q 0
C507 c_4_15/Q c_3_9/WL 0
C508 c_11_3/Q c_11_2/QB 0.01135f
C509 c_1_10/Q c_9_9/BLB 0.00303f
C510 c_5_12/QB c_4_9/WL 0
C511 c_12_12/Q c_13_9/VDD 0.00756f
C512 c_12_11/QB c_12_12/QB 0
C513 c_9_12/BL c_11_11/Q 0
C514 c_15_9/VDD c_9_13/BLB -0.004f
C515 c_11_9/VDD c_11_2/Q 0.00756f
C516 c_15_2/Q c_15_3/Q 0
C517 c_10_14/Q c_10_13/Q 0
C518 c_1_11/Q c_2_9/WL 0
C519 c_14_2/Q c_9_1/BLB 0.00303f
C520 c_9_14/QB c_9_13/BLB 0
C521 c_9_7/QB c_9_8/BL 0.00303f
C522 c_1_7/QB c_1_9/VDD 0.00969f
C523 c_14_12/QB c_14_11/Q 0.00377f
C524 c_14_9/WL c_9_11/BL 0.00159f
C525 c_9_12/BL c_0_11/Q 0
C526 c_9_8/BLB c_7_9/Q 0.00303f
C527 c_11_9/VDD c_9_15/BLB -0.01128f
C528 c_6_9/WL c_5_4/Q 0
C529 c_9_9/BL c_3_8/QB 0.00303f
C530 c_12_11/QB c_11_11/Q 0
C531 c_9_7/QB c_9_8/QB 0
C532 c_6_9/WL c_6_14/Q 0
C533 c_10_9/QB c_10_10/QB 0
C534 c_10_3/Q c_9_3/QB 0
C535 c_9_6/BL c_5_5/QB 0.00303f
C536 c_9_15/BL c_5_9/VDD -0.004f
C537 c_11_9/WL c_9_10/BL 0.00159f
C538 c_9_12/BLB c_2_9/WL 0.00159f
C539 c_10_9/WL c_9_13/Q 0
C540 c_6_0/QB c_7_9/WL 0
C541 c_8_12/QB c_8_11/Q 0.00377f
C542 c_3_0/QB c_4_9/WL 0
C543 c_2_3/Q c_9_2/BLB 0.00303f
C544 c_8_0/Q c_7_0/QB 0
C545 c_0_8/QB c_1_9/WL 0
C546 c_4_0/Q c_4_1/Q 0
C547 c_15_8/Q c_15_9/QB 0.00377f
C548 c_2_7/Q c_3_7/QB 0
C549 c_14_9/WL c_13_15/Q 0
C550 c_11_9/WL c_12_3/QB 0
C551 c_9_7/Q c_9_6/BLB 0.00303f
C552 c_5_14/QB c_9_15/BL 0.00303f
C553 c_13_8/Q c_14_8/Q 0.00634f
C554 c_14_9/WL c_14_3/QB 0
C555 c_5_14/Q c_6_14/Q 0.00634f
C556 c_3_13/QB c_2_13/QB 0.01281f
C557 c_6_5/QB c_7_9/WL 0
C558 c_1_4/Q c_2_4/QB 0
C559 c_11_9/WL c_9_8/BLB 0.00159f
C560 c_3_6/QB c_9_7/BL 0.00303f
C561 c_3_11/Q c_3_9/WL 0
C562 c_9_9/Q c_9_10/QB 0.00377f
C563 c_9_9/QB c_9_10/Q 0.01135f
C564 c_6_12/QB c_5_12/QB 0.0025f
C565 c_9_4/BLB c_3_5/QB 0
C566 c_9_2/BL c_7_1/Q 0
C567 c_8_0/Q c_9_9/VDD 0.00266f
C568 c_0_9/Q c_1_9/QB 0
C569 c_6_6/QB c_7_6/QB 0.01281f
C570 c_2_10/Q c_2_9/WL 0
C571 c_9_3/BLB c_1_9/VDD -0.004f
C572 c_1_12/Q c_2_9/WL 0
C573 c_9_4/BLB c_2_9/WL 0.00159f
C574 c_10_0/QB c_9_0/Q 0
C575 c_15_10/Q c_14_10/QB 0
C576 c_13_5/Q c_12_5/Q 0.00654f
C577 c_9_6/BL c_8_5/Q 0
C578 c_9_4/BL c_12_9/WL 0.00159f
C579 c_7_6/Q c_8_6/Q 0.00634f
C580 c_5_13/Q c_6_13/QB 0
C581 c_2_10/QB c_1_9/WL 0
C582 c_9_15/BL c_3_9/WL 0.00159f
C583 c_15_7/Q c_15_6/QB 0.01135f
C584 c_9_4/BL c_1_9/WL 0.00159f
C585 c_15_12/Q c_15_11/QB 0.01135f
C586 c_15_14/QB c_15_15/Q 0.01135f
C587 c_7_9/VDD c_7_0/Q 0.00266f
C588 c_14_9/WL c_13_10/Q 0
C589 c_0_12/QB c_9_11/BLB 0
C590 c_9_9/BLB c_15_9/WL 0.00122f
C591 c_11_3/QB c_12_9/WL 0
C592 c_13_14/Q c_14_14/Q 0.00634f
C593 c_9_5/BLB c_9_6/QB 0
C594 c_13_6/QB c_14_6/Q 0
C595 c_13_6/Q c_14_6/QB 0
C596 c_7_7/Q c_6_7/QB 0
C597 c_8_9/WL c_9_14/QB 0
C598 c_9_5/BL c_5_4/Q 0
C599 c_11_9/WL c_10_14/Q 0
C600 c_11_13/QB c_10_13/QB 0.01281f
C601 c_3_4/Q c_4_9/WL 0
C602 c_2_9/WL c_9_7/BL 0.00159f
C603 c_9_9/BL c_9_9/VDD -0.004f
C604 c_11_9/WL c_10_9/QB 0
C605 c_15_14/QB c_15_13/QB 0
C606 c_6_11/QB c_9_10/BLB 0
C607 c_5_0/QB c_4_9/WL 0
C608 c_9_12/BL c_3_11/Q 0
C609 c_3_9/VDD c_3_11/Q 0.00756f
C610 c_2_9/WL c_2_14/Q 0
C611 c_14_9/WL c_13_9/QB 0
C612 c_7_4/Q c_8_4/QB 0
C613 c_12_4/QB c_12_3/QB 0
C614 c_4_15/Q c_3_15/QB 0
C615 c_2_14/QB c_2_15/Q 0.01135f
C616 c_7_12/Q c_7_11/Q 0
C617 c_9_15/BL c_3_9/VDD -0.004f
C618 c_1_3/Q c_1_9/VDD 0.00756f
C619 c_2_7/QB c_9_6/BLB 0
C620 c_9_9/WL c_9_13/QB 0
C621 c_9_7/BLB c_15_9/WL 0.00122f
C622 c_3_1/Q c_4_1/QB 0
C623 c_8_8/Q c_9_7/BLB 0.00303f
C624 c_9_12/BL c_9_9/WL 0.00159f
C625 c_7_12/QB c_6_12/Q 0
C626 c_15_9/VDD c_9_8/BL -0.004f
C627 c_0_9/WL c_0_4/Q 0
C628 c_13_9/VDD c_13_7/Q 0.00756f
C629 c_1_9/VDD c_1_14/QB 0.00969f
C630 c_3_13/QB c_3_9/WL 0
C631 c_7_11/QB c_7_10/QB 0
C632 c_9_9/BL c_4_9/WL 0.00159f
C633 c_5_13/Q c_4_13/QB 0
C634 c_7_8/Q c_7_9/Q 0
C635 c_15_9/VDD c_14_10/QB 0.00969f
C636 c_9_11/BLB c_15_9/WL 0.00122f
C637 c_14_15/QB c_14_14/QB 0
C638 c_7_9/VDD c_7_10/QB 0.00969f
C639 c_7_1/QB c_7_0/QB 0
C640 c_5_15/Q c_4_15/QB 0
C641 c_12_6/Q c_9_5/BLB 0.00303f
C642 c_3_14/Q c_3_13/Q 0
C643 c_9_1/BL c_9_1/BLB -0
C644 c_0_13/Q c_1_9/VDD 0.00756f
C645 c_14_12/Q c_15_9/WL 0
C646 c_6_12/Q c_9_11/BLB 0.00303f
C647 c_9_9/Q c_9_10/BL 0
C648 c_1_15/QB c_1_14/Q 0.00377f
C649 c_10_9/WL c_9_2/QB 0
C650 c_8_11/QB c_9_9/VDD 0.00969f
C651 c_1_6/Q c_9_5/BLB 0.00303f
C652 c_8_9/WL c_8_9/QB 0
C653 c_13_9/VDD c_13_13/Q 0.00756f
C654 c_15_9/VDD c_14_7/Q 0.00756f
C655 c_10_11/QB c_9_10/BLB 0
C656 c_9_7/QB c_9_6/Q 0.00377f
C657 c_8_3/QB c_9_9/VDD 0.00969f
C658 c_11_7/Q c_11_8/QB 0.00377f
C659 c_7_14/Q c_7_13/Q 0
C660 c_7_11/Q c_7_9/WL 0
C661 c_4_12/QB c_3_12/Q 0
C662 c_9_3/BLB c_7_9/WL 0.00159f
C663 c_7_0/Q c_7_1/Q 0
C664 c_14_2/Q c_15_2/Q 0.00654f
C665 c_15_9/VDD c_14_13/QB 0.00969f
C666 c_9_12/Q c_10_9/WL 0
C667 c_9_12/BLB c_5_13/Q 0.00303f
C668 c_3_12/Q c_3_11/QB 0.01135f
C669 c_6_6/Q c_7_9/VDD 0.00756f
C670 c_15_12/QB c_9_11/BLB 0
C671 c_9_7/BLB c_1_8/QB 0
C672 c_0_10/QB c_0_9/QB 0
C673 c_9_9/Q c_9_8/BLB 0.00303f
C674 c_0_9/WL c_0_14/Q 0
C675 c_3_5/Q c_3_6/QB 0.00377f
C676 c_13_9/VDD c_9_12/BLB -0.004f
C677 c_11_9/WL c_11_6/Q 0
C678 c_14_12/Q c_15_12/QB 0
C679 c_8_8/Q c_8_9/Q 0
C680 c_8_2/QB c_9_9/VDD 0.00969f
C681 c_10_0/Q c_9_0/Q 0.00634f
C682 c_8_14/Q c_8_15/Q 0
C683 c_11_8/Q c_10_9/WL 0
C684 c_11_9/Q c_10_9/WL 0
C685 c_9_1/BLB c_2_9/WL 0.00159f
C686 c_6_9/WL c_7_2/QB 0
C687 c_6_4/Q c_6_3/QB 0.01135f
C688 c_6_6/Q c_7_6/Q 0.00654f
C689 c_2_8/Q c_1_8/Q 0.00634f
C690 c_11_14/QB c_12_14/QB 0.0025f
C691 c_9_12/BLB c_10_13/QB 0
C692 c_3_13/QB c_3_9/VDD 0.00969f
C693 c_9_1/BL c_12_9/WL 0.00159f
C694 c_9_1/BL c_1_9/WL 0.00159f
C695 c_11_8/Q c_9_9/BL 0
C696 c_9_7/QB c_9_9/WL 0
C697 c_10_3/Q c_10_2/QB 0.01135f
C698 c_7_5/Q c_8_5/Q 0.00634f
C699 c_3_15/Q c_2_15/Q 0.00654f
C700 c_8_1/Q c_9_1/Q 0.00654f
C701 c_8_14/Q c_7_9/WL 0
C702 c_9_0/BLB c_11_1/QB 0
C703 c_0_8/Q c_0_7/QB 0.01135f
C704 c_15_8/Q c_9_9/BL 0
C705 c_10_10/QB c_10_11/QB 0
C706 c_7_9/VDD c_6_7/QB 0.00969f
C707 c_5_9/WL c_6_8/QB 0
C708 c_5_2/Q c_5_9/VDD 0.00756f
C709 c_15_9/VDD c_15_3/QB 0.00969f
C710 c_0_5/Q c_0_4/Q 0
C711 c_9_14/BLB c_13_15/Q 0.00303f
C712 c_10_12/QB c_9_9/WL 0
C713 c_9_4/BLB c_9_5/QB 0
C714 c_4_3/Q c_5_9/VDD 0.00756f
C715 c_7_12/Q c_7_9/WL 0
C716 c_13_9/VDD c_9_4/BLB -0.004f
C717 c_4_4/QB c_4_5/Q 0.01135f
C718 c_14_9/WL c_14_5/QB 0
C719 c_1_5/Q c_9_6/BL 0
C720 c_10_9/WL c_9_3/BL 0.00159f
C721 c_4_8/QB c_5_9/VDD 0.00969f
C722 c_6_10/QB c_9_9/BLB 0
C723 c_3_5/Q c_2_9/WL 0
C724 c_10_9/QB c_9_9/Q 0
C725 c_10_9/Q c_9_9/QB 0
C726 c_4_7/QB c_4_8/Q 0.01135f
C727 c_6_2/QB c_7_9/WL 0
C728 c_8_5/Q c_9_9/VDD 0.00756f
C729 c_15_9/VDD c_14_6/Q 0.00756f
C730 c_8_9/WL c_9_8/Q 0
C731 c_7_9/VDD c_9_9/BL -0.004f
C732 c_2_9/WL c_1_9/WL 0.8704f
C733 c_4_9/WL c_5_5/QB 0
C734 c_11_9/WL c_10_6/QB 0
C735 c_12_0/QB c_13_0/Q 0
C736 c_7_4/QB c_8_4/QB 0.0025f
C737 c_0_7/Q c_1_9/WL 0
C738 c_10_5/Q c_10_9/WL 0
C739 c_6_9/WL c_9_13/BLB 0.00159f
C740 c_10_6/QB c_10_7/Q 0.01135f
C741 c_8_15/Q c_7_9/WL 0
C742 c_1_11/Q c_2_11/QB 0
C743 c_3_10/Q c_3_9/QB 0.01135f
C744 c_6_2/Q c_5_2/QB 0
C745 c_13_9/VDD c_12_5/QB 0.00969f
C746 c_9_11/BL c_0_10/QB 0.00303f
C747 c_13_9/VDD c_9_7/BL -0.004f
C748 c_5_9/WL c_5_9/VDD 0.04545f
C749 c_12_9/WL c_11_12/Q 0
C750 c_9_14/Q c_10_9/WL 0
C751 c_1_1/QB c_9_2/BL 0.00303f
C752 c_14_9/WL c_9_3/BLB 0.00159f
C753 c_8_2/QB c_9_2/QB 0.01281f
C754 c_15_4/QB c_15_3/QB 0
C755 c_13_9/WL c_9_13/BLB 0.00159f
C756 c_14_9/WL c_14_14/Q 0
C757 c_4_3/Q c_3_9/WL 0
C758 c_13_14/Q c_14_9/WL 0
C759 c_11_3/Q c_12_9/WL 0
C760 c_2_6/QB c_9_5/BLB 0
C761 c_1_7/Q c_9_6/BLB 0.00303f
C762 c_13_9/WL c_13_5/QB 0
C763 c_0_12/QB c_9_13/BL 0.00303f
C764 c_5_12/Q c_5_13/QB 0.00377f
C765 c_11_14/QB c_11_15/QB 0
C766 c_4_8/QB c_3_9/WL 0
C767 c_6_6/QB c_9_5/BLB 0
C768 c_1_11/Q c_0_9/WL 0
C769 c_5_14/QB c_5_9/WL 0
C770 c_5_12/Q c_4_9/WL 0
C771 c_6_9/WL c_5_10/QB 0
C772 c_5_14/Q c_9_13/BLB 0.00303f
C773 c_14_4/QB c_15_9/WL 0
C774 c_9_12/BLB c_6_13/QB 0
C775 c_9_2/BLB c_5_9/VDD -0.004f
C776 c_5_10/Q c_5_9/VDD 0.00756f
C777 c_11_13/QB c_9_12/BLB 0
C778 c_9_6/QB c_9_9/VDD 0.00969f
C779 c_10_1/Q c_9_2/BL 0
C780 c_2_8/QB c_3_8/Q 0
C781 c_7_3/Q c_7_9/WL 0
C782 c_12_9/QB c_12_9/WL 0
C783 c_7_15/QB c_6_15/Q 0
C784 c_0_5/QB c_0_4/QB 0
C785 c_11_9/WL c_10_11/QB 0
C786 c_4_4/Q c_9_5/BL 0
C787 c_0_9/WL c_0_5/Q 0
C788 c_5_3/Q c_6_3/QB 0
C789 c_7_11/QB c_8_11/QB 0.0025f
C790 c_9_2/BL c_5_1/QB 0.00303f
C791 c_8_14/QB c_9_9/VDD 0.00969f
C792 c_9_12/BLB c_8_13/QB 0
C793 c_1_6/QB c_1_7/Q 0.01135f
C794 c_0_9/WL c_9_12/BLB 0.00122f
C795 c_4_9/WL c_5_7/Q 0
C796 c_3_8/Q c_3_9/WL 0
C797 c_3_10/QB c_3_11/QB 0
C798 c_0_0/Q c_1_9/VDD 0.00266f
C799 c_0_0/QB c_0_1/QB 0
C800 c_1_9/VDD c_0_9/Q 0.00756f
C801 c_5_9/WL c_5_9/QB 0
C802 c_2_10/Q c_2_11/QB 0.00377f
C803 c_7_9/VDD c_7_1/QB 0.00969f
C804 c_13_3/Q c_12_9/WL 0
C805 c_11_10/QB c_11_9/VDD 0.00969f
C806 c_9_4/Q c_8_4/Q 0.00654f
C807 c_1_15/QB c_2_15/Q 0
C808 c_4_2/QB c_4_3/QB 0
C809 c_5_9/WL c_4_6/QB 0
C810 c_5_9/WL c_6_1/Q 0
C811 c_9_3/BL c_8_2/QB 0.00303f
C812 c_3_1/Q c_4_9/WL 0
C813 c_13_4/Q c_9_3/BLB 0.00303f
C814 c_11_5/Q c_9_4/BLB 0.00303f
C815 c_9_15/BL c_15_9/VDD -0.004f
C816 c_10_4/QB c_9_5/BL 0.00303f
C817 c_10_9/WL c_11_9/QB 0
C818 c_9_1/BLB c_15_2/QB 0
C819 c_9_2/BLB c_3_9/WL 0.00159f
C820 c_11_9/WL c_9_4/BL 0.00159f
C821 c_1_1/QB c_2_1/QB 0.0025f
C822 c_7_6/QB c_8_6/QB 0.0025f
C823 c_9_15/BL c_9_14/QB 0.00303f
C824 c_2_14/QB c_9_13/BLB 0
C825 c_9_13/BL c_15_9/WL 0.00122f
C826 c_0_9/WL c_9_4/BLB 0.00122f
C827 c_0_9/WL c_1_12/Q 0
C828 c_5_9/QB c_5_10/Q 0.01135f
C829 c_4_12/QB c_9_11/BLB 0
C830 c_3_14/QB c_9_13/BLB 0
C831 c_9_0/BL c_15_9/WL 0
C832 c_5_9/WL c_5_4/QB 0
C833 c_10_11/Q c_11_11/Q 0.00654f
C834 c_6_12/Q c_9_13/BL 0
C835 c_5_5/Q c_9_4/BLB 0.00303f
C836 c_13_9/VDD c_9_1/BLB -0.004f
C837 c_11_9/WL c_11_3/QB 0
C838 c_7_9/VDD c_7_14/Q 0.00756f
C839 c_6_12/QB c_5_12/Q 0
C840 c_9_4/BL c_3_3/QB 0.00303f
C841 c_5_9/WL c_9_12/BL 0.00159f
C842 c_15_14/QB c_15_9/VDD 0.00969f
C843 c_2_9/WL c_3_13/Q 0
C844 c_11_5/Q c_12_5/QB 0
C845 c_9_14/QB c_9_9/WL 0
C846 c_1_1/QB c_0_1/QB 0.01281f
C847 c_1_1/Q c_1_9/VDD 0.00756f
C848 c_9_12/BLB c_4_13/QB 0
C849 c_8_9/WL c_9_3/Q 0
C850 c_3_9/VDD c_3_8/Q 0.00756f
C851 c_11_2/Q c_11_3/QB 0.00377f
C852 c_0_1/Q c_0_2/Q 0
C853 c_0_9/WL c_0_2/QB 0
C854 c_12_8/QB c_12_9/WL 0
C855 c_2_9/WL c_9_10/BLB 0.00159f
C856 c_1_7/QB c_2_7/QB 0.0025f
C857 c_9_12/BLB c_13_13/Q 0.00303f
C858 c_15_12/QB c_9_13/BL 0.00303f
C859 c_0_9/WL c_9_7/BL 0.00122f
C860 c_3_2/Q c_4_9/WL 0
C861 c_13_2/Q c_14_9/WL 0
C862 c_9_10/BL c_5_9/VDD -0.004f
C863 c_1_13/Q c_1_9/VDD 0.00756f
C864 c_3_9/VDD c_9_2/BLB -0.004f
C865 c_3_12/QB c_3_9/WL 0
C866 c_8_8/Q c_7_8/QB 0
C867 c_7_12/Q c_8_12/Q 0.00634f
C868 c_6_4/QB c_5_4/Q 0
C869 c_13_9/VDD c_12_9/WL 0.04545f
C870 c_15_6/Q c_14_6/Q 0.00654f
C871 c_8_8/QB c_8_7/Q 0.00377f
C872 c_1_11/Q c_1_12/Q 0
C873 c_6_9/WL c_9_8/BL 0.00159f
C874 c_10_9/WL c_9_11/Q 0
C875 c_4_13/Q c_4_12/Q 0
C876 c_14_9/WL c_13_12/Q 0
C877 c_12_12/Q c_12_9/WL 0
C878 c_6_14/QB c_7_9/WL 0
C879 c_12_0/QB c_11_0/QB 0.0025f
C880 c_3_2/QB c_3_1/Q 0.00377f
C881 c_9_8/BLB c_5_9/VDD -0.004f
C882 c_4_11/Q c_5_9/VDD 0.00756f
C883 c_13_9/WL c_13_9/Q 0
C884 c_13_14/QB c_12_14/Q 0
C885 c_13_9/WL c_9_8/BL 0.00159f
C886 c_4_0/Q c_4_1/QB 0.00377f
C887 c_15_7/Q c_14_7/QB 0
C888 c_10_10/QB c_9_10/Q 0
C889 c_3_9/Q c_3_9/WL 0
C890 c_12_9/QB c_12_8/Q 0.00377f
C891 c_14_9/WL c_15_0/Q 0
C892 c_12_9/Q c_12_8/QB 0.01135f
C893 c_9_4/BLB c_0_5/Q 0.00303f
C894 c_13_9/WL c_14_10/QB 0
C895 c_13_6/Q c_13_5/QB 0.01135f
C896 c_13_6/QB c_13_5/Q 0.00377f
C897 c_13_14/Q c_12_14/QB 0
C898 c_9_4/BLB c_14_5/Q 0.00303f
C899 c_7_3/QB c_8_3/QB 0.0025f
C900 c_1_9/VDD c_9_14/BLB -0.004f
C901 c_9_9/WL c_8_9/QB 0
C902 c_8_9/WL c_9_5/BL 0.00159f
C903 c_8_9/WL c_9_0/BLB 0.00159f
C904 c_0_6/Q c_0_7/QB 0.00377f
C905 c_9_10/BL c_3_9/WL 0.00159f
C906 c_8_12/Q c_7_9/WL 0
C907 c_1_10/QB c_1_9/QB 0
C908 c_11_9/VDD c_9_12/BL -0.004f
C909 c_4_10/QB c_5_10/QB 0.01281f
C910 c_5_15/Q c_6_9/WL 0
C911 c_1_10/QB c_9_11/BL 0.00303f
C912 c_5_15/QB c_6_15/QB 0.0025f
C913 c_8_9/WL c_8_10/QB 0
C914 c_12_12/QB c_13_9/WL 0
C915 c_13_9/WL c_14_7/Q 0
C916 c_3_9/VDD c_3_12/QB 0.00969f
C917 c_9_4/BL c_2_3/Q 0
C918 c_9_14/BL c_9_13/Q 0
C919 c_5_9/QB c_9_10/BL 0.00303f
C920 c_1_9/WL c_0_4/Q 0
C921 c_9_5/BLB c_15_9/WL 0.00122f
C922 c_13_9/VDD c_12_9/Q 0.00756f
C923 c_13_9/WL c_14_13/QB 0
C924 c_12_6/Q c_12_7/Q 0
C925 c_15_8/Q c_15_9/Q 0
C926 c_12_12/QB c_12_13/Q 0.01135f
C927 c_3_3/Q c_4_3/Q 0.00634f
C928 c_6_9/Q c_6_8/Q 0
C929 c_2_0/Q c_2_1/Q 0
C930 c_3_10/Q c_3_11/Q 0
C931 c_4_11/Q c_3_9/WL 0
C932 c_9_8/BLB c_3_9/WL 0.00159f
C933 c_11_10/Q c_12_9/WL 0
C934 c_9_14/BL c_7_13/Q 0
C935 c_11_9/WL c_9_1/BL 0.00159f
C936 c_5_14/Q c_5_15/Q 0
C937 c_9_11/BL c_7_10/QB 0.00303f
C938 c_5_9/QB c_9_8/BLB 0
C939 c_15_1/Q c_15_9/VDD 0.00756f
C940 c_3_2/Q c_9_3/BL 0
C941 c_2_2/QB c_2_1/QB 0
C942 c_9_14/Q c_8_14/QB 0
C943 c_9_4/QB c_9_5/Q 0.01135f
C944 c_9_4/Q c_9_5/QB 0.00377f
C945 c_8_5/QB c_7_9/WL 0
C946 c_0_8/Q c_1_8/Q 0.00654f
C947 c_1_13/Q c_1_14/QB 0.00377f
C948 c_3_9/Q c_3_9/VDD 0.00756f
C949 c_13_1/QB c_13_0/Q 0.00377f
C950 c_0_9/WL c_9_1/BLB 0.00122f
C951 c_6_7/QB c_9_6/BLB 0
C952 c_14_13/Q c_14_14/Q 0
C953 c_8_11/QB c_9_11/Q 0
C954 c_8_11/Q c_9_11/QB 0
C955 c_9_6/BL c_15_9/WL 0.00122f
C956 c_6_9/WL c_6_9/Q 0
C957 c_1_13/Q c_0_13/Q 0.00654f
C958 c_3_4/QB c_3_5/QB 0
C959 c_0_14/Q c_1_9/WL 0
C960 c_3_9/VDD c_9_10/BL -0.004f
C961 c_3_4/QB c_2_9/WL 0
C962 c_9_1/BLB c_11_2/QB 0
C963 c_10_9/WL c_9_6/BLB 0.00159f
C964 c_15_13/Q c_14_13/QB 0
C965 c_2_11/QB c_1_9/WL 0
C966 c_0_6/QB c_0_7/Q 0.01135f
C967 c_9_4/BLB c_12_5/QB 0
C968 c_8_9/WL c_8_12/QB 0
C969 c_1_9/VDD c_0_10/QB 0.00969f
C970 c_14_15/QB c_13_15/Q 0
C971 c_11_13/QB c_12_9/WL 0
C972 c_9_14/BL c_9_9/VDD -0.004f
C973 c_9_8/Q c_9_9/WL 0
C974 c_11_5/Q c_12_9/WL 0
C975 c_10_11/Q c_9_9/WL 0
C976 c_6_9/WL c_6_10/Q 0
C977 c_9_12/BL c_4_11/Q 0
C978 c_14_9/WL c_13_12/QB 0
C979 c_2_9/WL c_2_8/Q 0
C980 c_3_9/VDD c_9_8/BLB -0.004f
C981 c_7_0/Q c_6_0/QB 0
C982 c_13_9/WL c_14_6/Q 0
C983 c_11_9/VDD c_10_12/QB 0.00969f
C984 c_8_15/Q c_9_14/BLB 0.00303f
C985 c_14_9/WL c_13_4/Q 0
C986 c_7_8/Q c_6_8/QB 0
C987 c_8_15/QB c_8_14/QB 0
C988 c_11_13/Q c_12_13/Q 0.00634f
C989 c_11_9/WL c_11_12/Q 0
C990 c_0_9/WL c_1_9/WL 0.06483f
C991 c_3_3/Q c_9_2/BLB 0.00303f
C992 c_14_15/Q c_15_9/WL 0
C993 c_13_9/VDD c_12_8/Q 0.00756f
C994 c_9_6/BLB c_12_7/QB 0
C995 c_3_3/QB c_2_9/WL 0
C996 c_14_0/QB c_15_0/QB 0.01281f
C997 c_5_6/QB c_5_9/VDD 0.00969f
C998 c_2_5/Q c_9_6/BL 0
C999 c_13_9/VDD c_9_10/BLB -0.004f
C1000 c_4_14/Q c_9_13/BLB 0.00303f
C1001 c_9_14/BLB c_7_9/WL 0.00159f
C1002 c_9_2/BL c_1_9/VDD -0.004f
C1003 c_11_9/WL c_11_3/Q 0
C1004 c_11_2/QB c_12_9/WL 0
C1005 c_2_9/WL c_9_15/BLB 0
C1006 c_5_0/QB c_5_1/QB 0
C1007 c_3_0/Q c_2_0/Q 0.00654f
C1008 c_5_9/WL c_4_15/QB 0
C1009 c_6_9/QB c_6_10/Q 0.01135f
C1010 c_4_12/QB c_9_13/BL 0.00303f
C1011 c_9_14/BL c_5_13/QB 0.00303f
C1012 c_5_9/WL c_4_5/QB 0
C1013 c_4_4/QB c_4_9/WL 0
C1014 c_9_11/BL c_10_9/WL 0.00159f
C1015 c_14_9/QB c_14_8/Q 0.00377f
C1016 c_11_3/Q c_11_2/Q 0
C1017 c_9_14/BL c_4_9/WL 0.00159f
C1018 c_9_5/BLB c_8_6/QB 0
C1019 c_2_7/Q c_3_7/Q 0.00654f
C1020 c_10_1/Q c_10_9/WL 0
C1021 c_11_9/WL c_12_9/QB 0
C1022 c_4_10/QB c_4_11/QB 0
C1023 c_9_0/BLB c_9_1/QB 0
C1024 c_9_2/BLB c_2_3/QB 0
C1025 c_15_4/Q c_15_9/WL 0
C1026 c_12_9/WL c_13_7/Q 0
C1027 c_1_15/Q c_0_15/QB 0
C1028 c_10_14/QB c_10_15/Q 0.01135f
C1029 c_1_7/Q c_1_9/VDD 0.00756f
C1030 c_5_10/QB c_9_9/BLB 0
C1031 c_1_11/Q c_1_9/WL 0
C1032 c_2_8/QB c_1_8/Q 0
C1033 c_5_9/WL c_4_0/QB 0
C1034 c_8_9/WL c_7_13/QB 0
C1035 c_9_5/BLB c_14_6/QB 0
C1036 c_13_13/Q c_12_9/WL 0
C1037 c_11_14/QB c_10_9/WL 0
C1038 c_11_9/VDD c_11_8/QB 0.00969f
C1039 c_11_8/QB c_10_8/Q 0
C1040 c_7_14/QB c_8_14/QB 0.0025f
C1041 c_9_15/BL c_6_9/WL 0.00159f
C1042 c_1_4/Q c_9_5/BL 0
C1043 c_4_6/QB c_5_6/QB 0.01281f
C1044 c_15_9/VDD c_9_2/BLB -0.004f
C1045 c_10_9/Q c_10_10/QB 0.00377f
C1046 c_15_5/Q c_14_5/QB 0
C1047 c_0_5/Q c_1_9/WL 0
C1048 c_7_5/QB c_8_9/WL 0
C1049 c_5_11/QB c_5_10/QB 0
C1050 c_10_9/WL c_11_7/QB 0
C1051 c_9_4/QB c_8_4/QB 0.01281f
C1052 c_6_0/Q c_7_9/WL 0
C1053 c_13_7/QB c_14_7/QB 0.0025f
C1054 c_9_15/BL c_13_9/WL 0.00159f
C1055 c_9_12/BLB c_12_9/WL 0.00159f
C1056 c_3_0/Q c_4_9/WL 0
C1057 c_9_12/BLB c_1_9/WL 0.00159f
C1058 c_6_15/Q c_7_15/Q 0.00654f
C1059 c_1_5/QB c_0_5/QB 0.01281f
C1060 c_2_9/WL c_2_3/Q 0
C1061 c_13_9/VDD c_12_15/QB 0.00479f
C1062 c_14_9/WL c_9_14/BLB 0.00159f
C1063 c_11_1/QB c_12_1/QB 0.0025f
C1064 c_5_14/Q c_9_15/BL 0
C1065 c_9_1/BLB c_0_2/QB 0
C1066 c_3_13/QB c_2_13/Q 0
C1067 c_7_9/VDD c_6_6/QB 0.00969f
C1068 c_2_11/QB c_9_10/BLB 0
C1069 c_8_4/QB c_8_3/Q 0.00377f
C1070 c_1_4/Q c_2_4/Q 0.00634f
C1071 c_10_2/Q c_11_2/QB 0
C1072 c_9_9/WL c_9_3/Q 0
C1073 c_14_9/WL c_14_1/Q 0
C1074 c_5_0/QB c_6_0/QB 0.0025f
C1075 c_6_5/Q c_5_5/Q 0.00634f
C1076 c_9_9/Q c_9_10/Q 0
C1077 c_6_6/Q c_6_5/QB 0.01135f
C1078 c_11_7/QB c_12_7/QB 0.0025f
C1079 c_1_9/VDD c_0_1/QB 0.00969f
C1080 c_9_4/BLB c_3_5/Q 0.00303f
C1081 c_9_2/BL c_7_9/WL 0.00159f
C1082 c_11_9/WL c_12_8/QB 0
C1083 c_6_6/QB c_7_6/Q 0
C1084 c_8_9/WL c_9_9/BLB 0.00159f
C1085 c_11_1/Q c_11_2/QB 0.00377f
C1086 c_15_10/Q c_14_10/Q 0.00654f
C1087 c_11_10/Q c_10_10/QB 0
C1088 c_9_4/BLB c_12_9/WL 0.00159f
C1089 c_7_9/VDD c_9_14/BL -0.004f
C1090 c_2_10/Q c_1_9/WL 0
C1091 c_9_4/BLB c_1_9/WL 0.00159f
C1092 c_1_12/Q c_1_9/WL 0
C1093 c_7_7/QB c_8_9/WL 0
C1094 c_0_12/Q c_9_11/BLB 0.00303f
C1095 c_0_9/WL c_9_10/BLB 0.00122f
C1096 c_14_9/WL c_14_13/Q 0
C1097 c_8_8/Q c_9_9/VDD 0.00756f
C1098 c_13_9/WL c_13_8/Q 0
C1099 c_13_11/Q c_12_11/Q 0.00654f
C1100 c_13_6/Q c_14_6/Q 0.00634f
C1101 c_9_6/BLB c_5_7/Q 0.00303f
C1102 c_11_13/QB c_10_13/Q 0
C1103 c_1_9/WL c_0_2/QB 0
C1104 c_12_5/QB c_12_9/WL 0
C1105 c_11_9/WL c_12_12/Q 0
C1106 c_11_9/WL c_10_13/QB 0
C1107 c_11_9/WL c_10_9/Q 0
C1108 c_15_14/QB c_15_13/Q 0.00377f
C1109 c_9_7/BL c_12_9/WL 0.00159f
C1110 c_5_0/Q c_4_9/WL 0
C1111 c_9_7/BL c_1_9/WL 0.00159f
C1112 c_3_9/QB c_3_10/QB 0
C1113 c_15_7/Q c_15_9/VDD 0.00756f
C1114 c_1_10/QB c_1_9/VDD 0.00969f
C1115 c_9_15/BL c_2_14/QB 0.00303f
C1116 c_2_14/Q c_1_9/WL 0
C1117 c_4_15/Q c_3_15/Q 0.00634f
C1118 c_12_4/Q c_12_3/QB 0.01135f
C1119 c_8_9/WL c_9_7/BLB 0.00159f
C1120 c_13_9/VDD c_9_15/BLB -0.01128f
C1121 c_7_12/QB c_8_9/WL 0
C1122 c_5_7/QB c_4_9/WL 0
C1123 c_3_14/QB c_9_15/BL 0.00303f
C1124 c_4_13/QB c_3_13/Q 0
C1125 c_9_10/BL c_15_9/VDD -0.004f
C1126 c_9_5/BL c_9_9/WL 0.00159f
C1127 c_10_5/QB c_10_4/QB 0
C1128 c_9_4/BL c_5_9/VDD -0.004f
C1129 c_6_11/QB c_9_12/BL 0.00303f
C1130 c_9_0/BLB c_9_9/WL 0.00159f
C1131 c_5_9/Q c_5_9/VDD 0.00756f
C1132 c_4_12/Q c_5_9/VDD 0.00756f
C1133 c_6_5/Q c_6_4/Q 0
C1134 c_15_1/Q c_14_1/QB 0
C1135 c_9_9/BLB c_14_10/QB 0
C1136 c_9_9/WL c_8_10/QB 0
C1137 c_2_7/Q c_9_6/BLB 0.00303f
C1138 c_8_9/WL c_9_11/BLB 0.00159f
C1139 c_1_11/Q c_9_10/BLB 0.00303f
C1140 c_3_14/Q c_3_9/WL 0
C1141 c_7_7/QB c_9_8/BL 0.00303f
C1142 c_15_9/VDD c_9_8/BLB -0.004f
C1143 c_13_7/QB c_13_6/QB 0
C1144 c_9_12/QB c_8_9/WL 0
C1145 c_13_9/VDD c_13_13/QB 0.00969f
C1146 c_15_9/VDD c_14_10/Q 0.00756f
C1147 c_7_11/Q c_7_10/QB 0.01135f
C1148 c_5_13/Q c_4_13/Q 0.00654f
C1149 c_14_15/QB c_14_14/Q 0.00377f
C1150 c_0_4/QB c_0_3/Q 0.00377f
C1151 c_9_12/BLB c_3_13/Q 0.00303f
C1152 c_5_11/QB c_4_11/QB 0.01281f
C1153 c_8_6/Q c_7_9/WL 0
C1154 c_14_9/WL c_9_2/BL 0.00159f
C1155 c_11_9/WL c_11_10/Q 0
C1156 c_13_9/VDD c_12_4/QB 0.00969f
C1157 c_0_13/QB c_9_14/BL 0.00303f
C1158 c_8_9/WL c_9_3/QB 0
C1159 c_10_9/WL c_9_2/Q 0
C1160 c_5_15/QB c_4_15/Q 0
C1161 c_8_11/Q c_9_9/VDD 0.00756f
C1162 c_8_9/WL c_8_9/Q 0
C1163 c_5_11/Q c_9_10/BLB 0.00303f
C1164 c_6_3/Q c_6_2/Q 0
C1165 c_8_0/Q c_9_0/Q 0.00654f
C1166 c_2_10/QB c_3_9/WL 0
C1167 c_9_4/BL c_3_9/WL 0.00159f
C1168 c_15_7/Q c_15_8/QB 0.00377f
C1169 c_10_5/QB c_10_6/Q 0.01135f
C1170 c_4_12/Q c_3_9/WL 0
C1171 c_9_7/BLB c_9_8/BL 2.55595f
C1172 c_14_8/QB c_14_7/QB 0
C1173 c_6_5/Q c_9_4/BLB 0.00303f
C1174 c_3_12/Q c_3_11/Q 0
C1175 c_13_9/WL c_13_3/QB 0
C1176 c_9_12/BL c_10_11/QB 0.00303f
C1177 c_8_6/QB c_9_9/VDD 0.00969f
C1178 c_0_10/Q c_0_9/QB 0.01135f
C1179 c_0_10/QB c_0_9/Q 0.00377f
C1180 c_15_7/QB c_15_6/QB 0
C1181 c_3_4/Q c_9_3/BLB 0.00303f
C1182 c_3_14/Q c_3_9/VDD 0.00756f
C1183 c_11_14/QB c_12_14/Q 0
C1184 c_3_14/QB c_3_13/QB 0
C1185 c_8_12/QB c_9_9/WL 0
C1186 c_9_8/QB c_9_7/BLB 0
C1187 c_10_9/WL c_9_0/Q 0
C1188 c_15_8/Q c_15_9/WL 0
C1189 c_11_9/WL c_11_13/QB 0
C1190 c_11_9/WL c_11_5/Q 0
C1191 c_9_14/QB c_10_14/Q 0
C1192 c_9_12/BLB c_10_13/Q 0.00303f
C1193 c_9_10/BL c_8_9/QB 0.00303f
C1194 c_6_6/Q c_5_6/Q 0.00634f
C1195 c_9_1/BLB c_12_9/WL 0.00159f
C1196 c_1_3/QB c_0_3/Q 0
C1197 c_0_9/WL c_0_6/QB 0
C1198 c_13_9/VDD c_13_1/Q 0.00756f
C1199 c_9_1/BLB c_1_9/WL 0.00159f
C1200 c_11_9/WL c_10_7/QB 0
C1201 c_8_8/QB c_8_7/QB 0
C1202 c_6_9/WL c_5_2/Q 0
C1203 c_4_15/Q c_4_14/Q 0
C1204 c_12_12/QB c_9_11/BLB 0
C1205 c_13_8/QB c_13_9/QB 0
C1206 c_0_8/Q c_0_7/Q 0
C1207 c_6_5/QB c_5_5/QB 0.0025f
C1208 c_7_6/QB c_8_9/WL 0
C1209 c_9_3/BL c_15_9/WL 0.00122f
C1210 c_10_10/Q c_9_9/WL 0
C1211 c_15_9/VDD c_15_3/Q 0.00756f
C1212 c_5_9/WL c_6_8/Q 0
C1213 c_2_10/QB c_3_9/VDD 0.00969f
C1214 c_9_4/BL c_3_9/VDD -0.004f
C1215 c_10_12/Q c_9_9/WL 0
C1216 c_9_4/BLB c_9_5/Q 0.00303f
C1217 c_14_14/QB c_15_9/WL 0
C1218 c_9_8/BLB c_8_9/QB 0
C1219 c_9_8/Q c_10_8/Q 0.00634f
C1220 c_10_11/Q c_11_9/VDD 0.00756f
C1221 c_11_9/WL c_11_2/QB 0
C1222 c_6_12/Q c_7_9/VDD 0.00756f
C1223 c_10_9/WL c_9_3/BLB 0.00159f
C1224 c_4_4/Q c_4_5/Q 0
C1225 c_14_12/Q c_14_13/QB 0.00377f
C1226 c_1_5/Q c_1_4/QB 0.01135f
C1227 c_4_8/Q c_5_9/VDD 0.00756f
C1228 c_6_10/Q c_9_9/BLB 0.00303f
C1229 c_15_11/QB c_15_9/WL 0
C1230 c_9_13/BLB c_9_13/BL -0
C1231 c_9_9/BL c_1_9/VDD -0.004f
C1232 c_10_9/Q c_9_9/Q 0.00634f
C1233 c_0_13/QB c_0_12/QB 0
C1234 c_2_9/WL c_2_13/QB 0
C1235 c_0_9/WL c_9_15/BLB 0
C1236 c_15_5/Q c_14_9/WL 0
C1237 c_9_3/BL c_1_2/QB 0.00303f
C1238 c_15_1/Q c_9_0/BLB 0.00303f
C1239 c_7_10/QB c_7_9/WL 0
C1240 c_15_12/Q c_14_9/WL 0
C1241 c_5_9/WL c_6_9/WL 0.8704f
C1242 c_1_0/QB c_9_1/BL 0.00303f
C1243 c_14_9/WL c_15_9/QB 0
C1244 c_3_10/Q c_3_9/Q 0
C1245 c_13_9/VDD c_12_5/Q 0.00756f
C1246 c_9_1/BL c_5_9/VDD -0.004f
C1247 c_9_11/BL c_0_10/Q 0
C1248 c_10_9/WL c_10_0/QB 0
C1249 c_1_1/Q c_9_2/BL 0
C1250 c_10_12/QB c_10_11/QB 0
C1251 c_1_6/QB c_1_5/Q 0.00377f
C1252 c_1_6/Q c_1_5/QB 0.01135f
C1253 c_15_12/QB c_15_11/QB 0
C1254 c_8_2/QB c_9_2/Q 0
C1255 c_2_9/QB c_1_9/QB 0.0025f
C1256 c_15_4/QB c_15_3/Q 0.00377f
C1257 c_10_15/QB c_10_14/QB 0
C1258 c_3_14/Q c_3_15/QB 0.00377f
C1259 c_2_6/Q c_9_5/BLB 0.00303f
C1260 c_6_2/Q c_9_3/BL 0
C1261 c_15_6/Q c_15_7/Q 0
C1262 c_13_9/WL c_13_5/Q 0
C1263 c_0_12/Q c_9_13/BL 0
C1264 c_6_2/Q c_7_9/VDD 0.00756f
C1265 c_3_13/QB c_3_12/Q 0.00377f
C1266 c_0_5/Q c_0_6/QB 0.00377f
C1267 c_4_8/Q c_3_9/WL 0
C1268 c_6_6/Q c_7_9/WL 0
C1269 c_0_5/QB c_1_9/VDD 0.00969f
C1270 c_5_14/Q c_5_9/WL 0
C1271 c_5_9/WL c_6_9/QB 0
C1272 c_6_9/WL c_9_2/BLB 0.00159f
C1273 c_6_9/WL c_5_10/Q 0
C1274 c_9_14/BLB c_11_15/QB 0
C1275 c_14_4/Q c_15_9/WL 0
C1276 c_4_8/QB c_5_8/Q 0
C1277 c_11_5/QB c_10_5/QB 0.01281f
C1278 c_1_0/QB c_2_9/WL 0
C1279 c_4_2/Q c_3_2/Q 0.00634f
C1280 c_3_6/QB c_3_9/WL 0
C1281 c_12_9/Q c_12_9/WL 0
C1282 c_10_2/Q c_9_1/BLB 0.00303f
C1283 c_13_9/WL c_9_2/BLB 0.00159f
C1284 c_9_8/BL c_10_8/QB 0
C1285 c_9_1/BL c_3_9/WL 0.00159f
C1286 c_8_0/Q c_7_9/WL 0
C1287 c_11_9/WL c_9_12/BLB 0.00159f
C1288 c_5_8/QB c_4_8/QB 0.01281f
C1289 c_9_2/BLB c_9_3/Q 0.00303f
C1290 c_9_15/BL c_4_14/Q 0
C1291 c_7_11/Q c_8_11/QB 0
C1292 c_7_11/QB c_8_11/Q 0
C1293 c_11_4/QB c_9_3/BLB 0
C1294 c_9_2/BL c_5_1/Q 0
C1295 c_9_12/BLB c_8_13/Q 0.00303f
C1296 c_1_3/QB c_1_2/QB 0
C1297 c_10_1/QB c_11_1/QB 0.01281f
C1298 c_5_9/WL c_5_8/Q 0
C1299 c_6_7/QB c_7_9/WL 0
C1300 c_14_9/QB c_15_9/VDD 0.00969f
C1301 c_14_11/QB c_9_10/BLB 0
C1302 c_9_2/BL c_3_1/QB 0.00303f
C1303 c_3_10/QB c_3_11/Q 0.01135f
C1304 c_9_8/QB c_10_8/QB 0.0025f
C1305 c_4_6/QB c_3_6/QB 0.0025f
C1306 c_13_9/VDD c_12_1/Q 0.00756f
C1307 c_0_0/Q c_0_1/QB 0.00377f
C1308 c_2_9/WL c_2_8/QB 0
C1309 c_4_2/QB c_5_2/Q 0
C1310 c_4_12/QB c_4_9/WL 0
C1311 c_4_2/QB c_4_3/Q 0.01135f
C1312 c_11_15/Q c_10_15/Q 0.00654f
C1313 c_3_2/Q c_2_2/QB 0
C1314 c_5_9/WL c_4_6/Q 0
C1315 c_5_9/WL c_5_8/QB 0
C1316 c_12_2/QB c_12_3/QB 0
C1317 c_8_9/WL c_9_13/BL 0.00159f
C1318 c_9_9/WL c_9_9/BLB 0.00159f
C1319 c_9_14/Q c_10_14/QB 0
C1320 c_9_0/BL c_8_9/WL 0
C1321 c_10_4/Q c_9_5/BL 0
C1322 c_3_5/QB c_3_9/WL 0
C1323 c_5_9/WL c_9_5/BL 0.00159f
C1324 c_9_1/BLB c_15_2/Q 0.00303f
C1325 c_4_9/WL c_3_11/QB 0
C1326 c_9_9/BL c_7_9/WL 0.00159f
C1327 c_5_9/WL c_9_0/BLB 0.00159f
C1328 c_9_2/BL c_14_1/Q 0
C1329 c_11_9/WL c_9_4/BLB 0.00159f
C1330 c_1_1/Q c_2_1/QB 0
C1331 c_1_1/QB c_2_1/Q 0
C1332 c_1_6/QB c_2_6/QB 0.0025f
C1333 c_2_9/WL c_3_9/WL 0.06483f
C1334 c_7_6/Q c_8_6/QB 0
C1335 c_1_12/QB c_9_11/BLB 0
C1336 c_14_12/QB c_15_9/VDD 0.00969f
C1337 c_3_6/QB c_3_9/VDD 0.00969f
C1338 c_4_9/WL c_5_4/Q 0
C1339 c_11_1/Q c_12_9/WL 0
C1340 c_9_1/BL c_3_9/VDD -0.004f
C1341 c_5_6/Q c_5_5/QB 0.01135f
C1342 c_0_6/QB c_9_7/BL 0.00303f
C1343 c_9_4/BL c_3_3/Q 0
C1344 c_9_12/BLB c_13_13/QB 0
C1345 c_11_5/Q c_12_5/Q 0.00634f
C1346 c_8_6/Q c_8_5/QB 0.01135f
C1347 c_5_9/WL c_4_2/QB 0
C1348 c_1_1/Q c_0_1/QB 0
C1349 c_11_9/WL c_12_5/QB 0
C1350 c_9_12/BLB c_4_13/Q 0.00303f
C1351 c_8_9/WL c_7_8/QB 0
C1352 c_11_9/WL c_9_7/BL 0.00159f
C1353 c_7_9/VDD c_6_10/QB 0.00969f
C1354 c_0_9/WL c_0_2/Q 0
C1355 c_12_8/Q c_12_9/WL 0
C1356 c_8_10/QB c_9_10/QB 0.01281f
C1357 c_1_7/Q c_2_7/QB 0
C1358 c_1_7/QB c_2_7/Q 0
C1359 c_9_1/BL c_2_0/QB 0.00303f
C1360 c_13_5/QB c_9_6/BL 0.00303f
C1361 c_8_9/WL c_9_11/QB 0
C1362 c_6_9/WL c_9_10/BL 0.00159f
C1363 c_14_2/QB c_9_3/BL 0.00303f
C1364 c_12_9/WL c_9_10/BLB 0.00159f
C1365 c_15_0/QB c_15_9/WL 0
C1366 c_12_0/Q c_13_0/QB 0
C1367 c_1_9/WL c_9_10/BLB 0.00159f
C1368 c_9_5/BLB c_10_6/Q 0.00303f
C1369 c_9_7/BLB c_9_9/WL 0.00159f
C1370 c_3_5/QB c_3_9/VDD 0.00969f
C1371 c_9_12/BL c_2_9/WL 0.00159f
C1372 c_3_9/VDD c_2_9/WL 0.04545f
C1373 c_1_13/QB c_9_14/BL 0.00303f
C1374 c_3_1/QB c_2_1/QB 0.01281f
C1375 c_14_11/Q c_9_10/BLB 0.00303f
C1376 c_8_14/Q c_7_14/Q 0.00634f
C1377 c_13_9/WL c_9_10/BL 0.00159f
C1378 c_9_4/BL c_2_3/QB 0.00303f
C1379 c_12_9/QB c_12_10/QB 0
C1380 c_9_9/WL c_9_11/BLB 0.00159f
C1381 c_2_9/WL c_2_4/QB 0
C1382 c_14_2/Q c_15_9/VDD 0.00756f
C1383 c_8_11/QB c_7_9/WL 0
C1384 c_8_3/QB c_7_9/WL 0
C1385 c_6_9/WL c_9_8/BLB 0.00159f
C1386 c_4_10/QB c_5_9/WL 0
C1387 c_12_12/QB c_9_13/BL 0.00303f
C1388 c_14_9/WL c_15_11/Q 0
C1389 c_9_10/BL c_6_9/QB 0.00303f
C1390 c_12_0/QB c_11_0/Q 0
C1391 c_9_12/QB c_9_9/WL 0
C1392 c_7_1/QB c_7_9/WL 0
C1393 c_13_9/WL c_12_3/QB 0
C1394 c_4_9/QB c_3_9/QB 0.0025f
C1395 c_11_9/VDD c_9_5/BL -0.004f
C1396 c_2_0/QB c_2_9/WL 0
C1397 c_13_14/Q c_12_14/Q 0.00654f
C1398 c_9_7/BLB c_13_8/Q 0.00303f
C1399 c_11_9/VDD c_9_0/BLB -0.004f
C1400 c_6_9/WL c_6_13/Q 0
C1401 c_13_9/WL c_9_8/BLB 0.00159f
C1402 c_12_9/Q c_12_8/Q 0
C1403 c_5_6/Q c_5_7/Q 0
C1404 c_15_6/QB c_9_7/BL 0.00303f
C1405 c_13_9/WL c_14_10/Q 0
C1406 c_13_6/Q c_13_5/Q 0
C1407 c_9_9/WL c_9_3/QB 0
C1408 c_15_5/QB c_14_5/Q 0
C1409 c_14_9/WL c_9_9/BL 0.00159f
C1410 c_8_2/QB c_7_9/WL 0
C1411 c_9_4/BL c_15_9/VDD -0.004f
C1412 c_9_9/WL c_8_9/Q 0
C1413 c_7_3/Q c_8_3/QB 0
C1414 c_8_9/WL c_9_5/BLB 0.00159f
C1415 c_12_4/QB c_12_5/QB 0
C1416 c_6_9/QB c_9_8/BLB 0
C1417 c_0_6/Q c_0_7/Q 0
C1418 c_1_10/Q c_1_9/QB 0.01135f
C1419 c_9_8/BL c_3_7/QB 0.00303f
C1420 c_4_10/QB c_5_10/Q 0
C1421 c_15_9/VDD c_14_8/QB 0.00969f
C1422 c_1_6/Q c_1_7/QB 0.00377f
C1423 c_1_10/Q c_9_11/BL 0
C1424 c_5_13/Q c_5_9/VDD 0.00756f
C1425 c_7_9/VDD c_6_14/Q 0.00756f
C1426 c_6_9/WL c_7_4/Q 0
C1427 c_7_14/Q c_7_9/WL 0
C1428 c_3_5/QB c_3_6/Q 0.01135f
C1429 c_6_9/WL c_7_2/Q 0
C1430 c_2_9/WL c_3_6/Q 0
C1431 c_10_10/Q c_9_10/QB 0
C1432 c_8_9/WL c_9_6/BL 0.00159f
C1433 c_5_14/QB c_5_13/Q 0.00377f
C1434 c_11_9/WL c_9_1/BLB 0.00159f
C1435 c_13_9/VDD c_12_13/QB 0.00969f
C1436 c_4_10/Q c_5_10/QB 0
C1437 c_9_4/BLB c_15_5/QB 0
C1438 c_3_15/QB c_2_9/WL 0
C1439 c_3_0/QB c_3_1/QB 0
C1440 c_2_2/Q c_2_1/QB 0.01135f
C1441 c_2_2/QB c_2_1/Q 0.00377f
C1442 c_5_7/QB c_9_6/BLB 0
C1443 c_8_5/Q c_7_9/WL 0
C1444 c_9_4/Q c_9_5/Q 0
C1445 c_12_12/Q c_12_13/QB 0.00377f
C1446 c_9_1/BLB c_11_2/Q 0.00303f
C1447 c_8_11/Q c_9_11/Q 0.00654f
C1448 c_2_11/Q c_3_11/QB 0
C1449 c_9_6/BLB c_15_9/WL 0.00122f
C1450 c_10_5/QB c_9_9/WL 0
C1451 c_6_12/Q c_6_11/Q 0
C1452 c_10_12/QB c_11_12/Q 0
C1453 c_3_4/QB c_3_5/Q 0.01135f
C1454 c_0_9/WL c_0_8/Q 0
C1455 c_14_8/QB c_15_8/QB 0.01281f
C1456 c_9_4/BLB c_12_5/Q 0.00303f
C1457 c_1_6/Q c_1_9/VDD 0.00756f
C1458 c_13_9/VDD c_12_10/QB 0.00969f
C1459 c_6_6/QB c_6_5/QB 0
C1460 c_9_9/WL c_10_8/QB 0
C1461 c_0_6/QB c_1_9/WL 0
C1462 c_1_9/VDD c_0_10/Q 0.00756f
C1463 c_14_2/QB c_13_2/QB 0.0025f
C1464 c_14_15/QB c_9_14/BLB 0
C1465 c_9_2/BL c_2_1/QB 0.00303f
C1466 c_11_9/WL c_12_9/WL 0.8704f
C1467 c_11_9/VDD c_10_10/Q 0.00756f
C1468 c_9_7/Q c_10_9/WL 0
C1469 c_7_0/Q c_6_0/Q 0.00654f
C1470 c_11_9/VDD c_10_12/Q 0.00756f
C1471 c_7_8/Q c_6_8/Q 0.00654f
C1472 c_6_9/WL c_5_6/QB 0
C1473 c_2_8/Q c_1_9/WL 0
C1474 c_8_15/Q c_8_14/QB 0.01135f
C1475 c_7_10/Q c_7_9/QB 0.01135f
C1476 c_3_3/Q c_2_9/WL 0
C1477 c_14_0/QB c_15_0/Q 0
C1478 c_14_0/Q c_15_0/QB 0
C1479 c_11_2/Q c_12_9/WL 0
C1480 c_1_5/Q c_1_9/VDD 0.00756f
C1481 c_1_5/Q c_2_5/QB 0
C1482 c_5_9/WL c_4_14/Q 0
C1483 c_9_2/BL c_0_1/QB 0.00303f
C1484 c_15_7/QB c_14_7/QB 0.01281f
C1485 c_11_5/QB c_9_6/BL 0.00303f
C1486 c_7_4/Q c_9_5/BL 0
C1487 c_1_12/QB c_9_13/BL 0.00303f
C1488 c_5_0/QB c_5_1/Q 0.01135f
C1489 c_5_0/Q c_5_1/QB 0.00377f
C1490 c_9_11/BL c_15_9/WL 0.00122f
C1491 c_9_13/BLB c_9_9/VDD -0.004f
C1492 c_1_1/QB c_1_2/QB 0
C1493 c_12_9/WL c_9_15/BLB 0
C1494 c_8_14/QB c_7_9/WL 0
C1495 c_1_9/WL c_9_15/BLB 0
C1496 c_5_9/WL c_9_9/BLB 0.00159f
C1497 c_7_8/Q c_6_9/WL 0
C1498 c_13_9/VDD c_9_12/BL -0.004f
C1499 c_9_13/QB c_10_13/QB 0.0025f
C1500 c_4_3/QB c_4_9/WL 0
C1501 c_4_4/Q c_4_9/WL 0
C1502 c_4_7/Q c_5_7/Q 0.00654f
C1503 c_14_9/WL c_13_8/QB 0
C1504 c_14_9/Q c_14_8/Q 0
C1505 c_14_0/QB c_14_9/WL 0
C1506 c_1_10/QB c_0_10/QB 0.01281f
C1507 c_13_9/VDD c_13_15/QB 0.00479f
C1508 c_9_1/BL c_15_9/VDD -0.004f
C1509 c_4_10/QB c_4_11/Q 0.01135f
C1510 c_11_9/WL c_12_9/Q 0
C1511 c_9_0/BLB c_9_1/Q 0.00303f
C1512 c_11_10/Q c_12_10/QB 0
C1513 c_3_9/QB c_3_8/QB 0
C1514 c_8_11/QB c_8_12/Q 0.01135f
C1515 c_2_9/WL c_2_3/QB 0
C1516 c_9_7/BLB c_4_8/QB 0
C1517 c_13_7/QB c_13_9/WL 0
C1518 c_13_13/QB c_12_9/WL 0
C1519 c_1_0/QB c_0_9/WL 0
C1520 c_1_15/Q c_0_15/Q 0.00654f
C1521 c_3_10/Q c_2_10/QB 0
C1522 c_5_9/WL c_5_11/QB 0
C1523 c_9_9/BLB c_9_10/QB 0
C1524 c_9_1/BL c_4_0/QB 0.00303f
C1525 c_3_5/QB c_4_5/QB 0.0025f
C1526 c_5_10/Q c_9_9/BLB 0.00303f
C1527 c_11_13/QB c_12_13/QB 0.0025f
C1528 c_8_9/WL c_9_13/Q 0
C1529 c_5_5/Q c_5_9/VDD 0.00756f
C1530 c_12_11/QB c_13_9/VDD 0.00969f
C1531 c_14_3/QB c_15_9/WL 0
C1532 c_12_4/QB c_12_9/WL 0
C1533 c_1_9/QB c_1_8/QB 0
C1534 c_6_9/WL c_7_4/QB 0
C1535 c_9_5/BLB c_14_6/Q 0.00303f
C1536 c_5_9/WL c_4_1/Q 0
C1537 c_4_9/WL c_9_13/BLB 0.00159f
C1538 c_14_9/QB c_13_9/WL 0
C1539 c_12_11/QB c_12_12/Q 0.01135f
C1540 c_6_9/WL c_6_11/QB 0
C1541 c_8_10/Q c_7_10/Q 0.00634f
C1542 c_4_9/Q c_5_9/VDD 0.00756f
C1543 c_10_15/QB c_11_15/Q 0
C1544 c_10_9/WL c_9_14/BLB 0.00159f
C1545 c_7_14/QB c_6_14/Q 0
C1546 c_7_14/Q c_6_14/QB 0
C1547 c_8_9/WL c_7_13/Q 0
C1548 c_2_11/QB c_3_9/WL 0
C1549 c_4_10/Q c_4_11/QB 0.00377f
C1550 c_9_9/WL c_9_13/BL 0.00159f
C1551 c_5_9/WL c_9_7/BLB 0.00159f
C1552 c_4_6/Q c_5_6/QB 0
C1553 c_1_5/QB c_2_5/Q 0
C1554 c_9_0/BL c_9_9/WL 0
C1555 c_7_5/Q c_8_9/WL 0
C1556 c_11_9/WL c_10_2/Q 0
C1557 c_5_11/QB c_5_10/Q 0.00377f
C1558 c_13_6/QB c_13_9/VDD 0.00969f
C1559 c_9_4/Q c_8_4/QB 0
C1560 c_2_6/QB c_2_5/QB 0
C1561 c_9_7/BLB c_3_8/Q 0.00303f
C1562 c_9_12/BLB c_2_13/QB 0
C1563 c_10_2/QB c_9_9/WL 0
C1564 c_1_13/QB c_1_14/Q 0.01135f
C1565 c_8_9/WL c_7_0/QB 0
C1566 c_5_9/WL c_9_11/BLB 0.00159f
C1567 c_11_9/WL c_11_1/Q 0
C1568 c_13_9/VDD c_12_15/Q 0.00565f
C1569 c_10_2/Q c_11_2/Q 0.00654f
C1570 c_4_9/WL c_5_10/QB 0
C1571 c_15_15/QB c_15_14/Q 0.00377f
C1572 c_14_12/QB c_13_9/WL 0
C1573 c_2_3/Q c_1_9/WL 0
C1574 c_11_9/VDD c_9_9/BLB -0.004f
C1575 c_9_1/BLB c_0_2/Q 0.00303f
C1576 c_11_6/QB c_9_5/BLB 0
C1577 c_13_1/Q c_12_9/WL 0
C1578 c_6_11/Q c_6_10/QB 0.01135f
C1579 c_4_13/QB c_5_9/VDD 0.00969f
C1580 c_9_3/BL c_7_2/QB 0.00303f
C1581 c_7_9/VDD c_7_2/QB 0.00969f
C1582 c_6_4/QB c_5_9/WL 0
C1583 c_11_1/Q c_11_2/Q 0
C1584 c_14_2/Q c_14_1/QB 0.01135f
C1585 c_5_0/QB c_6_0/Q 0
C1586 c_5_0/Q c_6_0/QB 0
C1587 c_8_9/WL c_9_9/VDD 0.04545f
C1588 c_10_9/QB c_10_10/Q 0.01135f
C1589 c_7_9/VDD c_6_15/QB 0.00479f
C1590 c_4_9/Q c_3_9/WL 0
C1591 c_9_14/BL c_1_9/VDD -0.004f
C1592 c_4_4/QB c_9_3/BLB 0
C1593 c_11_9/WL c_12_8/Q 0
C1594 c_10_12/QB c_10_13/QB 0
C1595 c_6_6/QB c_5_6/Q 0
C1596 c_11_9/WL c_9_10/BLB 0.00159f
C1597 c_9_9/WL c_9_11/QB 0
C1598 c_9_12/BL c_2_11/QB 0.00303f
C1599 c_3_9/VDD c_2_11/QB 0.00969f
C1600 c_5_9/QB c_4_9/Q 0
C1601 c_10_9/WL c_11_15/QB 0
C1602 c_13_10/QB c_13_9/Q 0.00377f
C1603 c_0_1/Q c_9_0/BLB 0.00303f
C1604 c_7_7/Q c_8_9/WL 0
C1605 c_8_13/QB c_9_13/QB 0.01281f
C1606 c_9_6/Q c_9_5/BLB 0.00303f
C1607 c_10_1/QB c_9_1/QB 0.0025f
C1608 c_5_9/WL c_5_2/QB 0
C1609 c_12_13/QB c_13_13/Q 0
C1610 c_13_10/QB c_14_10/QB 0.0025f
C1611 c_7_13/QB c_6_13/Q 0
C1612 c_9_12/BLB c_5_9/VDD -0.004f
C1613 c_11_14/QB c_10_14/QB 0.01281f
C1614 c_5_11/Q c_5_9/VDD 0.00756f
C1615 c_14_9/WL c_15_9/Q 0
C1616 c_13_7/Q c_14_7/QB 0
C1617 c_7_4/QB c_9_5/BL 0.00303f
C1618 c_14_9/WL c_13_0/QB 0
C1619 c_9_2/BLB c_9_3/QB 0
C1620 c_1_9/WL c_0_2/Q 0
C1621 c_0_9/WL c_9_12/BL 0.00122f
C1622 c_5_5/Q c_5_4/QB 0.01135f
C1623 c_2_2/QB c_1_2/QB 0.0025f
C1624 c_4_13/QB c_3_9/WL 0
C1625 c_9_10/BL c_9_9/BLB 2.55595f
C1626 c_12_5/Q c_12_9/WL 0
C1627 c_14_3/Q c_15_9/VDD 0.00756f
C1628 c_14_2/Q c_13_9/WL 0
C1629 c_11_8/QB c_12_8/QB 0.0025f
C1630 c_11_9/WL c_10_13/Q 0
C1631 c_11_9/VDD c_9_7/BLB -0.004f
C1632 c_9_7/BLB c_10_8/Q 0.00303f
C1633 c_9_12/BLB c_12_13/QB 0
C1634 c_7_9/VDD c_9_13/BLB -0.004f
C1635 c_3_9/Q c_3_10/QB 0.00377f
C1636 c_15_4/Q c_15_3/QB 0.01135f
C1637 c_12_6/QB c_12_7/QB 0
C1638 c_9_13/BLB c_14_14/QB 0
C1639 c_9_11/BL c_6_10/QB 0.00303f
C1640 c_2_14/Q c_2_13/QB 0.01135f
C1641 c_13_14/QB c_9_13/BLB 0
C1642 c_1_10/Q c_1_9/VDD 0.00756f
C1643 c_6_9/WL c_9_4/BL 0.00159f
C1644 c_11_9/VDD c_9_11/BLB -0.004f
C1645 c_5_9/Q c_6_9/WL 0
C1646 c_4_13/Q c_3_13/Q 0.00634f
C1647 c_9_8/BL c_9_9/VDD -0.004f
C1648 c_11_9/WL c_10_10/QB 0
C1649 c_10_5/Q c_10_4/QB 0.01135f
C1650 c_10_5/QB c_10_4/Q 0.00377f
C1651 c_9_2/BL c_10_9/WL 0.00159f
C1652 c_9_5/BLB c_9_9/WL 0.00159f
C1653 c_9_11/BLB c_3_12/QB 0
C1654 c_9_4/BLB c_5_9/VDD -0.004f
C1655 c_9_9/BLB c_14_10/Q 0.00303f
C1656 c_3_9/QB c_4_9/WL 0
C1657 c_9_4/BL c_13_9/WL 0.00159f
C1658 c_8_9/WL c_9_2/QB 0
C1659 c_12_14/QB c_11_14/Q 0
C1660 c_9_12/BLB c_3_9/WL 0.00159f
C1661 c_7_5/QB c_7_4/Q 0.00377f
C1662 c_9_14/Q c_9_13/BLB 0.00303f
C1663 c_1_9/VDD c_0_3/Q 0.00756f
C1664 c_9_4/BL c_9_3/Q 0
C1665 c_9_12/BLB c_15_13/QB 0
C1666 c_9_8/QB c_9_9/VDD 0.00969f
C1667 c_7_7/Q c_9_8/BL 0
C1668 c_0_6/Q c_0_9/WL 0
C1669 c_13_9/WL c_14_8/QB 0
C1670 c_9_7/Q c_9_6/QB 0.01135f
C1671 c_0_12/QB c_1_9/VDD 0.00969f
C1672 c_6_6/QB c_7_9/WL 0
C1673 c_13_7/QB c_13_6/Q 0.00377f
C1674 c_9_12/Q c_8_9/WL 0
C1675 c_5_9/Q c_6_9/QB 0
C1676 c_7_2/QB c_7_1/Q 0.00377f
C1677 c_9_7/QB c_10_7/QB 0.0025f
C1678 c_1_11/Q c_9_12/BL 0
C1679 c_5_11/QB c_4_11/Q 0
C1680 c_9_7/BL c_5_9/VDD -0.004f
C1681 c_11_9/WL c_12_15/QB 0
C1682 c_9_6/BL c_9_9/WL 0.00159f
C1683 c_13_9/VDD c_12_4/Q 0.00756f
C1684 c_0_13/Q c_9_14/BL 0
C1685 c_15_2/QB c_15_9/VDD 0.00969f
C1686 c_14_0/QB c_14_1/Q 0.01135f
C1687 c_12_1/Q c_12_9/WL 0
C1688 c_9_9/WL c_10_15/Q 0
C1689 c_4_11/QB c_4_9/WL 0
C1690 c_5_4/QB c_6_4/Q 0
C1691 c_9_14/BL c_7_9/WL 0.00159f
C1692 c_3_10/Q c_2_9/WL 0
C1693 c_4_9/WL c_9_8/BL 0.00159f
C1694 c_14_2/QB c_14_3/QB 0
C1695 c_9_4/BLB c_3_9/WL 0.00159f
C1696 c_2_10/Q c_3_9/WL 0
C1697 c_10_5/Q c_10_6/Q 0
C1698 c_15_10/QB c_15_9/VDD 0.00969f
C1699 c_9_12/BLB c_9_13/QB 0
C1700 c_5_3/Q c_5_9/VDD 0.00756f
C1701 c_3_14/Q c_2_14/QB 0
C1702 c_7_3/QB c_7_2/QB 0
C1703 c_5_9/Q c_5_8/Q 0
C1704 c_0_10/Q c_0_9/Q 0
C1705 c_9_12/BLB c_3_9/VDD -0.004f
C1706 c_9_12/BL c_5_11/Q 0
C1707 c_9_12/BLB c_9_12/BL -0
C1708 c_14_5/QB c_15_9/WL 0
C1709 c_9_1/QB c_9_9/VDD 0.00969f
C1710 c_5_9/Q c_5_8/QB 0.01135f
C1711 c_1_7/QB c_1_8/QB 0
C1712 c_8_9/WL c_9_3/BL 0.00159f
C1713 c_9_10/BL c_8_9/Q 0
C1714 c_7_11/QB c_8_9/WL 0
C1715 c_1_3/Q c_0_3/Q 0.00654f
C1716 c_9_7/BL c_3_9/WL 0.00159f
C1717 c_5_15/Q c_4_9/WL 0
C1718 c_13_6/QB c_13_7/Q 0.01135f
C1719 c_10_5/QB c_11_9/VDD 0.00969f
C1720 c_11_9/WL c_10_7/Q 0
C1721 c_8_0/Q c_7_0/Q 0.00634f
C1722 c_11_15/QB c_11_14/Q 0.00377f
C1723 c_3_4/QB c_3_3/QB 0
C1724 c_7_1/QB c_9_2/BL 0.00303f
C1725 c_15_2/QB c_15_1/QB 0
C1726 c_15_12/Q c_15_11/Q 0
C1727 c_2_14/Q c_3_9/WL 0
C1728 c_0_6/Q c_0_5/Q 0
C1729 c_12_7/Q c_9_8/BL 0
C1730 c_11_9/WL c_11_2/Q 0
C1731 c_9_3/BLB c_15_9/WL 0.00122f
C1732 c_10_1/QB c_9_9/WL 0
C1733 c_7_6/Q c_8_9/WL 0
C1734 c_10_3/QB c_10_9/WL 0
C1735 c_15_7/QB c_15_9/VDD 0.00969f
C1736 c_2_10/Q c_3_9/VDD 0.00756f
C1737 c_11_9/VDD c_10_8/QB 0.00969f
C1738 c_0_8/Q c_1_9/WL 0
C1739 c_9_4/BLB c_3_9/VDD -0.004f
C1740 c_4_6/QB c_9_7/BL 0.00303f
C1741 c_14_14/Q c_15_9/WL 0
C1742 c_9_8/BLB c_8_9/Q 0.00303f
C1743 c_8_9/WL c_9_14/Q 0
C1744 c_5_7/QB c_5_6/Q 0.00377f
C1745 c_5_9/WL c_9_13/BL 0.00159f
C1746 c_11_9/WL c_9_15/BLB 0
C1747 c_9_0/BL c_5_9/WL 0
C1748 c_0_13/Q c_0_12/QB 0.01135f
C1749 c_0_13/QB c_0_12/Q 0.00377f
C1750 c_9_14/BLB c_2_15/QB 0
C1751 c_1_9/VDD c_1_2/QB 0.00969f
C1752 c_0_15/QB c_0_14/QB 0
C1753 c_2_9/WL c_2_13/Q 0
C1754 c_6_9/WL c_9_1/BL 0.00159f
C1755 c_9_3/BL c_1_2/Q 0
C1756 c_3_2/Q c_3_1/QB 0.01135f
C1757 c_2_13/QB c_1_9/WL 0
C1758 c_7_14/QB c_9_13/BLB 0
C1759 c_9_1/BLB c_5_9/VDD -0.004f
C1760 c_3_9/VDD c_9_7/BL -0.004f
C1761 c_14_9/WL c_9_14/BL 0.00159f
C1762 c_6_4/QB c_7_4/Q 0
C1763 c_10_10/Q c_10_11/QB 0.00377f
C1764 c_13_9/WL c_9_1/BL 0.00159f
C1765 c_1_9/VDD c_1_8/QB 0.00969f
C1766 c_10_12/Q c_10_11/QB 0.01135f
C1767 c_9_1/QB c_9_2/QB 0
C1768 c_7_9/VDD c_9_8/BL -0.004f
C1769 c_3_9/VDD c_2_14/Q 0.00756f
C1770 c_4_15/Q c_4_9/WL 0
C1771 c_7_5/QB c_7_4/QB 0
C1772 c_5_9/WL c_4_5/Q 0
C1773 c_9_9/WL c_9_13/Q 0
C1774 c_2_9/Q c_1_9/QB 0
C1775 c_11_1/Q c_12_1/Q 0.00634f
C1776 c_5_4/QB c_5_3/Q 0.00377f
C1777 c_4_9/QB c_4_8/QB 0
C1778 c_3_14/Q c_3_15/Q 0
C1779 c_11_9/WL c_12_4/QB 0
C1780 c_6_9/WL c_6_1/QB 0
C1781 c_9_14/QB c_9_15/Q 0.01135f
C1782 c_7_12/Q c_6_12/Q 0.00654f
C1783 c_11_10/QB c_12_9/WL 0
C1784 c_1_9/VDD c_1_14/Q 0.00756f
C1785 c_5_3/QB c_5_4/Q 0.01135f
C1786 c_15_7/QB c_15_8/QB 0
C1787 c_7_8/Q c_7_7/QB 0.01135f
C1788 c_4_8/Q c_5_8/Q 0.00654f
C1789 c_9_6/Q c_9_9/VDD 0.00756f
C1790 c_11_5/QB c_10_5/Q 0
C1791 c_9_7/QB c_8_7/Q 0
C1792 c_3_7/QB c_3_8/Q 0.01135f
C1793 c_2_11/Q c_1_11/QB 0
C1794 c_5_5/Q c_4_5/QB 0
C1795 c_11_7/Q c_12_7/Q 0.00634f
C1796 c_0_6/Q c_9_7/BL 0
C1797 c_5_9/WL c_4_9/QB 0
C1798 c_8_9/WL c_7_1/Q 0
C1799 c_14_14/QB c_14_13/QB 0
C1800 c_1_0/QB c_1_9/WL 0
C1801 c_9_1/BLB c_3_9/WL 0.00159f
C1802 c_5_8/QB c_4_8/Q 0
C1803 c_11_7/Q c_11_8/Q 0
C1804 c_7_11/Q c_8_11/Q 0.00634f
C1805 c_4_12/Q c_3_12/Q 0.00634f
C1806 c_11_4/Q c_9_3/BLB 0.00303f
C1807 c_10_1/Q c_11_1/QB 0
C1808 c_1_3/Q c_1_2/QB 0.01135f
C1809 c_1_3/QB c_1_2/Q 0.00377f
C1810 c_9_15/BL c_9_9/VDD -0.004f
C1811 c_13_6/QB c_9_7/BL 0.00303f
C1812 c_11_9/VDD c_9_13/BL -0.004f
C1813 c_9_11/QB c_9_10/QB 0
C1814 c_14_9/Q c_15_9/VDD 0.00756f
C1815 c_9_2/BL c_3_1/Q 0
C1816 c_4_6/Q c_3_6/QB 0
C1817 c_9_13/BL c_3_12/QB 0.00303f
C1818 c_12_13/QB c_12_9/WL 0
C1819 c_9_0/BL c_11_9/VDD -0.01128f
C1820 c_9_7/BLB c_1_8/Q 0.00303f
C1821 c_7_1/QB c_7_0/Q 0.00377f
C1822 c_9_7/BL c_3_6/Q 0
C1823 c_7_8/Q c_9_7/BLB 0.00303f
C1824 c_8_8/Q c_7_9/WL 0
C1825 c_0_11/QB c_1_9/VDD 0.00969f
C1826 c_6_6/Q c_6_7/QB 0.00377f
C1827 c_14_6/QB c_14_5/QB 0
C1828 c_6_12/Q c_7_9/WL 0
C1829 c_7_3/QB c_8_9/WL 0
C1830 c_9_9/WL c_9_9/VDD 0.04545f
C1831 c_8_2/Q c_9_9/VDD 0.00756f
C1832 c_2_8/QB c_1_9/WL 0
C1833 c_11_9/VDD c_10_2/QB 0.00969f
C1834 c_7_9/QB c_8_9/QB 0.0025f
C1835 c_3_2/Q c_2_2/Q 0.00654f
C1836 c_14_11/QB c_9_12/BL 0.00303f
C1837 c_12_2/Q c_12_3/QB 0.00377f
C1838 c_3_3/QB c_2_3/Q 0
C1839 c_10_9/WL c_11_11/QB 0
C1840 c_9_0/BLB c_9_1/BL 2.55595f
C1841 c_3_5/Q c_3_9/WL 0
C1842 c_5_9/WL c_9_5/BLB 0.00159f
C1843 c_4_9/WL c_3_11/Q 0
C1844 c_6_11/QB c_5_11/QB 0.0025f
C1845 c_1_1/Q c_2_1/Q 0.00634f
C1846 c_1_6/QB c_2_6/Q 0
C1847 c_8_0/QB c_7_0/QB 0.0025f
C1848 c_7_9/VDD c_6_9/Q 0.00756f
C1849 c_10_9/QB c_10_8/QB 0
C1850 c_8_9/WL c_7_14/QB 0
C1851 c_12_9/WL c_12_10/QB 0
C1852 c_4_7/QB c_5_9/VDD 0.00969f
C1853 c_9_1/BLB c_3_9/VDD -0.004f
C1854 c_13_9/WL c_12_9/QB 0
C1855 c_2_12/Q c_1_12/QB 0
C1856 c_9_15/BL c_4_9/WL 0.00159f
C1857 c_5_7/QB c_4_7/Q 0
C1858 c_13_11/QB c_13_9/VDD 0.00969f
C1859 c_8_6/Q c_8_5/Q 0
C1860 c_6_1/QB c_9_0/BLB 0
C1861 c_3_13/Q c_2_13/QB 0
C1862 c_3_14/Q c_4_14/Q 0.00634f
C1863 c_11_9/WL c_12_5/Q 0
C1864 c_8_0/QB c_9_9/VDD 0.00777f
C1865 c_7_9/VDD c_6_10/Q 0.00756f
C1866 c_2_9/WL c_9_5/BL 0.00159f
C1867 c_5_9/WL c_9_6/BL 0.00159f
C1868 c_6_2/Q c_7_9/WL 0
C1869 c_13_4/QB c_13_5/QB 0
C1870 c_13_9/VDD c_12_2/QB 0.00969f
C1871 c_9_5/BL c_8_4/Q 0
C1872 c_9_0/BLB c_2_9/WL 0.00159f
C1873 c_3_7/Q c_9_8/BL 0
C1874 c_8_10/QB c_9_10/Q 0
C1875 c_1_7/Q c_2_7/Q 0.00634f
C1876 c_13_9/WL c_14_3/Q 0
C1877 c_1_4/Q c_0_4/QB 0
C1878 c_13_3/Q c_13_9/WL 0
C1879 c_13_5/Q c_9_6/BL 0
C1880 c_8_9/WL c_9_11/Q 0
C1881 c_2_9/WL c_2_14/QB 0
C1882 c_12_0/Q c_13_0/Q 0.00654f
C1883 c_15_6/Q c_15_7/QB 0.00377f
C1884 c_15_9/VDD c_14_5/Q 0.00756f
C1885 c_3_14/QB c_2_9/WL 0
C1886 c_3_5/Q c_3_9/VDD 0.00756f
C1887 c_9_4/QB c_9_3/Q 0.00377f
C1888 c_6_4/QB c_7_4/QB 0.01281f
C1889 c_9_12/BLB c_15_9/VDD -0.004f
C1890 c_1_13/Q c_9_14/BL 0
C1891 c_5_9/WL c_4_1/QB 0
C1892 c_15_5/QB c_15_6/QB 0
C1893 c_8_10/Q c_8_9/QB 0.01135f
C1894 c_3_1/Q c_2_1/QB 0
C1895 c_3_1/QB c_2_1/Q 0
C1896 c_14_12/QB c_9_11/BLB 0
C1897 c_9_12/BL c_12_9/WL 0.00159f
C1898 c_10_9/WL c_9_9/BL 0.00159f
C1899 c_9_9/WL c_9_2/QB 0
C1900 c_4_7/QB c_3_9/WL 0
C1901 c_8_2/Q c_9_2/QB 0
C1902 c_9_12/BL c_1_9/WL 0.00159f
C1903 c_12_9/Q c_12_10/QB 0.00377f
C1904 c_12_9/QB c_12_10/Q 0.01135f
C1905 c_2_9/WL c_2_4/Q 0
C1906 c_8_11/Q c_7_9/WL 0
C1907 c_13_15/QB c_12_9/WL 0
C1908 c_14_9/WL c_15_9/WL 0.06483f
C1909 c_2_7/QB c_2_6/QB 0
C1910 c_2_10/QB c_9_9/BLB 0
C1911 c_1_9/WL c_2_4/QB 0
C1912 c_11_14/QB c_11_15/Q 0.01135f
C1913 c_8_3/Q c_9_3/Q 0.00654f
C1914 c_14_11/Q c_9_12/BL 0
C1915 c_9_4/BLB c_4_5/QB 0
C1916 c_9_12/Q c_9_9/WL 0
C1917 c_11_9/VDD c_9_5/BLB -0.004f
C1918 c_8_6/Q c_9_6/QB 0
C1919 c_4_9/QB c_3_9/Q 0
C1920 c_4_6/QB c_4_7/QB 0
C1921 c_8_6/QB c_7_9/WL 0
C1922 c_3_8/QB c_4_8/QB 0.0025f
C1923 c_12_11/QB c_12_9/WL 0
C1924 c_2_0/QB c_1_9/WL 0
C1925 c_0_8/QB c_9_7/BLB 0
C1926 c_1_3/QB c_1_4/Q 0.01135f
C1927 c_4_9/QB c_9_10/BL 0.00303f
C1928 c_2_10/QB c_3_10/QB 0.01281f
C1929 c_9_4/BLB c_15_9/VDD -0.004f
C1930 c_11_9/WL c_12_1/Q 0
C1931 c_10_15/QB c_9_9/WL 0
C1932 c_3_13/QB c_4_9/WL 0
C1933 c_5_9/VDD c_9_10/BLB -0.004f
C1934 c_13_9/WL c_12_8/QB 0
C1935 c_9_2/BLB c_0_3/QB 0
C1936 c_9_14/BL c_9_14/BLB -0
C1937 c_12_4/Q c_12_5/QB 0.00377f
C1938 c_12_4/QB c_12_5/Q 0.01135f
C1939 c_8_8/QB c_8_9/QB 0
C1940 c_14_9/WL c_15_12/QB 0
C1941 c_6_9/WL c_5_13/Q 0
C1942 c_4_10/Q c_5_9/WL 0
C1943 c_12_0/QB c_9_1/BL 0.00303f
C1944 c_9_3/BLB c_5_4/Q 0.00303f
C1945 c_1_6/Q c_1_7/Q 0
C1946 c_0_6/Q c_1_9/WL 0
C1947 c_11_9/VDD c_9_6/BL -0.004f
C1948 c_9_15/BL c_7_9/VDD -0.004f
C1949 c_3_5/Q c_3_6/Q 0
C1950 c_4_9/QB c_9_8/BLB 0
C1951 c_9_15/BL c_14_14/QB 0.00303f
C1952 c_13_6/QB c_12_9/WL 0
C1953 c_9_4/QB c_9_5/BL 0.00303f
C1954 c_9_15/BL c_13_14/QB 0.00303f
C1955 c_11_9/VDD c_10_15/Q 0.00565f
C1956 c_9_11/BL c_5_10/QB 0.00303f
C1957 c_13_9/VDD c_13_9/WL 0.04545f
C1958 c_4_2/Q c_4_3/QB 0.00377f
C1959 c_9_7/BL c_15_9/VDD -0.004f
C1960 c_10_9/WL c_11_4/QB 0
C1961 c_3_13/Q c_3_9/WL 0
C1962 c_11_12/QB c_11_11/QB 0
C1963 c_10_10/Q c_9_10/Q 0.00634f
C1964 c_11_14/QB c_9_13/BLB 0
C1965 c_6_10/QB c_7_9/WL 0
C1966 c_6_9/WL c_6_3/QB 0
C1967 c_12_15/Q c_12_9/WL 0
C1968 c_11_10/QB c_10_10/QB 0.01281f
C1969 c_9_3/BL c_9_9/WL 0.00159f
C1970 c_8_9/WL c_9_6/BLB 0.00159f
C1971 c_9_3/BL c_8_2/Q 0
C1972 c_2_9/WL c_3_12/Q 0
C1973 c_5_14/Q c_5_13/Q 0
C1974 c_12_12/Q c_13_9/WL 0
C1975 c_9_14/BL c_14_13/Q 0
C1976 c_10_5/QB c_10_6/QB 0
C1977 c_4_10/Q c_5_10/Q 0.00654f
C1978 c_13_9/VDD c_12_13/Q 0.00756f
C1979 c_9_7/BLB c_14_8/QB 0
C1980 c_2_2/Q c_2_1/Q 0
C1981 c_3_15/Q c_2_9/WL 0
C1982 c_3_0/Q c_3_1/QB 0.00377f
C1983 c_3_0/QB c_3_1/Q 0.01135f
C1984 c_3_9/WL c_9_10/BLB 0.00159f
C1985 c_9_15/BL c_9_14/Q 0
C1986 c_15_14/QB c_14_14/QB 0.01281f
C1987 c_12_12/Q c_12_13/Q 0
C1988 c_2_11/Q c_3_11/Q 0.00654f
C1989 c_4_12/Q c_9_11/BLB 0.00303f
C1990 c_5_3/QB c_4_3/QB 0.01281f
C1991 c_10_5/Q c_9_9/WL 0
C1992 c_10_12/Q c_11_12/Q 0.00654f
C1993 c_9_14/Q c_9_9/WL 0
C1994 c_6_7/Q c_6_8/QB 0.00377f
C1995 c_13_9/VDD c_12_10/Q 0.00756f
C1996 c_9_4/BL c_9_3/QB 0.00303f
C1997 c_14_2/QB c_13_2/Q 0
C1998 c_9_9/QB c_8_9/QB 0.01281f
C1999 c_6_9/WL c_7_9/QB 0
C2000 c_12_2/QB c_11_2/QB 0.0025f
C2001 c_9_8/Q c_8_8/QB 0
C2002 c_10_1/QB c_11_9/VDD 0.00969f
C2003 c_9_2/BL c_2_1/Q 0
C2004 c_3_9/VDD c_3_13/Q 0.00756f
C2005 c_10_9/WL c_11_12/QB 0
C2006 c_6_9/WL c_6_15/Q 0
C2007 c_10_9/WL c_11_14/Q 0
C2008 c_8_9/WL c_9_11/BL 0.00159f
C2009 c_7_10/Q c_7_9/Q 0
C2010 c_13_9/VDD c_9_5/BL -0.004f
C2011 c_14_0/Q c_15_0/Q 0.00654f
C2012 c_13_9/VDD c_9_0/BLB -0.004f
C2013 c_3_9/VDD c_9_10/BLB -0.004f
C2014 c_9_9/BL c_13_8/QB 0.00303f
C2015 c_14_11/QB c_15_9/VDD 0.00969f
C2016 c_5_0/Q c_5_1/Q 0
C2017 c_6_9/QB c_7_9/QB 0.01281f
C2018 c_1_1/QB c_1_2/Q 0.01135f
C2019 c_1_1/Q c_1_2/QB 0.00377f
C2020 c_14_9/WL c_14_6/QB 0
C2021 c_6_9/WL c_6_13/QB 0
C2022 c_6_7/QB c_5_7/Q 0
C2023 c_6_14/Q c_7_9/WL 0
C2024 c_13_1/Q c_12_1/Q 0.00654f
C2025 c_11_9/WL c_11_10/QB 0
C2026 c_12_0/Q c_11_0/QB 0
C2027 c_8_15/QB c_9_9/WL 0
C2028 c_9_6/BLB c_14_7/Q 0.00303f
C2029 c_11_8/QB c_12_9/WL 0
C2030 c_5_2/Q c_4_9/WL 0
C2031 c_9_13/QB c_10_13/Q 0
C2032 c_4_3/Q c_4_9/WL 0
C2033 c_1_10/Q c_0_10/QB 0
C2034 c_1_10/QB c_0_10/Q 0
C2035 c_12_11/QB c_9_10/BLB 0
C2036 c_4_8/QB c_4_9/WL 0
C2037 c_9_1/BLB c_15_9/VDD -0.004f
C2038 c_8_2/QB c_8_3/QB 0
C2039 c_14_2/QB c_14_9/WL 0
C2040 c_11_10/Q c_12_10/Q 0.00634f
C2041 c_9_10/QB c_9_9/VDD 0.00969f
C2042 c_3_9/Q c_3_8/QB 0.01135f
C2043 c_5_5/Q c_6_9/WL 0
C2044 c_8_11/Q c_8_12/Q 0
C2045 c_9_7/BLB c_4_8/Q 0.00303f
C2046 c_9_2/BLB c_9_9/VDD -0.004f
C2047 c_3_10/Q c_2_10/Q 0.00654f
C2048 c_9_5/BL c_0_4/Q 0
C2049 c_6_3/Q c_5_9/WL 0
C2050 c_9_9/BLB c_9_10/Q 0.00303f
C2051 c_10_14/Q c_10_15/Q 0
C2052 c_2_3/QB c_1_9/WL 0
C2053 c_3_5/Q c_4_5/QB 0
C2054 c_11_13/QB c_12_13/Q 0
C2055 c_2_9/WL c_9_9/BLB 0.00159f
C2056 c_9_14/QB c_9_15/QB 0
C2057 c_9_8/Q c_9_9/QB 0.00377f
C2058 c_5_9/WL c_5_13/QB 0
C2059 c_9_14/BLB c_15_9/WL 0.00122f
C2060 c_12_4/Q c_12_9/WL 0
C2061 c_11_9/WL c_12_13/QB 0
C2062 c_9_11/BL c_14_10/QB 0.00303f
C2063 c_1_15/QB c_2_9/WL 0
C2064 c_5_9/WL c_4_9/WL 0.06483f
C2065 c_14_12/QB c_9_13/BL 0.00303f
C2066 c_14_9/Q c_13_9/WL 0
C2067 c_10_9/WL c_9_6/QB 0
C2068 c_14_1/Q c_15_9/WL 0
C2069 c_9_15/BLB c_5_9/VDD -0.01128f
C2070 c_9_15/BL c_7_14/QB 0.00303f
C2071 c_4_10/Q c_4_11/Q 0
C2072 c_3_4/QB c_3_9/WL 0
C2073 c_13_3/QB c_12_3/Q 0
C2074 c_4_9/WL c_3_8/Q 0
C2075 c_2_9/WL c_3_10/QB 0
C2076 c_11_7/Q c_9_6/BLB 0.00303f
C2077 c_5_6/QB c_9_5/BLB 0
C2078 c_6_3/Q c_9_2/BLB 0.00303f
C2079 c_13_6/Q c_13_9/VDD 0.00756f
C2080 c_2_6/Q c_2_5/QB 0.01135f
C2081 c_9_12/BLB c_2_13/Q 0.00303f
C2082 c_1_13/Q c_1_14/Q 0
C2083 c_14_13/Q c_15_9/WL 0
C2084 c_11_9/WL c_12_10/QB 0
C2085 c_2_8/Q c_3_9/WL 0
C2086 c_14_11/Q c_15_9/VDD 0.00756f
C2087 c_4_9/WL c_5_10/Q 0
C2088 c_4_9/WL c_9_2/BLB 0.00159f
C2089 c_15_15/Q c_15_14/Q 0
C2090 c_12_15/QB c_13_15/QB 0.01281f
C2091 c_9_0/QB c_9_9/VDD 0.00777f
C2092 c_15_6/Q c_9_7/BL 0
C2093 c_11_6/Q c_9_5/BLB 0.00303f
C2094 c_6_11/Q c_6_10/Q 0
C2095 c_13_9/WL c_13_7/Q 0
C2096 c_8_5/QB c_8_6/QB 0
C2097 c_3_3/QB c_3_9/WL 0
C2098 c_4_13/Q c_5_9/VDD 0.00756f
C2099 c_9_7/BLB c_2_9/WL 0.00159f
C2100 c_5_0/Q c_6_0/Q 0.00634f
C2101 c_12_0/QB c_13_9/VDD 0.00777f
C2102 c_11_7/QB c_9_8/BL 0.00303f
C2103 c_10_9/Q c_10_10/Q 0
C2104 c_6_9/WL c_6_4/Q 0
C2105 c_9_15/BLB c_3_9/WL 0
C2106 c_9_3/BL c_5_2/Q 0
C2107 c_10_12/Q c_10_13/QB 0.00377f
C2108 c_10_12/QB c_10_13/Q 0.01135f
C2109 c_4_4/Q c_9_3/BLB 0.00303f
C2110 c_12_13/QB c_13_13/QB 0.01281f
C2111 c_9_9/WL c_9_11/Q 0
C2112 c_13_9/WL c_13_13/Q 0
C2113 c_15_13/QB c_15_14/Q 0.01135f
C2114 c_2_9/WL c_9_11/BLB 0.00159f
C2115 c_3_4/QB c_3_9/VDD 0.00969f
C2116 c_0_9/WL c_9_5/BL 0.00122f
C2117 c_6_9/WL c_9_12/BLB 0.00159f
C2118 c_13_10/Q c_13_9/Q 0
C2119 c_6_9/WL c_5_11/Q 0
C2120 c_0_9/WL c_9_0/BLB 0.00122f
C2121 c_13_5/QB c_14_5/QB 0.0025f
C2122 c_8_13/Q c_9_13/QB 0
C2123 c_3_4/QB c_2_4/QB 0.01281f
C2124 c_10_1/Q c_9_1/QB 0
C2125 c_10_1/QB c_9_1/Q 0
C2126 c_12_13/Q c_13_13/Q 0.00654f
C2127 c_13_10/QB c_14_10/Q 0
C2128 c_13_10/Q c_14_10/QB 0
C2129 c_13_9/WL c_14_5/Q 0
C2130 c_11_9/WL c_9_12/BL 0.00159f
C2131 c_5_9/WL c_6_12/QB 0
C2132 c_11_12/Q c_9_11/BLB 0.00303f
C2133 c_6_13/Q c_7_13/Q 0.00654f
C2134 c_9_12/BLB c_13_9/WL 0.00159f
C2135 c_3_9/VDD c_2_8/Q 0.00756f
C2136 c_14_9/WL c_13_0/Q 0
C2137 c_9_10/BL c_9_9/VDD -0.004f
C2138 c_9_7/QB c_8_7/QB 0.01281f
C2139 c_1_9/VDD c_9_13/BLB -0.004f
C2140 c_4_9/WL c_3_12/QB 0
C2141 c_2_2/Q c_1_2/QB 0
C2142 c_2_2/QB c_1_2/Q 0
C2143 c_4_13/Q c_3_9/WL 0
C2144 c_11_8/QB c_12_8/Q 0
C2145 c_10_4/QB c_9_3/BLB 0
C2146 c_11_0/QB c_10_0/QB 0.01281f
C2147 c_5_9/WL c_9_3/BL 0.00159f
C2148 c_4_12/Q c_9_13/BL 0
C2149 c_15_15/QB c_15_9/VDD 0.00479f
C2150 c_9_12/BLB c_12_13/Q 0.00303f
C2151 c_9_11/QB c_10_11/QB 0.0025f
C2152 c_3_3/QB c_3_9/VDD 0.00969f
C2153 c_7_15/QB c_6_9/WL 0
C2154 c_10_6/QB c_9_5/BLB 0
C2155 c_9_2/BL c_15_9/WL 0.00122f
C2156 c_15_4/Q c_15_3/Q 0
C2157 c_12_6/Q c_12_7/QB 0.00377f
C2158 c_9_11/BL c_6_10/Q 0
C2159 c_9_13/BLB c_14_14/Q 0.00303f
C2160 c_11_10/Q c_10_10/Q 0.00654f
C2161 c_2_14/Q c_2_13/Q 0
C2162 c_6_9/WL c_9_4/BLB 0.00159f
C2163 c_13_14/Q c_9_13/BLB 0.00303f
C2164 c_12_11/QB c_11_9/WL 0
C2165 c_3_9/VDD c_9_15/BLB -0.01128f
C2166 c_6_2/QB c_7_2/QB 0.01281f
C2167 c_9_8/BLB c_9_9/VDD -0.004f
C2168 c_1_5/QB c_1_4/Q 0.00377f
C2169 c_14_3/QB c_15_3/QB 0.01281f
C2170 c_10_5/Q c_10_4/Q 0
C2171 c_12_14/Q c_11_14/Q 0.00634f
C2172 c_12_11/Q c_11_11/QB 0
C2173 c_1_15/Q c_1_9/VDD 0.00565f
C2174 c_3_9/Q c_4_9/WL 0
C2175 c_9_4/BLB c_13_9/WL 0.00159f
C2176 c_8_9/WL c_9_2/Q 0
C2177 c_7_5/Q c_7_4/Q 0
C2178 c_11_14/QB c_11_13/Q 0.00377f
C2179 c_2_12/Q c_3_12/QB 0
C2180 c_9_3/BL c_9_2/BLB 2.55595f
C2181 c_9_2/BLB c_12_3/Q 0.00303f
C2182 c_9_12/BLB c_15_13/Q 0.00303f
C2183 c_7_9/VDD c_9_2/BLB -0.004f
C2184 c_13_11/QB c_14_11/QB 0.0025f
C2185 c_0_12/Q c_1_9/VDD 0.00756f
C2186 c_8_13/QB c_8_12/QB 0
C2187 c_10_6/QB c_9_6/BL 0
C2188 c_2_3/Q c_3_9/WL 0
C2189 c_9_10/BL c_4_9/WL 0.00159f
C2190 c_6_9/WL c_9_7/BL 0.00159f
C2191 c_13_2/QB c_13_3/QB 0
C2192 c_8_14/Q c_9_13/BLB 0.00303f
C2193 c_11_9/VDD c_10_15/QB 0.00479f
C2194 c_11_9/VDD c_11_8/Q 0.00756f
C2195 c_6_4/Q c_9_5/BL 0
C2196 c_11_9/Q c_11_9/VDD 0.00756f
C2197 c_11_8/Q c_10_8/Q 0.00654f
C2198 c_7_14/Q c_8_14/QB 0
C2199 c_7_2/QB c_7_9/WL 0
C2200 c_15_10/QB c_9_9/BLB 0
C2201 c_9_7/QB c_10_7/Q 0
C2202 c_11_9/WL c_12_15/Q 0
C2203 c_9_6/BLB c_9_9/WL 0.00159f
C2204 c_8_1/QB c_9_0/BLB 0
C2205 c_6_15/QB c_7_9/WL 0
C2206 c_13_9/WL c_12_5/QB 0
C2207 c_1_13/QB c_1_12/QB 0
C2208 c_13_9/VDD c_9_9/BLB -0.004f
C2209 c_15_9/VDD c_9_10/BLB -0.004f
C2210 c_15_2/Q c_15_9/VDD 0.00756f
C2211 c_13_9/WL c_9_7/BL 0.00159f
C2212 c_14_0/Q c_14_1/Q 0
C2213 c_4_10/QB c_4_9/Q 0.00377f
C2214 c_8_9/WL c_9_0/Q 0
C2215 c_11_9/WL c_10_12/QB 0
C2216 c_6_9/WL c_5_3/Q 0
C2217 c_4_9/WL c_9_8/BLB 0.00159f
C2218 c_5_9/Q c_4_9/QB 0
C2219 c_4_11/Q c_4_9/WL 0
C2220 c_15_1/Q c_15_0/QB 0.01135f
C2221 c_9_1/BLB c_12_2/QB 0
C2222 c_1_5/Q c_0_5/QB 0
C2223 c_4_4/QB c_3_4/Q 0
C2224 c_14_2/QB c_14_1/Q 0.00377f
C2225 c_5_15/QB c_6_15/Q 0
C2226 c_5_13/QB c_6_13/Q 0
C2227 c_7_3/Q c_7_2/QB 0.01135f
C2228 c_9_4/QB c_9_3/QB 0
C2229 c_11_9/VDD c_9_3/BL -0.004f
C2230 c_9_13/BLB c_1_14/QB 0
C2231 c_3_0/QB c_4_0/Q 0
C2232 c_6_6/QB c_6_7/QB 0
C2233 c_9_7/BLB c_12_8/QB 0
C2234 c_0_11/QB c_0_10/QB 0
C2235 c_9_1/Q c_9_9/VDD 0.00756f
C2236 c_1_7/QB c_9_8/BL 0.00303f
C2237 c_11_7/QB c_11_6/QB 0
C2238 c_3_9/VDD c_2_3/Q 0.00756f
C2239 c_14_0/QB c_13_0/QB 0.0025f
C2240 c_1_3/QB c_9_2/BLB 0
C2241 c_1_7/Q c_1_8/QB 0.00377f
C2242 c_8_9/WL c_9_3/BLB 0.00159f
C2243 c_15_7/Q c_15_8/Q 0
C2244 c_9_4/BLB c_9_5/BL 2.55595f
C2245 c_15_5/Q c_15_9/WL 0
C2246 c_11_9/Q c_9_10/BL 0
C2247 c_7_11/Q c_8_9/WL 0
C2248 c_9_13/BLB c_7_9/WL 0.00159f
C2249 c_13_6/Q c_13_7/Q 0
C2250 c_10_5/Q c_11_9/VDD 0.00756f
C2251 c_9_3/QB c_8_3/Q 0
C2252 c_7_13/QB c_6_13/QB 0.01281f
C2253 c_2_3/Q c_2_4/QB 0.00377f
C2254 c_15_12/Q c_15_9/WL 0
C2255 c_13_11/QB c_12_9/WL 0
C2256 c_3_4/QB c_3_3/Q 0.00377f
C2257 c_15_9/QB c_15_9/WL 0
C2258 c_15_2/Q c_15_1/QB 0.01135f
C2259 c_9_11/BL c_9_9/WL 0.00159f
C2260 c_13_9/VDD c_9_7/BLB -0.004f
C2261 c_1_15/Q c_1_14/QB 0.01135f
C2262 c_12_2/QB c_12_9/WL 0
C2263 c_10_3/Q c_10_9/WL 0
C2264 c_10_1/Q c_9_9/WL 0
C2265 c_13_11/QB c_14_11/Q 0
C2266 c_4_6/Q c_9_7/BL 0
C2267 c_8_13/QB c_7_13/QB 0.0025f
C2268 c_11_10/Q c_9_9/BLB 0.00303f
C2269 c_9_14/BL c_10_9/WL 0.00159f
C2270 c_11_9/Q c_9_8/BLB 0.00303f
C2271 c_11_0/QB c_10_0/Q 0
C2272 c_3_7/Q c_3_8/Q 0
C2273 c_13_9/VDD c_9_11/BLB -0.004f
C2274 c_1_9/VDD c_1_11/QB 0.00969f
C2275 c_11_14/QB c_9_15/BL 0.00303f
C2276 c_6_12/Q c_5_12/QB 0
C2277 c_7_9/VDD c_9_10/BL -0.004f
C2278 c_14_11/QB c_13_9/WL 0
C2279 c_0_13/Q c_0_12/Q 0
C2280 c_9_14/BLB c_2_15/Q 0.00303f
C2281 c_11_9/WL c_11_8/QB 0
C2282 c_1_9/VDD c_1_2/Q 0.00756f
C2283 c_12_12/Q c_9_11/BLB 0.00303f
C2284 c_0_15/QB c_0_14/Q 0.00377f
C2285 c_0_15/Q c_0_14/QB 0.01135f
C2286 c_8_14/Q c_8_9/WL 0
C2287 c_6_9/WL c_9_1/BLB 0.00159f
C2288 c_3_2/Q c_3_1/Q 0
C2289 c_2_13/Q c_1_9/WL 0
C2290 c_7_12/Q c_8_9/WL 0
C2291 c_1_9/VDD c_9_8/BL -0.004f
C2292 c_3_14/QB c_2_14/Q 0
C2293 c_5_0/QB c_4_0/Q 0
C2294 c_6_12/QB c_6_13/Q 0.01135f
C2295 c_7_3/QB c_9_2/BLB 0
C2296 c_13_9/WL c_9_1/BLB 0.00159f
C2297 c_7_9/VDD c_9_8/BLB -0.004f
C2298 c_9_1/QB c_9_2/Q 0.01135f
C2299 c_9_1/Q c_9_2/QB 0.00377f
C2300 c_9_4/BL c_0_3/QB 0.00303f
C2301 c_2_9/WL c_9_13/BL 0.00159f
C2302 c_7_5/Q c_7_4/QB 0.01135f
C2303 c_10_14/Q c_10_15/QB 0.00377f
C2304 c_3_6/QB c_3_7/QB 0
C2305 c_4_9/QB c_4_8/Q 0.00377f
C2306 c_9_0/BL c_2_9/WL 0
C2307 c_6_4/QB c_6_3/QB 0
C2308 c_11_9/WL c_12_4/Q 0
C2309 c_11_9/Q c_10_9/QB 0
C2310 c_14_4/QB c_14_3/Q 0.00377f
C2311 c_7_9/VDD c_6_13/Q 0.00756f
C2312 c_13_4/QB c_13_3/QB 0
C2313 c_8_15/Q c_8_9/WL 0
C2314 c_7_8/Q c_7_7/Q 0
C2315 c_5_6/QB c_4_9/WL 0
C2316 c_9_13/BL c_11_12/Q 0
C2317 c_0_9/WL c_9_9/BLB 0.00122f
C2318 c_3_3/QB c_2_3/QB 0.01281f
C2319 c_4_14/QB c_9_13/BLB 0
C2320 c_14_15/QB c_15_9/WL 0
C2321 c_13_9/VDD c_13_1/QB 0.00969f
C2322 c_11_9/VDD c_11_9/QB 0.00969f
C2323 c_14_9/WL c_9_13/BLB 0.00159f
C2324 c_0_9/WL c_1_15/QB 0
C2325 c_8_10/Q c_9_9/BLB 0.00303f
C2326 c_9_1/QB c_9_0/Q 0.00377f
C2327 c_3_5/QB c_4_5/Q 0
C2328 c_14_14/Q c_14_13/QB 0.01135f
C2329 c_6_15/QB c_6_14/QB 0
C2330 c_8_9/WL c_7_9/WL 0.8704f
C2331 c_14_9/WL c_13_5/QB 0
C2332 c_13_9/WL c_12_9/WL 0.06483f
C2333 c_7_9/VDD c_7_4/Q 0.00756f
C2334 c_1_3/Q c_1_2/Q 0
C2335 c_7_2/Q c_9_3/BL 0
C2336 c_10_5/QB c_9_5/QB 0.0025f
C2337 c_7_9/VDD c_7_2/Q 0.00756f
C2338 c_13_6/Q c_9_7/BL 0
C2339 c_9_11/QB c_9_10/Q 0.00377f
C2340 c_9_11/Q c_9_10/QB 0.01135f
C2341 c_2_9/WL c_3_7/QB 0
C2342 c_9_12/BLB c_7_13/QB 0
C2343 c_12_13/Q c_12_9/WL 0
C2344 c_10_11/Q c_9_10/BLB 0.00303f
C2345 c_14_11/Q c_13_9/WL 0
C2346 c_0_11/Q c_1_9/VDD 0.00756f
C2347 c_15_9/VDD c_9_15/BLB -0.01128f
C2348 c_14_6/Q c_14_5/QB 0.01135f
C2349 c_3_6/QB c_9_5/BLB 0
C2350 c_7_3/Q c_8_9/WL 0
C2351 c_15_14/Q c_15_9/VDD 0.00756f
C2352 c_7_9/Q c_8_9/QB 0
C2353 c_7_9/QB c_8_9/Q 0
C2354 c_4_13/QB c_4_14/Q 0.01135f
C2355 c_3_3/Q c_2_3/Q 0.00654f
C2356 c_9_14/Q c_10_14/Q 0.00634f
C2357 c_0_9/WL c_9_7/BLB 0.00122f
C2358 c_13_11/QB c_9_10/BLB 0
C2359 c_9_10/BL c_11_9/QB 0.00303f
C2360 c_9_13/BLB c_6_14/QB 0
C2361 c_2_13/QB c_3_9/WL 0
C2362 c_10_9/Q c_10_8/QB 0.01135f
C2363 c_5_7/QB c_6_7/QB 0.0025f
C2364 c_15_6/QB c_15_9/VDD 0.00969f
C2365 c_13_8/Q c_13_9/QB 0.00377f
C2366 c_12_9/WL c_12_10/Q 0
C2367 c_0_9/WL c_9_11/BLB 0.00122f
C2368 c_13_9/WL c_12_9/Q 0
C2369 c_4_2/QB c_9_1/BLB 0
C2370 c_9_8/BL c_7_9/WL 0.00159f
C2371 c_1_9/VDD c_1_4/Q 0.00756f
C2372 c_14_8/Q c_14_7/QB 0.01135f
C2373 c_5_9/WL c_6_11/Q 0
C2374 c_3_13/Q c_2_13/Q 0.00654f
C2375 c_13_7/QB c_12_7/Q 0
C2376 c_13_9/VDD c_12_1/QB 0.00969f
C2377 c_9_8/BLB c_11_9/QB 0
C2378 c_9_3/BLB c_1_4/Q 0.00303f
C2379 c_15_11/Q c_15_9/WL 0
C2380 c_2_9/WL c_9_5/BLB 0.00159f
C2381 c_5_9/WL c_9_6/BLB 0.00159f
C2382 c_5_14/QB c_5_9/VDD 0.00969f
C2383 c_13_4/QB c_13_5/Q 0.01135f
C2384 c_13_4/Q c_13_5/QB 0.00377f
C2385 c_13_9/VDD c_12_2/Q 0.00756f
C2386 c_10_11/Q c_10_10/QB 0.01135f
C2387 c_9_4/BLB c_7_5/QB 0
C2388 c_9_5/BL c_12_9/WL 0.00159f
C2389 c_9_0/BLB c_12_9/WL 0.00159f
C2390 c_9_5/BL c_1_9/WL 0.00159f
C2391 c_9_0/BLB c_1_9/WL 0.00159f
C2392 c_9_9/BL c_15_9/WL 0.00122f
C2393 c_14_3/QB c_13_3/QB 0.0025f
C2394 c_11_10/QB c_12_10/QB 0.0025f
C2395 c_8_8/QB c_9_7/BLB 0
C2396 c_2_14/QB c_1_9/WL 0
C2397 c_9_4/Q c_9_3/Q 0
C2398 c_8_8/Q c_9_9/BL 0
C2399 c_3_1/Q c_2_1/Q 0.00654f
C2400 c_8_10/Q c_8_9/Q 0
C2401 c_6_5/Q c_6_9/WL 0
C2402 c_3_9/VDD c_2_13/QB 0.00969f
C2403 c_1_6/Q c_1_5/Q 0
C2404 c_3_5/QB c_9_6/BL 0.00303f
C2405 c_15_12/QB c_15_11/Q 0.00377f
C2406 c_8_2/Q c_9_2/Q 0.00654f
C2407 c_9_9/WL c_9_2/Q 0
C2408 c_12_9/Q c_12_10/Q 0
C2409 c_2_9/WL c_9_6/BL 0.00159f
C2410 c_9_4/BL c_9_9/VDD -0.004f
C2411 c_1_12/QB c_1_9/VDD 0.00969f
C2412 c_5_2/Q c_5_1/QB 0.01135f
C2413 c_7_8/Q c_7_9/VDD 0.00756f
C2414 c_9_6/BLB c_0_7/QB 0
C2415 c_7_2/Q c_7_1/Q 0
C2416 c_2_7/QB c_2_6/Q 0.00377f
C2417 c_2_7/Q c_2_6/QB 0.01135f
C2418 c_2_10/Q c_9_9/BLB 0.00303f
C2419 c_4_7/Q c_9_8/BL 0
C2420 c_5_9/QB c_5_9/VDD 0.00969f
C2421 c_1_9/WL c_2_4/Q 0
C2422 c_10_9/QB c_11_9/QB 0.01281f
C2423 c_9_14/BLB c_11_15/Q 0.00303f
C2424 c_4_6/QB c_5_9/VDD 0.00969f
C2425 c_3_14/Q c_4_9/WL 0
C2426 c_2_8/QB c_3_9/WL 0
C2427 c_4_6/Q c_4_7/QB 0.00377f
C2428 c_6_9/WL c_9_10/BLB 0.00159f
C2429 c_4_12/QB c_5_12/QB 0.01281f
C2430 c_6_15/QB c_9_14/BLB 0
C2431 c_13_9/VDD c_9_13/BL -0.004f
C2432 c_11_5/Q c_10_5/QB 0
C2433 c_3_8/QB c_4_8/Q 0
C2434 c_5_9/WL c_9_11/BL 0.00159f
C2435 c_6_11/QB c_6_12/QB 0
C2436 c_1_3/Q c_1_4/Q 0
C2437 c_6_9/WL c_7_15/Q 0
C2438 c_7_7/QB c_8_7/Q 0
C2439 c_7_3/QB c_7_4/Q 0.01135f
C2440 c_15_5/QB c_15_9/VDD 0.00969f
C2441 c_12_12/QB c_13_12/Q 0
C2442 c_9_0/BL c_13_9/VDD -0.01128f
C2443 c_2_10/Q c_3_10/QB 0
C2444 c_9_9/BL c_1_8/QB 0.00303f
C2445 c_13_9/WL c_12_8/Q 0
C2446 c_7_3/QB c_7_2/Q 0.00377f
C2447 c_12_12/Q c_9_13/BL 0
C2448 c_12_4/Q c_12_5/Q 0
C2449 c_8_8/QB c_8_9/Q 0.01135f
C2450 c_13_9/WL c_9_10/BLB 0.00159f
C2451 c_6_3/Q c_9_4/BL 0
C2452 c_6_9/Q c_7_9/WL 0
C2453 c_7_9/VDD c_7_4/QB 0.00969f
C2454 c_9_15/BL c_1_9/VDD -0.004f
C2455 c_14_9/WL c_13_9/Q 0
C2456 c_7_10/QB c_6_10/QB 0.01281f
C2457 c_5_9/WL c_5_1/QB 0
C2458 c_5_4/QB c_5_9/VDD 0.00969f
C2459 c_6_11/QB c_7_11/QB 0.01281f
C2460 c_14_9/WL c_9_8/BL 0.00159f
C2461 c_9_2/BL c_11_1/QB 0.00303f
C2462 c_9_12/BL c_5_9/VDD -0.004f
C2463 c_7_9/VDD c_6_11/QB 0.00969f
C2464 c_12_14/QB c_9_13/BLB 0
C2465 c_11_9/VDD c_9_6/BLB -0.004f
C2466 c_14_9/WL c_14_10/QB 0
C2467 c_11_9/WL c_10_11/Q 0
C2468 c_10_7/QB c_10_8/QB 0
C2469 c_9_4/BL c_4_9/WL 0.00159f
C2470 c_9_11/BL c_9_10/QB 0.00303f
C2471 c_9_4/Q c_9_5/BL 0
C2472 c_9_15/BL c_14_14/Q 0
C2473 c_13_6/Q c_12_9/WL 0
C2474 c_4_2/Q c_5_2/Q 0.00654f
C2475 c_9_11/BL c_5_10/Q 0
C2476 c_9_15/BL c_13_14/Q 0
C2477 c_5_9/Q c_4_9/WL 0
C2478 c_10_9/WL c_10_14/QB 0
C2479 c_4_2/Q c_4_3/Q 0
C2480 c_4_12/Q c_4_9/WL 0
C2481 c_10_9/WL c_11_4/Q 0
C2482 c_6_10/Q c_7_9/WL 0
C2483 c_4_6/QB c_3_9/WL 0
C2484 c_14_9/WL c_14_7/Q 0
C2485 c_9_3/BLB c_9_9/WL 0.00159f
C2486 c_8_9/WL c_8_12/Q 0
C2487 c_8_0/QB c_9_0/Q 0
C2488 c_1_0/QB c_2_0/QB 0.0025f
C2489 c_10_5/Q c_10_6/QB 0.00377f
C2490 c_1_9/Q c_0_9/QB 0
C2491 c_0_13/QB c_0_14/QB 0
C2492 c_1_6/Q c_2_6/QB 0
C2493 c_3_0/Q c_3_1/Q 0
C2494 c_3_9/VDD c_2_8/QB 0.00969f
C2495 c_15_5/QB c_15_4/QB 0
C2496 c_14_9/WL c_14_13/QB 0
C2497 c_1_12/Q c_9_11/BLB 0.00303f
C2498 c_15_14/QB c_14_14/Q 0
C2499 c_9_0/BLB c_11_1/Q 0.00303f
C2500 c_5_3/QB c_5_2/Q 0.00377f
C2501 c_9_7/Q c_8_9/WL 0
C2502 c_11_9/WL c_12_2/QB 0
C2503 c_12_0/QB c_12_9/WL 0
C2504 c_9_10/BL c_0_9/QB 0.00303f
C2505 c_2_9/WL c_3_8/QB 0
C2506 c_5_3/QB c_4_3/Q 0
C2507 c_15_7/Q c_9_6/BLB 0.00303f
C2508 c_9_15/BL c_8_14/Q 0
C2509 c_9_7/BLB c_9_7/BL -0
C2510 c_9_12/BL c_3_9/WL 0.00159f
C2511 c_3_9/VDD c_3_9/WL 0.04545f
C2512 c_5_9/WL c_4_2/Q 0
C2513 c_10_0/QB c_9_9/WL 0
C2514 c_6_7/Q c_6_8/Q 0
C2515 c_14_3/QB c_9_2/BLB 0
C2516 c_12_2/QB c_11_2/Q 0
C2517 c_1_15/Q c_9_14/BLB 0.00303f
C2518 c_2_4/QB c_3_9/WL 0
C2519 c_11_9/VDD c_9_11/BL -0.004f
C2520 c_8_9/WL c_8_5/QB 0
C2521 c_9_9/Q c_8_9/QB 0
C2522 c_9_9/QB c_8_9/Q 0
C2523 c_3_14/QB c_3_13/Q 0.00377f
C2524 c_6_9/WL c_7_9/Q 0
C2525 c_8_14/Q c_9_9/WL 0
C2526 c_9_8/BLB c_0_9/QB 0
C2527 c_9_1/BL c_7_0/QB 0.00303f
C2528 c_14_0/QB c_15_9/WL 0
C2529 c_12_2/Q c_11_2/QB 0
C2530 c_9_1/BL c_2_0/Q 0
C2531 c_10_1/Q c_11_9/VDD 0.00756f
C2532 c_14_2/Q c_9_3/BL 0
C2533 c_2_0/QB c_3_9/WL 0
C2534 c_5_9/WL c_5_3/QB 0
C2535 c_14_9/WL c_15_3/QB 0
C2536 c_13_9/WL c_12_15/QB 0
C2537 c_6_12/Q c_5_12/Q 0.00634f
C2538 c_6_7/Q c_6_9/WL 0
C2539 c_7_8/QB c_7_9/QB 0
C2540 c_13_9/VDD c_9_5/BLB -0.004f
C2541 c_9_15/BL c_1_14/QB 0.00303f
C2542 c_12_11/QB c_12_10/QB 0
C2543 c_15_8/Q c_14_8/QB 0
C2544 c_12_12/QB c_13_12/QB 0.01281f
C2545 c_9_1/BL c_9_9/VDD -0.004f
C2546 c_4_15/Q c_4_14/QB 0.01135f
C2547 c_6_9/QB c_7_9/Q 0
C2548 c_1_1/Q c_1_2/Q 0
C2549 c_5_9/WL c_6_0/QB 0
C2550 c_14_9/WL c_14_6/Q 0
C2551 c_11_14/QB c_11_9/VDD 0.00969f
C2552 c_9_7/Q c_9_8/BL 0
C2553 c_9_4/BL c_12_3/Q 0
C2554 c_8_15/Q c_9_9/WL 0
C2555 c_7_9/VDD c_9_4/BL -0.004f
C2556 c_12_0/Q c_11_0/Q 0.00634f
C2557 c_9_15/BL c_7_9/WL 0.00159f
C2558 c_0_9/WL c_9_13/BL 0.00122f
C2559 c_9_12/BL c_3_9/VDD -0.004f
C2560 c_9_10/BL c_1_9/QB 0.00303f
C2561 c_9_0/BL c_0_9/WL 0
C2562 c_5_3/QB c_9_2/BLB 0
C2563 c_3_9/VDD c_2_4/QB 0.00969f
C2564 c_1_10/Q c_0_10/Q 0.00654f
C2565 c_9_7/Q c_9_8/QB 0.00377f
C2566 c_9_5/QB c_9_6/BL 0.00303f
C2567 c_5_9/WL c_6_5/QB 0
C2568 c_11_9/VDD c_11_7/QB 0.00969f
C2569 c_11_3/QB c_12_3/Q 0
C2570 c_3_6/Q c_3_9/WL 0
C2571 c_4_8/Q c_4_9/WL 0
C2572 c_13_9/VDD c_9_6/BL -0.004f
C2573 c_8_2/Q c_7_9/WL 0
C2574 c_7_3/QB c_7_4/QB 0
C2575 c_14_4/QB c_14_5/Q 0.01135f
C2576 c_10_5/QB c_9_4/BLB 0
C2577 c_8_9/WL c_9_14/BLB 0.00159f
C2578 c_9_10/Q c_9_9/VDD 0.00756f
C2579 c_2_0/QB c_3_9/VDD 0.00777f
C2580 c_12_11/QB c_9_12/BL 0.00303f
C2581 c_8_4/Q c_9_9/VDD 0.00756f
C2582 c_9_8/BLB c_1_9/QB 0
C2583 c_3_6/QB c_4_9/WL 0
C2584 c_5_3/Q c_5_2/QB 0.01135f
C2585 c_10_2/QB c_11_2/QB 0.01281f
C2586 c_9_8/Q c_9_9/Q 0
C2587 c_0_15/QB c_1_9/WL 0
C2588 c_9_1/BL c_4_9/WL 0.00159f
C2589 c_4_6/QB c_3_6/Q 0
C2590 c_6_9/WL c_9_15/BLB 0
C2591 c_11_9/WL c_12_13/Q 0
C2592 c_9_9/BLB c_12_9/WL 0.00159f
C2593 c_9_11/BL c_14_10/Q 0
C2594 c_9_9/BLB c_1_9/WL 0.00159f
C2595 c_5_5/Q c_4_5/Q 0.00654f
C2596 c_3_13/Q c_3_12/Q 0
C2597 c_15_6/Q c_15_5/QB 0.01135f
C2598 c_14_12/Q c_14_11/QB 0.01135f
C2599 c_10_14/QB c_11_14/Q 0
C2600 c_7_6/QB c_9_7/BL 0.00303f
C2601 c_2_11/Q c_2_10/QB 0.01135f
C2602 c_13_9/WL c_9_15/BLB 0
C2603 c_8_0/QB c_7_9/WL 0
C2604 c_9_4/BL c_1_3/QB 0.00303f
C2605 c_3_9/VDD c_3_6/Q 0.00756f
C2606 c_11_9/WL c_12_10/Q 0
C2607 c_3_5/QB c_4_9/WL 0
C2608 c_12_15/Q c_13_15/QB 0
C2609 c_10_0/Q c_9_9/WL 0
C2610 c_15_9/Q c_15_9/WL 0
C2611 c_15_9/VDD c_14_8/Q 0.00756f
C2612 c_9_12/BL c_10_12/QB 0
C2613 c_3_4/QB c_9_5/BL 0.00303f
C2614 c_2_7/QB c_9_8/BL 0.00303f
C2615 c_9_15/BL c_4_14/QB 0.00303f
C2616 c_3_15/QB c_3_9/VDD 0.00479f
C2617 c_8_5/Q c_8_6/QB 0.00377f
C2618 c_3_3/Q c_3_9/WL 0
C2619 c_13_9/WL c_13_13/QB 0
C2620 c_4_15/QB c_5_9/VDD 0.00479f
C2621 c_9_12/BLB c_9_13/BL 2.55595f
C2622 c_9_15/BL c_14_9/WL 0.00159f
C2623 c_8_8/QB c_7_8/QB 0.0025f
C2624 c_9_7/BLB c_12_9/WL 0.00159f
C2625 c_0_3/QB c_0_4/Q 0.01135f
C2626 c_4_5/QB c_5_9/VDD 0.00969f
C2627 c_9_7/BLB c_1_9/WL 0.00159f
C2628 c_13_9/WL c_12_4/QB 0
C2629 c_14_2/Q c_13_2/QB 0
C2630 c_11_9/WL c_9_5/BL 0.00159f
C2631 c_13_1/Q c_14_1/QB 0
C2632 c_10_12/Q c_10_13/Q 0
C2633 c_11_9/WL c_9_0/BLB 0.00159f
C2634 c_12_13/Q c_13_13/QB 0
C2635 c_15_13/Q c_15_14/Q 0
C2636 c_1_7/QB c_0_7/QB 0.01281f
C2637 c_0_9/WL c_9_5/BLB 0.00122f
C2638 c_12_9/WL c_9_11/BLB 0.00159f
C2639 c_9_1/BLB c_5_2/QB 0
C2640 c_6_5/Q c_7_5/QB 0
C2641 c_9_11/BLB c_1_9/WL 0.00159f
C2642 c_9_5/BL c_8_4/QB 0.00303f
C2643 c_5_15/Q c_9_14/BLB 0.00303f
C2644 c_13_5/Q c_14_5/QB 0
C2645 c_9_15/Q c_10_15/Q 0.00634f
C2646 c_3_4/QB c_2_4/Q 0
C2647 c_15_14/QB c_14_9/WL 0
C2648 c_9_4/QB c_9_9/VDD 0.00969f
C2649 c_10_1/Q c_9_1/Q 0.00634f
C2650 c_2_12/Q c_2_9/WL 0
C2651 c_13_10/Q c_14_10/Q 0.00634f
C2652 c_11_14/QB c_10_14/Q 0
C2653 c_9_10/BL c_13_9/QB 0.00303f
C2654 c_8_9/WL c_9_2/BL 0.00159f
C2655 c_10_3/QB c_10_4/QB 0
C2656 c_0_1/Q c_0_0/QB 0.01135f
C2657 c_7_3/QB c_9_4/BL 0.00303f
C2658 c_11_5/Q c_9_6/BL 0
C2659 c_1_12/Q c_9_13/BL 0
C2660 c_2_3/QB c_3_9/WL 0
C2661 c_4_0/QB c_5_9/VDD 0.00777f
C2662 c_14_12/Q c_14_11/Q 0
C2663 c_13_7/QB c_9_6/BLB 0
C2664 c_2_2/Q c_1_2/Q 0.00634f
C2665 c_7_9/VDD c_9_1/BL -0.004f
C2666 c_11_0/Q c_10_0/QB 0
C2667 c_10_4/Q c_9_3/BLB 0.00303f
C2668 c_8_3/Q c_9_9/VDD 0.00756f
C2669 c_5_9/WL c_9_3/BLB 0.00159f
C2670 c_4_15/QB c_3_9/WL 0
C2671 c_15_15/Q c_15_9/VDD 0.00565f
C2672 c_3_3/Q c_3_9/VDD 0.00756f
C2673 c_9_11/Q c_10_11/QB 0
C2674 c_9_6/QB c_8_6/QB 0.01281f
C2675 c_4_5/QB c_3_9/WL 0
C2676 c_13_9/WL c_13_1/Q 0
C2677 c_9_13/Q c_10_13/QB 0
C2678 c_0_9/WL c_9_6/BL 0.00122f
C2679 c_14_8/Q c_15_8/QB 0
C2680 c_14_9/WL c_13_8/Q 0
C2681 c_13_9/QB c_9_8/BLB 0
C2682 c_9_15/BL c_6_14/QB 0.00303f
C2683 c_5_5/Q c_9_6/BL 0
C2684 c_13_9/VDD c_13_10/QB 0.00969f
C2685 c_14_3/QB c_15_3/Q 0
C2686 c_5_9/WL c_5_6/Q 0
C2687 c_15_9/VDD c_14_7/QB 0.00969f
C2688 c_5_4/Q c_5_5/QB 0.00377f
C2689 c_3_2/QB c_2_9/WL 0
C2690 c_1_9/VDD c_9_2/BLB -0.004f
C2691 c_4_6/QB c_4_5/QB 0
C2692 c_6_2/QB c_5_2/Q 0
C2693 c_7_9/VDD c_6_1/QB 0.00969f
C2694 c_15_13/QB c_15_9/VDD 0.00969f
C2695 c_9_4/BLB c_4_5/Q 0.00303f
C2696 c_9_7/Q c_9_6/Q 0
C2697 c_12_4/QB c_9_5/BL 0.00303f
C2698 c_1_9/VDD c_0_7/QB 0.00969f
C2699 c_10_9/WL c_11_1/QB 0
C2700 c_12_2/QB c_12_1/Q 0.00377f
C2701 c_13_1/QB c_12_9/WL 0
C2702 c_0_1/Q c_1_1/QB 0
C2703 c_9_3/BL c_2_9/WL 0.00159f
C2704 c_4_12/QB c_5_12/Q 0
C2705 c_0_9/WL c_0_3/QB 0
C2706 c_1_9/QB c_1_8/Q 0.00377f
C2707 c_1_12/QB c_2_12/QB 0.0025f
C2708 c_4_0/QB c_3_9/WL 0
C2709 c_8_13/Q c_8_12/QB 0.01135f
C2710 c_4_15/Q c_9_14/BLB 0.00303f
C2711 c_13_2/Q c_13_3/QB 0.00377f
C2712 c_3_9/VDD c_2_3/QB 0.00969f
C2713 c_7_14/Q c_6_14/Q 0.00654f
C2714 c_9_5/QB c_9_9/VDD 0.00969f
C2715 c_8_12/Q c_9_9/WL 0
C2716 c_8_1/Q c_9_0/BLB 0.00303f
C2717 c_1_13/Q c_1_12/QB 0.01135f
C2718 c_1_5/Q c_2_5/Q 0.00634f
C2719 c_13_9/WL c_12_5/Q 0
C2720 c_11_9/Q c_12_9/QB 0
C2721 c_2_3/QB c_2_4/QB 0
C2722 c_11_9/WL c_10_10/Q 0
C2723 c_11_9/WL c_10_12/Q 0
C2724 c_11_3/Q c_12_3/Q 0.00634f
C2725 c_5_9/WL c_6_2/QB 0
C2726 c_5_11/QB c_9_10/BLB 0
C2727 c_15_1/Q c_15_0/Q 0
C2728 c_12_0/QB c_11_9/WL 0
C2729 c_9_7/Q c_9_9/WL 0
C2730 c_9_1/BLB c_12_2/Q 0.00303f
C2731 c_9_14/QB c_9_13/QB 0
C2732 c_9_12/BL c_15_9/VDD -0.004f
C2733 c_3_4/Q c_4_4/Q 0.00634f
C2734 c_8_9/WL c_8_6/Q 0
C2735 c_0_8/QB c_0_9/QB 0
C2736 c_9_0/BLB c_13_1/Q 0.00303f
C2737 c_11_9/VDD c_9_3/BLB -0.004f
C2738 c_9_4/Q c_9_3/QB 0.01135f
C2739 c_0_5/Q c_9_6/BL 0
C2740 c_3_0/Q c_4_0/Q 0.00634f
C2741 c_0_11/Q c_0_10/QB 0.01135f
C2742 c_0_11/QB c_0_10/Q 0.00377f
C2743 c_9_6/BL c_14_5/Q 0
C2744 c_9_7/BLB c_12_8/Q 0.00303f
C2745 c_1_7/Q c_9_8/BL 0
C2746 c_2_11/Q c_2_9/WL 0
C2747 c_10_10/QB c_9_9/BLB 0
C2748 c_11_7/QB c_11_6/Q 0.00377f
C2749 c_9_9/WL c_8_5/QB 0
C2750 c_4_10/Q c_4_9/Q 0
C2751 c_1_3/Q c_9_2/BLB 0.00303f
C2752 c_14_9/WL c_15_1/Q 0
C2753 c_14_0/Q c_13_0/QB 0
C2754 c_14_0/QB c_13_0/Q 0
C2755 c_1_3/QB c_2_9/WL 0
C2756 c_5_13/Q c_4_9/WL 0
C2757 c_8_9/WL c_7_0/Q 0
C2758 c_6_5/Q c_6_4/QB 0.01135f
C2759 c_2_3/Q c_2_4/Q 0
C2760 c_3_7/Q c_3_6/QB 0.01135f
C2761 c_10_9/WL c_11_15/Q 0
C2762 c_14_9/WL c_13_3/QB 0
C2763 c_12_1/QB c_12_9/WL 0
C2764 c_6_13/QB c_7_13/Q 0
C2765 c_9_14/BL c_15_9/WL 0.00122f
C2766 c_11_9/VDD c_10_0/QB 0.00777f
C2767 c_13_3/Q c_12_3/Q 0.00654f
C2768 c_8_13/QB c_9_13/Q 0
C2769 c_1_9/Q c_1_9/VDD 0.00756f
C2770 c_9_15/BL c_12_14/QB 0.00303f
C2771 c_10_0/QB c_9_0/QB 0.0025f
C2772 c_12_2/Q c_12_9/WL 0
C2773 c_9_1/QB c_9_2/BL 0.00303f
C2774 c_13_9/WL c_12_1/Q 0
C2775 c_6_1/QB c_7_1/Q 0
C2776 c_8_13/Q c_7_13/QB 0
C2777 c_4_7/Q c_4_8/QB 0.00377f
C2778 c_12_7/Q c_12_8/QB 0.00377f
C2779 c_11_0/Q c_10_0/Q 0.00654f
C2780 c_11_0/QB c_10_9/WL 0
C2781 c_9_10/BL c_1_9/VDD -0.004f
C2782 c_8_13/QB c_7_13/Q 0
C2783 c_2_5/Q c_2_6/QB 0.00377f
C2784 c_9_2/BLB c_7_9/WL 0.00159f
C2785 c_7_7/QB c_8_7/QB 0.0025f
C2786 c_9_15/BL c_9_14/BLB 2.55595f
C2787 c_11_8/Q c_12_8/QB 0
C2788 c_3_15/QB c_4_15/QB 0.0025f
C2789 c_0_15/Q c_0_14/Q 0
C2790 c_9_1/BLB c_10_2/QB 0
C2791 c_9_15/Q c_9_9/VDD 0.00565f
C2792 c_12_6/QB c_11_6/QB 0.0025f
C2793 c_13_9/VDD c_12_7/Q 0.00756f
C2794 c_3_7/Q c_2_9/WL 0
C2795 c_1_9/VDD c_9_8/BLB -0.004f
C2796 c_5_9/WL c_4_7/Q 0
C2797 c_9_9/WL c_9_14/BLB 0.00159f
C2798 c_5_0/Q c_4_0/Q 0.00654f
C2799 c_10_4/QB c_10_9/WL 0
C2800 c_7_3/Q c_9_2/BLB 0.00303f
C2801 c_6_7/Q c_7_7/QB 0
C2802 c_9_1/BL c_15_0/QB 0.00303f
C2803 c_9_6/BL c_12_5/QB 0.00303f
C2804 c_10_9/WL c_9_13/BLB 0.00159f
C2805 c_9_1/Q c_9_2/Q 0
C2806 c_9_13/BL c_12_9/WL 0.00159f
C2807 c_3_10/Q c_3_9/WL 0
C2808 c_9_1/BL c_1_0/Q 0
C2809 c_9_13/BL c_1_9/WL 0.00159f
C2810 c_11_9/WL c_9_9/BLB 0.00159f
C2811 c_8_13/QB c_9_9/VDD 0.00969f
C2812 c_15_2/QB c_9_3/BL 0.00303f
C2813 c_11_9/Q c_10_9/Q 0.00654f
C2814 c_9_0/BL c_12_9/WL 0
C2815 c_8_9/WL c_7_10/QB 0
C2816 c_0_9/WL c_0_15/Q 0
C2817 c_9_0/BL c_1_9/WL 0
C2818 c_14_9/QB c_13_9/QB 0.0025f
C2819 c_14_4/Q c_14_3/Q 0
C2820 c_13_4/Q c_13_3/QB 0.01135f
C2821 c_1_10/QB c_1_11/QB 0
C2822 c_3_3/Q c_2_3/QB 0
C2823 c_5_9/WL c_4_14/QB 0
C2824 c_0_3/QB c_0_2/QB 0
C2825 c_9_11/BL c_2_10/QB 0.00303f
C2826 c_8_10/Q c_9_9/VDD 0.00756f
C2827 c_9_1/Q c_9_0/Q 0
C2828 c_13_9/VDD c_12_3/Q 0.00756f
C2829 c_13_9/VDD c_9_3/BL -0.004f
C2830 c_9_0/BLB c_12_1/Q 0.00303f
C2831 c_3_5/Q c_4_5/Q 0.00634f
C2832 c_7_1/QB c_7_2/QB 0
C2833 c_12_9/QB c_11_9/QB 0.0025f
C2834 c_6_13/QB c_5_13/QB 0.0025f
C2835 c_14_9/WL c_13_5/Q 0
C2836 c_6_9/WL c_6_8/QB 0
C2837 c_15_10/QB c_15_11/QB 0
C2838 c_14_2/Q c_14_3/QB 0.00377f
C2839 c_13_14/QB c_13_9/VDD 0.00969f
C2840 c_9_3/BLB c_7_4/Q 0.00303f
C2841 c_15_10/Q c_15_9/VDD 0.00756f
C2842 c_9_12/BLB c_9_13/Q 0.00303f
C2843 c_10_9/WL c_10_6/Q 0
C2844 c_2_9/WL c_1_0/Q 0
C2845 c_9_11/Q c_9_10/Q 0
C2846 c_10_5/QB c_9_5/Q 0
C2847 c_10_5/Q c_9_5/QB 0
C2848 c_15_7/QB c_15_8/Q 0.01135f
C2849 c_7_2/QB c_8_2/QB 0.0025f
C2850 c_11_1/Q c_12_1/QB 0
C2851 c_7_9/VDD c_6_3/QB 0.00969f
C2852 c_14_9/WL c_9_2/BLB 0.00159f
C2853 c_9_12/BLB c_7_13/Q 0.00303f
C2854 c_3_10/Q c_3_9/VDD 0.00756f
C2855 c_13_9/WL c_14_8/Q 0
C2856 c_11_9/Q c_11_10/Q 0
C2857 c_7_9/Q c_8_9/Q 0.00634f
C2858 c_11_9/WL c_9_7/BLB 0.00159f
C2859 c_4_13/Q c_4_14/Q 0
C2860 c_8_8/QB c_9_9/VDD 0.00969f
C2861 c_6_8/QB c_6_9/QB 0
C2862 c_9_10/BL c_7_9/WL 0.00159f
C2863 c_9_4/BL c_14_3/QB 0.00303f
C2864 c_5_5/Q c_4_9/WL 0
C2865 c_9_7/BLB c_2_8/Q 0.00303f
C2866 c_10_4/QB c_11_4/QB 0.01281f
C2867 c_1_7/QB c_1_8/Q 0.01135f
C2868 c_10_11/Q c_9_12/BL 0
C2869 c_2_12/Q c_2_11/QB 0.01135f
C2870 c_11_9/VDD c_10_0/Q 0.00266f
C2871 c_13_3/Q c_13_2/QB 0.01135f
C2872 c_11_15/Q c_11_14/Q 0
C2873 c_11_9/WL c_9_11/BLB 0.00159f
C2874 c_10_0/Q c_9_0/QB 0
C2875 c_5_9/WL c_6_14/QB 0
C2876 c_2_13/Q c_3_9/WL 0
C2877 c_4_9/WL c_4_9/Q 0
C2878 c_9_1/BL c_0_0/QB 0.00303f
C2879 c_6_9/WL c_7_10/Q 0
C2880 c_10_15/QB c_9_15/Q 0
C2881 c_9_8/BLB c_7_9/WL 0.00159f
C2882 c_8_1/QB c_9_9/VDD 0.00969f
C2883 c_13_11/QB c_9_12/BL 0.00303f
C2884 c_9_2/BL c_9_9/WL 0.00159f
C2885 c_5_14/QB c_6_9/WL 0
C2886 c_13_9/VDD c_13_11/Q 0.00756f
C2887 c_6_8/QB c_5_8/Q 0
C2888 c_7_9/VDD c_7_9/QB 0.00969f
C2889 c_9_12/BLB c_9_9/VDD -0.004f
C2890 c_8_9/WL c_9_9/BL 0.00159f
C2891 c_7_3/QB c_8_3/Q 0
C2892 c_5_14/Q c_5_9/VDD 0.00756f
C2893 c_13_4/Q c_13_5/Q 0
C2894 c_9_4/BLB c_7_5/Q 0.00303f
C2895 c_6_13/Q c_7_9/WL 0
C2896 c_4_7/QB c_3_7/QB 0.0025f
C2897 c_4_13/QB c_5_13/QB 0.01281f
C2898 c_6_2/QB c_7_2/Q 0
C2899 c_9_5/BLB c_12_9/WL 0.00159f
C2900 c_7_9/VDD c_6_15/Q 0.00565f
C2901 c_1_9/VDD c_0_14/QB 0.00969f
C2902 c_13_9/WL c_12_13/QB 0
C2903 c_9_5/BLB c_1_9/WL 0.00159f
C2904 c_6_13/QB c_6_12/QB 0
C2905 c_5_8/QB c_6_8/QB 0.0025f
C2906 c_4_13/QB c_4_9/WL 0
C2907 c_9_15/QB c_10_15/Q 0
C2908 c_15_1/Q c_14_1/Q 0.00654f
C2909 c_11_10/QB c_12_10/Q 0
C2910 c_7_14/Q c_9_13/BLB 0.00303f
C2911 c_2_14/QB c_2_13/QB 0
C2912 c_12_11/QB c_13_11/QB 0.01281f
C2913 c_9_4/BL c_5_3/QB 0.00303f
C2914 c_6_3/Q c_6_4/Q 0
C2915 c_15_12/QB c_15_9/WL 0
C2916 c_9_13/BLB c_11_14/Q 0.00303f
C2917 c_1_9/VDD c_1_8/Q 0.00756f
C2918 c_9_7/QB c_9_8/Q 0.01135f
C2919 c_3_9/VDD c_2_13/Q 0.00756f
C2920 c_6_9/WL c_5_9/QB 0
C2921 c_7_9/VDD c_6_13/QB 0.00969f
C2922 c_3_5/Q c_9_6/BL 0
C2923 c_6_7/QB c_9_8/BL 0.00303f
C2924 c_13_9/WL c_14_7/QB 0
C2925 c_9_9/QB c_9_9/VDD 0.00969f
C2926 c_0_12/QB c_0_11/QB 0
C2927 c_5_8/Q c_5_9/VDD 0.00756f
C2928 c_12_0/QB c_12_1/Q 0.01135f
C2929 c_7_4/Q c_7_9/WL 0
C2930 c_2_9/WL c_9_6/BLB 0.00159f
C2931 c_9_4/BLB c_9_9/VDD -0.004f
C2932 c_1_4/QB c_2_9/WL 0
C2933 c_5_2/Q c_5_1/Q 0
C2934 c_9_6/Q c_8_6/Q 0.00654f
C2935 c_9_6/BLB c_0_7/Q 0.00303f
C2936 c_6_9/WL c_6_1/Q 0
C2937 c_9_12/BLB c_5_13/QB 0
C2938 c_7_2/Q c_7_9/WL 0
C2939 c_2_7/Q c_2_6/Q 0
C2940 c_13_9/WL c_12_10/QB 0
C2941 c_9_6/BL c_12_9/WL 0.00159f
C2942 c_8_7/Q c_9_9/VDD 0.00756f
C2943 c_15_7/Q c_14_9/WL 0
C2944 c_9_6/BL c_1_9/WL 0.00159f
C2945 c_0_1/Q c_1_9/VDD 0.00756f
C2946 c_10_11/Q c_10_12/QB 0.00377f
C2947 c_10_9/Q c_11_9/QB 0
C2948 c_9_14/Q c_9_15/Q 0
C2949 c_9_12/BLB c_4_9/WL 0.00159f
C2950 c_10_9/WL c_9_8/BL 0.00159f
C2951 c_4_9/WL c_5_11/Q 0
C2952 c_4_6/Q c_5_9/VDD 0.00756f
C2953 c_5_8/QB c_5_9/VDD 0.00969f
C2954 c_0_9/WL c_9_3/BL 0.00122f
C2955 c_14_9/WL c_9_10/BL 0.00159f
C2956 c_12_7/Q c_13_7/Q 0.00654f
C2957 c_13_2/QB c_13_9/VDD 0.00969f
C2958 c_11_5/Q c_10_5/Q 0.00654f
C2959 c_9_5/BL c_5_9/VDD -0.004f
C2960 c_11_5/QB c_10_9/WL 0
C2961 c_7_7/Q c_8_7/Q 0.00634f
C2962 c_5_9/QB c_6_9/QB 0.0025f
C2963 c_11_9/WL c_10_5/QB 0
C2964 c_9_0/BLB c_5_9/VDD -0.004f
C2965 c_4_4/QB c_5_4/Q 0
C2966 c_7_3/Q c_7_4/Q 0
C2967 c_8_9/WL c_8_11/QB 0
C2968 c_0_9/WL c_0_4/QB 0
C2969 c_8_9/WL c_8_3/QB 0
C2970 c_15_9/VDD c_15_1/QB 0.00969f
C2971 c_9_8/QB c_10_9/WL 0
C2972 c_1_1/QB c_2_9/WL 0
C2973 c_6_9/WL c_5_4/QB 0
C2974 c_15_4/QB c_15_9/VDD 0.00969f
C2975 c_9_3/BL c_11_2/QB 0.00303f
C2976 c_7_3/Q c_7_2/Q 0
C2977 c_9_7/BL c_9_9/VDD -0.004f
C2978 c_1_6/QB c_2_9/WL 0
C2979 c_7_4/QB c_9_3/BLB 0
C2980 c_6_9/WL c_9_12/BL 0.00159f
C2981 c_12_14/Q c_9_13/BLB 0.00303f
C2982 c_7_10/Q c_8_10/QB 0
C2983 c_0_3/QB c_1_9/WL 0
C2984 c_7_1/QB c_8_9/WL 0
C2985 c_9_8/QB c_9_9/BL 0.00303f
C2986 c_7_10/QB c_6_10/Q 0
C2987 c_5_9/WL c_5_1/Q 0
C2988 c_7_3/QB c_6_3/QB 0.01281f
C2989 c_6_11/QB c_7_11/Q 0
C2990 c_14_9/WL c_9_8/BLB 0.00159f
C2991 c_12_7/QB c_9_8/BL 0.00303f
C2992 c_15_9/VDD c_15_8/QB 0.00969f
C2993 c_11_9/WL c_10_8/QB 0
C2994 c_8_6/Q c_9_9/WL 0
C2995 c_14_9/WL c_14_10/Q 0
C2996 c_4_2/QB c_5_9/VDD 0.00969f
C2997 c_10_7/Q c_10_8/QB 0.00377f
C2998 c_9_4/BLB c_4_9/WL 0.00159f
C2999 c_2_9/WL c_1_9/QB 0
C3000 c_13_9/WL c_9_12/BL 0.00159f
C3001 c_9_11/BL c_9_10/Q 0
C3002 c_9_11/QB c_9_10/BLB 0
C3003 c_10_3/QB c_9_9/WL 0
C3004 c_9_11/BL c_2_9/WL 0.00159f
C3005 c_5_9/QB c_5_8/Q 0.00377f
C3006 c_8_9/WL c_8_2/QB 0
C3007 c_1_13/QB c_2_9/WL 0
C3008 c_0_14/QB c_1_14/QB 0.01281f
C3009 c_8_15/QB c_9_15/Q 0
C3010 c_11_10/Q c_11_9/QB 0.01135f
C3011 c_4_6/Q c_3_9/WL 0
C3012 c_10_9/WL c_11_11/Q 0
C3013 c_5_9/WL c_9_14/BLB 0.00159f
C3014 c_6_1/QB c_5_1/QB 0.0025f
C3015 c_1_5/QB c_2_9/WL 0
C3016 c_1_9/Q c_0_9/Q 0.00654f
C3017 c_0_13/Q c_0_14/QB 0.00377f
C3018 c_0_13/QB c_0_14/Q 0.01135f
C3019 c_9_5/BL c_3_9/WL 0.00159f
C3020 c_1_6/Q c_2_6/Q 0.00634f
C3021 c_13_3/Q c_13_4/QB 0.00377f
C3022 c_9_0/BLB c_3_9/WL 0.00159f
C3023 c_5_8/QB c_5_9/QB 0
C3024 c_11_9/WL c_12_1/QB 0
C3025 c_8_14/QB c_9_13/BLB 0
C3026 c_15_1/Q c_9_2/BL 0
C3027 c_8_9/WL c_7_14/Q 0
C3028 c_0_9/WL c_1_3/QB 0
C3029 c_12_11/QB c_13_9/WL 0
C3030 c_9_10/BL c_0_9/Q 0
C3031 c_2_14/QB c_3_9/WL 0
C3032 c_9_7/BL c_4_9/WL 0.00159f
C3033 c_11_9/WL c_12_2/Q 0
C3034 c_9_1/QB c_10_9/WL 0
C3035 c_3_14/QB c_3_9/WL 0
C3036 c_2_12/Q c_1_12/Q 0.00634f
C3037 c_6_3/Q c_5_3/Q 0.00634f
C3038 c_13_14/QB c_13_13/Q 0.00377f
C3039 c_2_12/QB c_3_12/QB 0.01281f
C3040 c_11_7/Q c_10_9/WL 0
C3041 c_4_10/QB c_5_9/VDD 0.00969f
C3042 c_6_1/Q c_9_0/BLB 0.00303f
C3043 c_7_9/VDD c_6_4/Q 0.00756f
C3044 c_14_6/QB c_15_9/WL 0
C3045 c_4_2/QB c_3_9/WL 0
C3046 c_7_8/Q c_7_9/WL 0
C3047 c_12_2/Q c_11_2/Q 0.00634f
C3048 c_11_5/QB c_11_4/QB 0
C3049 c_0_8/QB c_1_9/VDD 0.00969f
C3050 c_11_13/Q c_10_9/WL 0
C3051 c_5_3/Q c_4_9/WL 0
C3052 c_2_4/Q c_3_9/WL 0
C3053 c_8_9/WL c_8_5/Q 0
C3054 c_11_10/QB c_10_10/Q 0
C3055 c_9_9/Q c_8_9/Q 0.00654f
C3056 c_0_5/Q c_0_4/QB 0.01135f
C3057 c_8_0/QB c_7_0/Q 0
C3058 c_7_9/VDD c_9_12/BLB -0.004f
C3059 c_9_8/BLB c_0_9/Q 0.00303f
C3060 c_0_13/QB c_0_9/WL 0
C3061 c_14_0/Q c_15_9/WL 0
C3062 c_10_6/Q c_9_6/QB 0
C3063 c_13_6/QB c_13_9/WL 0
C3064 c_1_15/Q c_2_15/QB 0
C3065 c_6_14/QB c_6_13/Q 0.00377f
C3066 c_6_5/Q c_9_6/BL 0
C3067 c_5_4/QB c_9_5/BL 0.00303f
C3068 c_14_9/WL c_15_3/Q 0
C3069 c_13_9/WL c_12_15/Q 0
C3070 c_3_9/VDD c_9_5/BL -0.004f
C3071 c_14_2/QB c_15_9/WL 0
C3072 c_11_7/Q c_12_7/QB 0
C3073 c_9_0/BLB c_3_9/VDD -0.004f
C3074 c_7_8/QB c_7_9/Q 0.01135f
C3075 c_15_15/QB c_14_15/Q 0
C3076 c_12_11/QB c_12_10/Q 0.00377f
C3077 c_1_11/Q c_2_11/Q 0.00634f
C3078 c_9_1/BLB c_9_9/VDD -0.004f
C3079 c_9_5/BL c_2_4/QB 0.00303f
C3080 c_9_1/BL c_6_0/QB 0.00303f
C3081 c_7_4/QB c_7_9/WL 0
C3082 c_3_9/VDD c_2_14/QB 0.00969f
C3083 c_11_9/WL c_9_13/BL 0.00159f
C3084 c_9_4/BL c_1_9/VDD -0.004f
C3085 c_13_10/QB c_12_9/WL 0
C3086 c_3_14/QB c_3_9/VDD 0.00969f
C3087 c_5_9/WL c_6_0/Q 0
C3088 c_7_9/VDD c_7_15/QB 0.00479f
C3089 c_6_11/QB c_7_9/WL 0
C3090 c_11_9/WL c_9_0/BL 0
C3091 c_4_10/QB c_3_9/WL 0
C3092 c_9_4/BL c_9_3/BLB 2.55595f
C3093 c_9_15/QB c_9_9/VDD 0.00479f
C3094 c_13_9/Q c_13_8/QB 0.01135f
C3095 c_7_9/VDD c_9_4/BLB -0.004f
C3096 c_11_9/VDD c_9_14/BLB -0.004f
C3097 c_15_6/Q c_15_9/VDD 0.00756f
C3098 c_10_9/WL c_11_6/QB 0
C3099 c_11_9/WL c_10_2/QB 0
C3100 c_13_9/VDD c_13_4/QB 0.00969f
C3101 c_3_9/VDD c_2_4/Q 0.00756f
C3102 c_9_5/Q c_9_6/BL 0
C3103 c_2_0/Q c_1_9/WL 0
C3104 c_8_9/WL c_9_6/QB 0
C3105 c_13_9/VDD c_9_6/BLB -0.004f
C3106 c_7_3/Q c_7_4/QB 0.00377f
C3107 c_14_4/Q c_14_5/Q 0
C3108 c_10_5/Q c_9_4/BLB 0.00303f
C3109 c_10_1/QB c_10_2/Q 0.01135f
C3110 c_9_3/BL c_0_2/QB 0.00303f
C3111 c_6_1/QB c_6_0/QB 0
C3112 c_12_12/QB c_11_12/QB 0.0025f
C3113 c_2_9/WL c_2_2/QB 0
C3114 c_10_2/QB c_11_2/Q 0
C3115 c_3_12/Q c_3_9/WL 0
C3116 c_5_9/WL c_9_2/BL 0.00159f
C3117 c_8_9/WL c_8_14/QB 0
C3118 c_12_0/Q c_9_1/BL 0
C3119 c_5_15/QB c_5_9/VDD 0.00479f
C3120 c_3_15/Q c_3_9/WL 0
C3121 c_10_1/QB c_11_1/Q 0
C3122 c_7_9/VDD c_9_7/BL -0.004f
C3123 c_13_3/Q c_14_3/QB 0
C3124 c_9_6/Q c_10_9/WL 0
C3125 c_0_15/Q c_1_9/WL 0
C3126 c_9_1/BLB c_4_9/WL 0.00159f
C3127 c_4_6/Q c_3_6/Q 0.00634f
C3128 c_5_7/Q c_9_8/BL 0
C3129 c_13_1/Q c_12_1/QB 0
C3130 c_7_6/Q c_9_7/BL 0
C3131 c_0_9/WL c_1_0/Q 0
C3132 c_8_1/QB c_7_1/Q 0
C3133 c_8_0/Q c_9_9/WL 0
C3134 c_0_13/QB c_9_12/BLB 0
C3135 c_5_14/QB c_5_15/QB 0
C3136 c_13_7/QB c_14_9/WL 0
C3137 c_11_12/QB c_11_11/Q 0.00377f
C3138 c_2_11/Q c_2_10/Q 0
C3139 c_15_7/QB c_9_6/BLB 0
C3140 c_11_9/VDD c_11_15/QB 0.00479f
C3141 c_9_2/BL c_9_2/BLB -0
C3142 c_9_15/BL c_10_9/WL 0.00159f
C3143 c_9_4/BL c_1_3/Q 0
C3144 c_9_11/BL c_15_10/QB 0.00303f
C3145 c_9_1/BLB c_9_2/QB 0
C3146 c_1_4/QB c_0_4/Q 0
C3147 c_0_8/Q c_9_7/BLB 0.00303f
C3148 c_14_12/QB c_13_12/Q 0
C3149 c_14_9/QB c_14_9/WL 0
C3150 c_13_9/VDD c_9_11/BL -0.004f
C3151 c_3_5/Q c_4_9/WL 0
C3152 c_14_1/QB c_15_9/VDD 0.00969f
C3153 c_11_10/QB c_9_9/BLB 0
C3154 c_7_15/QB c_8_15/QB 0.0025f
C3155 c_12_9/QB c_13_9/QB 0.01281f
C3156 c_10_9/WL c_9_9/WL 0.8704f
C3157 c_3_14/QB c_3_15/QB 0
C3158 c_3_9/VDD c_3_12/Q 0.00756f
C3159 c_4_14/Q c_5_9/VDD 0.00756f
C3160 c_2_7/Q c_9_8/BL 0
C3161 c_0_6/QB c_9_5/BLB 0
C3162 c_3_15/Q c_3_9/VDD 0.00565f
C3163 c_13_1/QB c_12_1/Q 0
C3164 c_9_9/BL c_9_9/WL 0.00159f
C3165 c_4_4/QB c_4_3/QB 0
C3166 c_9_9/BLB c_5_9/VDD -0.004f
C3167 c_11_13/Q c_11_12/QB 0.01135f
C3168 c_11_13/Q c_11_14/Q 0
C3169 c_9_1/BL c_9_0/Q 0
C3170 c_13_9/WL c_12_4/Q 0
C3171 c_11_9/WL c_9_5/BLB 0.00159f
C3172 c_9_4/BL c_7_9/WL 0.00159f
C3173 c_14_2/Q c_13_2/Q 0.00634f
C3174 c_7_10/Q c_9_9/BLB 0.00303f
C3175 c_5_14/QB c_4_14/Q 0
C3176 c_1_7/QB c_2_9/WL 0
C3177 c_14_12/QB c_14_9/WL 0
C3178 c_6_8/QB c_9_7/BLB 0
C3179 c_9_15/QB c_10_15/QB 0.0025f
C3180 c_1_7/Q c_0_7/QB 0
C3181 c_1_7/QB c_0_7/Q 0
C3182 c_11_9/VDD c_9_2/BL -0.004f
C3183 c_6_5/Q c_7_5/Q 0.00654f
C3184 c_13_9/VDD c_13_15/Q 0.00565f
C3185 c_9_7/BLB c_14_8/Q 0.00303f
C3186 c_9_4/Q c_9_9/VDD 0.00756f
C3187 c_5_11/QB c_5_9/VDD 0.00969f
C3188 c_14_1/QB c_15_1/QB 0.01281f
C3189 c_3_2/QB c_9_1/BLB 0
C3190 c_14_11/QB c_15_11/QB 0.01281f
C3191 c_9_9/BL c_13_8/Q 0
C3192 c_10_3/Q c_10_4/QB 0.00377f
C3193 c_10_3/QB c_10_4/Q 0.01135f
C3194 c_9_1/BL c_1_9/VDD -0.004f
C3195 c_2_12/Q c_1_9/WL 0
C3196 c_7_3/Q c_9_4/BL 0
C3197 c_0_9/WL c_0_0/QB 0
C3198 c_0_1/Q c_0_0/Q 0
C3199 c_0_9/WL c_0_9/QB 0
C3200 c_4_14/Q c_3_9/WL 0
C3201 c_12_7/Q c_12_9/WL 0
C3202 c_11_9/WL c_9_6/BL 0.00159f
C3203 c_2_9/QB c_3_9/QB 0.01281f
C3204 c_7_9/VDD c_9_1/BLB -0.004f
C3205 c_9_14/BL c_9_13/BLB 2.55595f
C3206 c_4_1/Q c_5_9/VDD 0.00756f
C3207 c_10_7/QB c_9_6/BLB 0
C3208 c_11_10/Q c_9_11/BL 0
C3209 c_11_9/WL c_10_15/Q 0
C3210 c_9_9/BLB c_3_9/WL 0.00159f
C3211 c_4_7/QB c_4_9/WL 0
C3212 c_11_8/Q c_12_9/WL 0
C3213 c_5_9/WL c_5_12/QB 0
C3214 c_11_9/Q c_12_9/WL 0
C3215 c_7_15/QB c_7_14/QB 0
C3216 c_0_9/WL c_9_6/BLB 0.00122f
C3217 c_9_13/Q c_10_13/Q 0.00634f
C3218 c_0_9/WL c_1_4/QB 0
C3219 c_9_9/BLB c_12_10/QB 0
C3220 c_9_7/BLB c_5_9/VDD -0.004f
C3221 c_3_14/Q c_4_14/QB 0
C3222 c_13_9/VDD c_13_10/Q 0.00756f
C3223 c_8_11/QB c_9_9/WL 0
C3224 c_15_6/QB c_9_5/BLB 0
C3225 c_8_2/Q c_8_3/QB 0.00377f
C3226 c_8_3/QB c_9_9/WL 0
C3227 c_10_3/QB c_9_2/BLB 0
C3228 c_3_5/QB c_2_5/QB 0.01281f
C3229 c_14_2/Q c_14_9/WL 0
C3230 c_3_10/QB c_3_9/WL 0
C3231 c_9_11/BLB c_5_9/VDD -0.004f
C3232 c_9_1/BL c_10_0/QB 0.00303f
C3233 c_2_9/WL c_2_5/QB 0
C3234 c_4_6/Q c_4_5/QB 0.01135f
C3235 c_15_13/Q c_15_9/VDD 0.00756f
C3236 c_1_9/VDD c_0_7/Q 0.00756f
C3237 c_12_4/Q c_9_5/BL 0
C3238 c_14_12/QB c_13_12/QB 0.0025f
C3239 c_12_2/Q c_12_1/Q 0
C3240 c_9_9/VDD c_9_10/BLB -0.004f
C3241 c_9_3/BLB c_2_9/WL 0.00159f
C3242 c_9_14/Q c_9_15/QB 0.00377f
C3243 c_0_9/WL c_1_1/QB 0
C3244 c_0_1/Q c_1_1/Q 0.00654f
C3245 c_9_7/BLB c_2_8/QB 0
C3246 c_9_3/BLB c_8_4/Q 0.00303f
C3247 c_14_11/QB c_13_11/Q 0
C3248 c_9_3/BL c_12_9/WL 0.00159f
C3249 c_12_9/WL c_12_3/Q 0
C3250 c_1_6/QB c_0_9/WL 0
C3251 c_9_3/BL c_1_9/WL 0.00159f
C3252 c_13_9/VDD c_13_9/QB 0.00969f
C3253 c_8_2/QB c_9_9/WL 0
C3254 c_4_1/Q c_3_9/WL 0
C3255 c_13_14/QB c_12_9/WL 0
C3256 c_9_15/BL c_7_14/Q 0
C3257 c_9_5/Q c_9_9/VDD 0.00756f
C3258 c_15_9/VDD c_9_5/BL -0.004f
C3259 c_9_4/BL c_14_9/WL 0.00159f
C3260 c_0_4/QB c_1_9/WL 0
C3261 c_9_6/BLB c_13_7/Q 0.00303f
C3262 c_2_3/QB c_2_4/Q 0.01135f
C3263 c_9_7/BLB c_3_9/WL 0.00159f
C3264 c_3_9/VDD c_9_9/BLB -0.004f
C3265 c_9_0/BLB c_15_9/VDD -0.004f
C3266 c_11_9/Q c_12_9/Q 0.00634f
C3267 c_0_9/WL c_1_9/QB 0
C3268 c_11_9/WL c_10_1/QB 0
C3269 c_5_3/QB c_6_3/QB 0.0025f
C3270 c_9_15/BL c_11_14/Q 0
C3271 c_0_9/WL c_9_11/BL 0.00122f
C3272 c_14_9/WL c_14_8/QB 0
C3273 c_1_13/QB c_0_9/WL 0
C3274 c_10_2/Q c_9_2/QB 0
C3275 c_4_9/WL c_3_13/Q 0
C3276 c_5_2/QB c_5_9/VDD 0.00969f
C3277 c_14_11/Q c_15_11/QB 0
C3278 c_10_3/QB c_11_9/VDD 0.00969f
C3279 c_9_11/BL c_8_10/Q 0
C3280 c_9_11/BLB c_3_9/WL 0.00159f
C3281 c_1_5/QB c_0_9/WL 0
C3282 c_3_9/VDD c_3_10/QB 0.00969f
C3283 c_0_8/QB c_0_9/Q 0.01135f
C3284 c_4_9/WL c_9_10/BLB 0.00159f
C3285 c_11_14/QB c_11_13/QB 0
C3286 c_3_8/QB c_2_8/Q 0
C3287 c_9_12/BL c_5_11/QB 0.00303f
C3288 c_8_15/QB c_9_15/QB 0.01281f
C3289 c_0_11/Q c_0_10/Q 0
C3290 c_6_11/Q c_5_11/Q 0.00634f
C3291 c_6_2/QB c_6_1/QB 0
C3292 c_12_0/Q c_13_9/VDD 0.00266f
C3293 c_9_1/BL c_7_9/WL 0.00159f
C3294 c_9_9/WL c_8_5/Q 0
C3295 c_8_9/WL c_9_14/BL 0.00159f
C3296 c_14_0/Q c_13_0/Q 0.00634f
C3297 c_1_3/Q c_2_9/WL 0
C3298 c_2_11/Q c_1_9/WL 0
C3299 c_15_4/QB c_9_5/BL 0.00303f
C3300 c_9_0/BLB c_15_1/QB 0
C3301 c_1_3/QB c_1_9/WL 0
C3302 c_9_15/BL c_12_14/Q 0
C3303 c_13_11/Q c_12_9/WL 0
C3304 c_6_6/Q c_5_9/WL 0
C3305 c_9_7/BLB c_3_9/VDD -0.004f
C3306 c_10_7/QB c_11_7/QB 0.01281f
C3307 c_8_13/Q c_9_13/Q 0.00654f
C3308 c_9_9/VDD c_8_7/QB 0.00969f
C3309 c_2_9/WL c_1_14/QB 0
C3310 c_9_1/Q c_9_2/BL 0
C3311 c_9_4/QB c_9_3/BLB 0
C3312 c_14_11/Q c_13_11/Q 0.00634f
C3313 c_13_2/QB c_9_1/BLB 0
C3314 c_4_7/Q c_4_8/Q 0
C3315 c_6_1/QB c_7_9/WL 0
C3316 c_15_9/QB c_9_10/BL 0.00303f
C3317 c_12_7/Q c_12_8/Q 0
C3318 c_9_12/BL c_9_11/BLB 2.55595f
C3319 c_11_0/Q c_10_9/WL 0
C3320 c_3_9/VDD c_9_11/BLB -0.004f
C3321 c_5_9/WL c_5_0/QB 0
C3322 c_9_12/QB c_9_13/QB 0
C3323 c_8_13/Q c_7_13/Q 0.00634f
C3324 c_12_12/QB c_12_11/Q 0.00377f
C3325 c_15_5/QB c_9_6/BL 0.00303f
C3326 c_2_5/Q c_2_6/Q 0
C3327 c_11_8/Q c_12_8/Q 0.00634f
C3328 c_7_7/Q c_8_7/QB 0
C3329 c_10_2/Q c_9_3/BL 0
C3330 c_0_13/QB c_1_9/WL 0
C3331 c_3_15/Q c_4_15/QB 0
C3332 c_8_4/Q c_7_9/WL 0
C3333 c_9_6/BLB c_8_7/Q 0.00303f
C3334 c_6_4/QB c_5_4/QB 0.0025f
C3335 c_9_9/BL c_4_8/QB 0.00303f
C3336 c_9_15/BL c_8_14/QB 0.00303f
C3337 c_8_10/QB c_8_9/QB 0
C3338 c_5_9/WL c_6_7/QB 0
C3339 c_12_6/Q c_11_6/QB 0
C3340 c_12_6/QB c_11_6/Q 0
C3341 c_12_9/WL c_11_9/QB 0
C3342 c_9_13/BLB c_15_9/WL 0.00122f
C3343 c_15_9/QB c_9_8/BLB 0
C3344 c_9_9/WL c_9_6/QB 0
C3345 c_1_5/QB c_0_5/Q 0
C3346 c_6_2/Q c_7_2/QB 0
C3347 c_6_5/Q c_7_9/VDD 0.00756f
C3348 c_1_13/QB c_9_12/BLB 0
C3349 c_9_1/BL c_10_0/Q 0
C3350 c_1_5/Q c_1_4/Q 0
C3351 c_10_4/Q c_10_9/WL 0
C3352 c_9_1/BL c_15_0/Q 0
C3353 c_12_11/Q c_11_11/Q 0.00634f
C3354 c_6_7/Q c_7_7/Q 0.00654f
C3355 c_9_6/BL c_12_5/Q 0
C3356 c_8_14/QB c_9_9/WL 0
C3357 c_13_11/QB c_13_9/WL 0
C3358 c_9_7/BL c_9_6/BLB 2.55595f
C3359 c_1_9/Q c_1_10/QB 0.00377f
C3360 c_13_2/QB c_12_9/WL 0
C3361 c_5_9/WL c_9_9/BL 0.00159f
C3362 c_8_13/Q c_9_9/VDD 0.00756f
C3363 c_15_2/Q c_9_3/BL 0
C3364 c_13_9/WL c_12_2/QB 0
C3365 c_7_11/QB c_9_10/BLB 0
C3366 c_7_9/VDD c_9_10/BLB -0.004f
C3367 c_9_9/BL c_3_8/Q 0
C3368 c_14_9/Q c_13_9/QB 0
C3369 c_5_15/QB c_4_15/QB 0.01281f
C3370 c_1_10/Q c_1_11/QB 0.00377f
C3371 c_14_12/QB c_14_13/Q 0.01135f
C3372 c_8_4/QB c_9_9/VDD 0.00969f
C3373 c_14_9/WL c_9_1/BL 0.00159f
C3374 c_11_9/VDD c_11_11/QB 0.00969f
C3375 c_7_9/VDD c_7_15/Q 0.00565f
C3376 c_15_10/Q c_9_9/BLB 0.00303f
C3377 c_9_14/BL c_14_13/QB 0.00303f
C3378 c_0_3/QB c_0_2/Q 0.00377f
C3379 c_9_11/BL c_2_10/Q 0
C3380 c_15_11/QB c_9_10/BLB 0
C3381 c_10_9/WL c_9_10/QB 0
C3382 c_10_9/WL c_9_2/BLB 0.00159f
C3383 c_1_13/QB c_1_12/Q 0.00377f
C3384 c_13_9/VDD c_9_3/BLB -0.004f
C3385 c_12_9/Q c_11_9/QB 0
C3386 c_9_15/BLB c_9_9/VDD -0.01128f
C3387 c_1_5/QB c_9_4/BLB 0
C3388 c_1_6/QB c_9_7/BL 0.00303f
C3389 c_6_9/WL c_6_8/Q 0
C3390 c_3_4/QB c_4_9/WL 0
C3391 c_5_5/Q c_6_5/QB 0
C3392 c_13_14/Q c_13_9/VDD 0.00756f
C3393 c_10_12/QB c_9_11/BLB 0
C3394 c_0_1/Q c_9_2/BL 0
C3395 c_4_7/QB c_3_7/Q 0
C3396 c_14_2/Q c_14_1/Q 0
C3397 c_10_5/Q c_9_5/Q 0.00634f
C3398 c_8_0/Q c_9_0/QB 0
C3399 c_9_12/QB c_10_12/QB 0.0025f
C3400 c_9_13/BLB c_1_14/Q 0.00303f
C3401 c_15_5/QB c_15_4/Q 0.00377f
C3402 c_13_9/WL c_14_1/QB 0
C3403 c_9_13/BL c_5_9/VDD -0.004f
C3404 c_6_8/QB c_7_8/QB 0.01281f
C3405 c_9_0/BL c_5_9/VDD -0.01128f
C3406 c_2_11/Q c_9_10/BLB 0.00303f
C3407 c_4_14/Q c_4_15/QB 0.00377f
C3408 c_6_8/Q c_6_9/QB 0.00377f
C3409 c_9_13/BLB c_10_14/QB 0
C3410 c_1_7/Q c_1_8/Q 0
C3411 c_10_4/QB c_11_4/Q 0
C3412 c_10_4/Q c_11_4/QB 0
C3413 c_1_9/VDD c_0_4/Q 0.00756f
C3414 c_3_3/QB c_4_9/WL 0
C3415 c_11_9/VDD c_10_9/WL 0.04545f
C3416 c_8_3/Q c_7_9/WL 0
C3417 c_10_9/WL c_10_8/Q 0
C3418 c_9_3/BLB c_0_4/Q 0.00303f
C3419 c_13_11/Q c_9_10/BLB 0.00303f
C3420 c_13_3/Q c_13_2/Q 0
C3421 c_10_9/WL c_9_0/QB 0
C3422 c_11_13/Q c_9_14/BL 0
C3423 c_4_9/WL c_9_15/BLB 0
C3424 c_9_1/BL c_0_0/Q 0
C3425 c_11_9/VDD c_9_9/BL -0.004f
C3426 c_10_8/Q c_9_9/BL 0
C3427 c_8_9/WL c_8_8/Q 0
C3428 c_1_15/Q c_1_14/Q 0
C3429 c_1_7/QB c_0_9/WL 0
C3430 c_4_5/Q c_5_9/VDD 0.00756f
C3431 c_8_1/Q c_9_9/VDD 0.00756f
C3432 c_6_9/WL c_6_9/QB 0
C3433 c_5_14/Q c_6_9/WL 0
C3434 c_7_15/Q c_8_15/QB 0
C3435 c_6_8/Q c_5_8/Q 0.00634f
C3436 c_11_8/QB c_9_7/BLB 0
C3437 c_11_9/WL c_12_7/Q 0
C3438 c_7_9/VDD c_7_9/Q 0.00756f
C3439 c_15_9/VDD c_9_9/BLB -0.004f
C3440 c_5_9/WL c_5_5/QB 0
C3441 c_7_3/Q c_8_3/Q 0.00634f
C3442 c_8_3/QB c_9_2/BLB 0
C3443 c_9_13/BL c_3_9/WL 0.00159f
C3444 c_4_10/QB c_3_10/Q 0
C3445 c_11_9/WL c_10_15/QB 0
C3446 c_11_9/WL c_11_8/Q 0
C3447 c_9_0/BL c_3_9/WL 0
C3448 c_11_9/WL c_11_9/Q 0
C3449 c_1_9/VDD c_0_14/Q 0.00756f
C3450 c_4_13/Q c_5_13/QB 0
C3451 c_6_4/Q c_6_5/QB 0.00377f
C3452 c_13_9/WL c_12_13/Q 0
C3453 c_5_8/QB c_6_8/Q 0
C3454 c_4_13/Q c_4_9/WL 0
C3455 c_2_14/QB c_2_13/Q 0.00377f
C3456 c_6_2/QB c_6_3/QB 0
C3457 c_6_7/Q c_7_9/VDD 0.00756f
C3458 c_4_9/QB c_5_9/VDD 0.00969f
C3459 c_10_9/WL c_9_10/BL 0.00159f
C3460 c_9_0/BLB c_14_1/QB 0
C3461 c_6_9/WL c_5_8/Q 0
C3462 c_0_0/QB c_1_9/WL 0
C3463 c_0_9/QB c_1_9/WL 0
C3464 c_5_7/QB c_9_8/BL 0.00303f
C3465 c_13_4/QB c_12_9/WL 0
C3466 c_9_9/Q c_9_9/VDD 0.00756f
C3467 c_0_12/Q c_0_11/QB 0.01135f
C3468 c_0_12/QB c_0_11/Q 0.00377f
C3469 c_14_9/WL c_14_3/Q 0
C3470 c_5_9/WL c_5_12/Q 0
C3471 c_9_8/BL c_15_9/WL 0.00122f
C3472 c_13_3/Q c_14_9/WL 0
C3473 c_4_5/Q c_3_9/WL 0
C3474 c_6_9/WL c_5_8/QB 0
C3475 c_14_10/QB c_15_9/WL 0
C3476 c_13_9/WL c_12_10/Q 0
C3477 c_9_6/BLB c_12_9/WL 0.00159f
C3478 c_11_9/WL c_9_3/BL 0.00159f
C3479 c_11_9/WL c_12_3/Q 0
C3480 c_10_11/Q c_10_10/Q 0
C3481 c_8_8/Q c_9_8/BL 0
C3482 c_9_6/BLB c_1_9/WL 0.00159f
C3483 c_1_4/QB c_1_9/WL 0
C3484 c_0_9/WL c_1_9/VDD 0.04545f
C3485 c_11_9/VDD c_11_4/QB 0.00969f
C3486 c_10_11/Q c_10_12/Q 0
C3487 c_6_9/WL c_9_5/BL 0.00159f
C3488 c_10_9/WL c_9_8/BLB 0.00159f
C3489 c_6_3/QB c_7_9/WL 0
C3490 c_14_9/QB c_15_9/QB 0.01281f
C3491 c_3_7/QB c_3_9/WL 0
C3492 c_6_9/WL c_9_0/BLB 0.00159f
C3493 c_9_7/BLB c_15_9/VDD -0.004f
C3494 c_0_9/WL c_9_3/BLB 0.00122f
C3495 c_3_3/QB c_3_2/QB 0
C3496 c_13_2/Q c_13_9/VDD 0.00756f
C3497 c_3_9/VDD c_9_13/BL -0.004f
C3498 c_9_3/BL c_11_2/Q 0
C3499 c_9_4/BLB c_6_5/QB 0
C3500 c_14_7/Q c_15_9/WL 0
C3501 c_4_0/QB c_4_1/Q 0.01135f
C3502 c_9_5/BLB c_5_9/VDD -0.004f
C3503 c_4_6/QB c_4_5/Q 0.00377f
C3504 c_9_9/BL c_9_8/BLB 2.55595f
C3505 c_9_8/QB c_8_8/Q 0
C3506 c_9_0/BL c_3_9/VDD -0.01128f
C3507 c_11_9/WL c_10_5/Q 0
C3508 c_7_15/Q c_7_14/QB 0.01135f
C3509 c_6_10/QB c_5_10/QB 0.0025f
C3510 c_8_9/WL c_8_11/Q 0
C3511 c_1_1/Q c_2_9/WL 0
C3512 c_13_9/WL c_9_5/BL 0.00159f
C3513 c_6_15/QB c_6_14/Q 0.00377f
C3514 c_4_4/Q c_5_4/Q 0.00654f
C3515 c_5_9/WL c_5_7/Q 0
C3516 c_4_9/QB c_3_9/WL 0
C3517 c_15_9/VDD c_9_11/BLB -0.004f
C3518 c_14_13/QB c_15_9/WL 0
C3519 c_13_9/WL c_9_0/BLB 0.00159f
C3520 c_1_1/QB c_1_9/WL 0
C3521 c_14_12/Q c_15_9/VDD 0.00756f
C3522 c_7_9/VDD c_9_15/BLB -0.01128f
C3523 c_2_9/WL c_2_12/QB 0
C3524 c_5_5/Q c_5_6/Q 0
C3525 c_7_3/Q c_6_3/QB 0
C3526 c_13_9/VDD c_13_12/Q 0.00756f
C3527 c_8_5/QB c_8_4/Q 0.00377f
C3528 c_1_6/QB c_1_9/WL 0
C3529 c_4_9/QB c_5_9/QB 0.01281f
C3530 c_15_14/Q c_14_14/QB 0
C3531 c_14_12/QB c_15_12/Q 0
C3532 c_8_9/WL c_8_6/QB 0
C3533 c_9_11/Q c_9_10/BLB 0.00303f
C3534 c_12_12/Q c_13_12/Q 0.00654f
C3535 c_8_14/Q c_8_13/QB 0.01135f
C3536 c_10_3/Q c_9_9/WL 0
C3537 c_7_9/QB c_7_9/WL 0
C3538 c_10_9/WL c_10_14/Q 0
C3539 c_9_6/BL c_5_9/VDD -0.004f
C3540 c_1_13/Q c_2_9/WL 0
C3541 c_0_14/Q c_1_14/QB 0
C3542 c_14_9/WL c_15_2/QB 0
C3543 c_9_14/BL c_9_9/WL 0.00159f
C3544 c_1_9/QB c_1_9/WL 0
C3545 c_4_7/QB c_9_6/BLB 0
C3546 c_9_11/BL c_12_9/WL 0.00159f
C3547 c_8_15/Q c_9_15/Q 0.00654f
C3548 c_10_9/QB c_10_9/WL 0
C3549 c_9_11/BL c_1_9/WL 0.00159f
C3550 c_1_11/Q c_1_9/VDD 0.00756f
C3551 c_6_1/QB c_5_1/Q 0
C3552 c_1_13/QB c_1_9/WL 0
C3553 c_11_9/VDD c_11_12/QB 0.00969f
C3554 c_6_15/Q c_7_9/WL 0
C3555 c_3_9/VDD c_3_7/QB 0.00969f
C3556 c_9_12/BL c_9_11/QB 0.00303f
C3557 c_0_13/Q c_0_14/Q 0
C3558 c_9_5/BLB c_3_9/WL 0.00159f
C3559 c_11_9/VDD c_11_14/Q 0.00756f
C3560 c_14_9/WL c_15_10/QB 0
C3561 c_13_3/Q c_13_4/Q 0
C3562 c_13_14/QB c_13_13/QB 0
C3563 c_12_4/QB c_12_3/Q 0.00377f
C3564 c_9_13/BLB c_6_14/Q 0.00303f
C3565 c_1_5/QB c_1_9/WL 0
C3566 c_15_3/QB c_15_9/WL 0
C3567 c_9_7/BLB c_15_8/QB 0
C3568 c_0_9/WL c_1_3/Q 0
C3569 c_6_6/Q c_5_6/QB 0
C3570 c_5_9/VDD c_4_1/QB 0.00969f
C3571 c_11_8/QB c_10_8/QB 0.01281f
C3572 c_0_12/QB c_1_12/QB 0.01281f
C3573 c_9_1/Q c_10_9/WL 0
C3574 c_3_1/QB c_2_9/WL 0
C3575 c_0_5/Q c_1_9/VDD 0.00756f
C3576 c_0_11/QB c_1_11/QB 0.01281f
C3577 c_4_2/Q c_9_1/BLB 0.00303f
C3578 c_13_14/Q c_13_13/Q 0
C3579 c_6_13/QB c_7_9/WL 0
C3580 c_4_6/QB c_9_5/BLB 0
C3581 c_6_4/Q c_9_3/BLB 0.00303f
C3582 c_14_6/Q c_15_9/WL 0
C3583 c_10_12/QB c_9_13/BL 0.00303f
C3584 c_9_12/BLB c_1_9/VDD -0.004f
C3585 c_0_9/WL c_1_14/QB 0
C3586 c_11_14/QB c_12_9/WL 0
C3587 c_11_5/QB c_11_4/Q 0.00377f
C3588 c_2_9/WL c_9_14/BLB 0.00159f
C3589 c_12_9/WL c_13_15/Q 0
C3590 c_9_6/BL c_3_9/WL 0.00159f
C3591 c_2_7/QB c_2_9/WL 0
C3592 c_0_13/Q c_0_9/WL 0
C3593 c_3_10/Q c_9_9/BLB 0.00303f
C3594 c_8_13/QB c_7_9/WL 0
C3595 c_13_6/Q c_13_9/WL 0
C3596 c_9_4/BLB c_14_5/QB 0
C3597 c_11_9/WL c_11_9/QB 0
C3598 c_1_15/Q c_2_15/Q 0.00634f
C3599 c_3_13/QB c_9_14/BL 0.00303f
C3600 c_11_7/QB c_12_9/WL 0
C3601 c_15_7/QB c_14_9/WL 0
C3602 c_8_10/Q c_7_9/WL 0
C3603 c_3_9/VDD c_9_5/BLB -0.004f
C3604 c_9_1/BLB c_2_2/QB 0
C3605 c_15_15/Q c_14_15/Q 0.00654f
C3606 c_3_14/QB c_2_14/QB 0.01281f
C3607 c_4_10/Q c_5_9/VDD 0.00756f
C3608 c_4_1/QB c_3_9/WL 0
C3609 c_10_3/QB c_9_4/BL 0.00303f
C3610 c_9_5/BL c_2_4/Q 0
C3611 c_9_1/BL c_6_0/Q 0
C3612 c_6_11/Q c_9_10/BLB 0.00303f
C3613 c_3_6/Q c_3_7/QB 0.00377f
C3614 c_9_4/BLB c_1_9/VDD -0.004f
C3615 c_1_12/Q c_1_9/VDD 0.00756f
C3616 c_9_4/BLB c_2_5/QB 0
C3617 c_13_10/Q c_12_9/WL 0
C3618 c_12_0/QB c_13_9/WL 0
C3619 c_13_9/VDD c_13_12/QB 0.00969f
C3620 c_10_3/QB c_11_3/QB 0.01281f
C3621 c_10_9/WL c_11_6/Q 0
C3622 c_7_1/QB c_7_2/Q 0.01135f
C3623 c_11_0/QB c_11_1/QB 0
C3624 c_13_9/VDD c_13_4/Q 0.00756f
C3625 c_4_12/Q c_5_12/QB 0
C3626 c_3_9/VDD c_9_6/BL -0.004f
C3627 c_12_12/Q c_13_12/QB 0
C3628 c_1_9/VDD c_0_2/QB 0.00969f
C3629 c_14_6/QB c_14_7/Q 0.01135f
C3630 c_5_15/QB c_6_9/WL 0
C3631 c_6_1/QB c_6_0/Q 0.00377f
C3632 c_14_4/QB c_15_9/VDD 0.00969f
C3633 c_10_1/Q c_10_2/Q 0
C3634 c_9_3/BL c_0_2/Q 0
C3635 c_0_6/Q c_9_5/BLB 0.00303f
C3636 c_9_9/BL c_1_8/Q 0
C3637 c_8_8/QB c_7_9/WL 0
C3638 c_2_9/WL c_2_2/Q 0
C3639 c_3_8/QB c_2_8/QB 0.01281f
C3640 c_7_2/Q c_8_2/QB 0
C3641 c_9_7/BL c_1_9/VDD -0.004f
C3642 c_6_9/WL c_7_13/QB 0
C3643 c_7_8/Q c_9_9/BL 0
C3644 c_13_9/QB c_12_9/WL 0
C3645 c_9_8/Q c_9_7/BLB 0.00303f
C3646 c_2_2/QB c_1_9/WL 0
C3647 c_4_10/Q c_3_9/WL 0
C3648 c_10_1/Q c_11_1/Q 0.00654f
C3649 c_1_3/QB c_2_3/Q 0
C3650 c_13_6/QB c_9_5/BLB 0
C3651 c_3_8/QB c_3_9/WL 0
C3652 c_6_9/WL c_7_5/QB 0
C3653 c_1_10/QB c_2_10/QB 0.0025f
C3654 c_9_5/BLB c_3_6/Q 0.00303f
C3655 c_6_4/Q c_7_9/WL 0
C3656 c_10_14/Q c_11_14/Q 0.00654f
C3657 c_9_15/BL c_15_9/WL 0.00122f
C3658 c_8_1/Q c_7_1/Q 0.00634f
C3659 c_8_1/QB c_7_9/WL 0
C3660 c_5_6/Q c_9_7/BL 0
C3661 c_6_1/QB c_9_2/BL 0.00303f
C3662 c_13_7/QB c_12_7/QB 0.01281f
C3663 c_0_13/Q c_9_12/BLB 0.00303f
C3664 c_5_14/Q c_5_15/QB 0.00377f
C3665 c_9_11/BL c_9_10/BLB 2.55595f
C3666 c_9_5/QB c_8_5/QB 0.01281f
C3667 c_4_11/QB c_4_12/QB 0
C3668 c_9_12/BLB c_7_9/WL 0.00159f
C3669 c_1_0/QB c_2_0/Q 0
C3670 c_9_2/BL c_2_9/WL 0.00159f
C3671 c_10_11/QB c_11_11/QB 0.01281f
C3672 c_9_1/BLB c_9_2/Q 0.00303f
C3673 c_14_15/Q c_13_15/QB 0
C3674 c_10_6/QB c_10_9/WL 0
C3675 c_6_15/Q c_6_14/QB 0.01135f
C3676 c_4_11/QB c_3_11/QB 0.0025f
C3677 c_14_4/QB c_15_4/QB 0.01281f
C3678 c_14_9/Q c_14_9/WL 0
C3679 c_8_8/Q c_9_9/WL 0
C3680 c_15_14/QB c_15_9/WL 0
C3681 c_7_15/QB c_8_15/Q 0
C3682 c_12_9/Q c_13_9/QB 0
C3683 c_9_6/BLB c_8_7/QB 0
C3684 c_3_14/QB c_3_15/Q 0.01135f
C3685 c_6_9/WL c_9_9/BLB 0.00159f
C3686 c_15_9/VDD c_9_13/BL -0.004f
C3687 c_4_4/QB c_4_3/Q 0.00377f
C3688 c_9_0/BL c_15_9/VDD -0.01128f
C3689 c_13_12/Q c_13_13/Q 0
C3690 c_6_9/Q c_6_10/QB 0.00377f
C3691 c_6_13/QB c_6_14/QB 0
C3692 c_4_3/QB c_4_4/Q 0.01135f
C3693 c_5_6/QB c_5_5/QB 0
C3694 c_6_9/WL c_7_7/QB 0
C3695 c_9_10/BL c_15_9/Q 0
C3696 c_13_9/VDD c_12_14/QB 0.00969f
C3697 c_3_9/VDD c_3_8/QB 0.00969f
C3698 c_9_4/BLB c_7_9/WL 0.00159f
C3699 c_13_9/WL c_9_9/BLB 0.00159f
C3700 c_13_10/QB c_12_10/QB 0.01281f
C3701 c_5_14/Q c_4_14/Q 0.00654f
C3702 c_8_7/Q c_7_9/WL 0
C3703 c_1_7/Q c_2_9/WL 0
C3704 c_6_7/Q c_9_6/BLB 0.00303f
C3705 c_13_2/QB c_13_1/Q 0.00377f
C3706 c_9_11/BL c_10_10/QB 0.00303f
C3707 c_6_8/Q c_9_7/BLB 0.00303f
C3708 c_1_7/Q c_0_7/Q 0.00654f
C3709 c_5_9/WL c_6_6/QB 0
C3710 c_14_9/WL c_13_7/Q 0
C3711 c_2_0/Q c_3_9/WL 0
C3712 c_6_9/WL c_5_11/QB 0
C3713 c_4_14/QB c_4_13/QB 0
C3714 c_1_7/QB c_1_9/WL 0
C3715 c_13_9/VDD c_9_14/BLB -0.004f
C3716 c_10_9/WL c_10_11/QB 0
C3717 c_9_15/BL c_1_14/Q 0
C3718 c_2_12/Q c_2_13/QB 0.00377f
C3719 c_15_9/Q c_9_8/BLB 0.00303f
C3720 c_2_14/Q c_1_14/QB 0
C3721 c_9_1/BLB c_1_9/VDD -0.004f
C3722 c_10_3/Q c_10_4/Q 0
C3723 c_5_9/WL c_4_4/QB 0
C3724 c_0_9/WL c_0_9/Q 0
C3725 c_5_13/QB c_5_9/VDD 0.00969f
C3726 c_14_9/WL c_13_13/Q 0
C3727 c_9_7/BL c_7_9/WL 0.00159f
C3728 c_11_9/WL c_9_6/BLB 0.00159f
C3729 c_9_6/Q c_8_6/QB 0
C3730 c_0_8/QB c_9_9/BL 0.00303f
C3731 c_2_9/QB c_3_9/Q 0
C3732 c_1_9/Q c_2_9/QB 0
C3733 c_2_9/Q c_3_9/QB 0
C3734 c_5_9/WL c_9_14/BL 0.00159f
C3735 c_9_1/BL c_7_0/Q 0
C3736 c_9_15/BL c_10_14/QB 0.00303f
C3737 c_6_9/WL c_9_7/BLB 0.00159f
C3738 c_7_12/QB c_6_9/WL 0
C3739 c_4_9/WL c_5_9/VDD 0.04545f
C3740 c_10_7/Q c_9_6/BLB 0.00303f
C3741 c_8_13/QB c_8_12/Q 0.00377f
C3742 c_2_9/WL c_2_1/QB 0
C3743 c_14_9/WL c_14_5/Q 0
C3744 c_2_9/QB c_9_10/BL 0.00303f
C3745 c_9_9/BLB c_12_10/Q 0.00303f
C3746 c_5_14/QB c_5_13/QB 0
C3747 c_9_12/BLB c_14_9/WL 0.00159f
C3748 c_9_8/Q c_10_8/QB 0
C3749 c_6_9/WL c_9_11/BLB 0.00159f
C3750 c_9_9/WL c_10_14/QB 0
C3751 c_13_9/WL c_9_7/BLB 0.00159f
C3752 c_9_7/Q c_10_7/QB 0
C3753 c_2_11/QB c_2_12/QB 0
C3754 c_8_11/Q c_9_9/WL 0
C3755 c_1_6/QB c_0_6/QB 0.01281f
C3756 c_5_14/QB c_4_9/WL 0
C3757 c_13_7/QB c_13_8/QB 0
C3758 c_9_4/BL c_10_9/WL 0.00159f
C3759 c_10_3/Q c_9_2/BLB 0.00303f
C3760 c_3_5/Q c_2_5/QB 0
C3761 c_5_6/QB c_5_7/Q 0.01135f
C3762 c_2_0/Q c_3_9/VDD 0.00266f
C3763 c_13_9/WL c_9_11/BLB 0.00159f
C3764 c_2_9/QB c_9_8/BLB 0
C3765 c_6_4/QB c_6_9/WL 0
C3766 c_0_9/WL c_1_1/Q 0
C3767 c_1_9/VDD c_1_9/WL 0.04545f
C3768 c_2_5/QB c_1_9/WL 0
C3769 c_3_14/QB c_4_14/Q 0
C3770 c_9_9/WL c_8_6/QB 0
C3771 c_15_8/Q c_14_8/Q 0.00654f
C3772 c_14_12/Q c_13_9/WL 0
C3773 c_9_13/QB c_9_9/VDD 0.00969f
C3774 c_10_9/WL c_11_3/QB 0
C3775 c_11_9/Q c_11_10/QB 0.00377f
C3776 c_9_3/BLB c_12_9/WL 0.00159f
C3777 c_9_9/BL c_14_8/QB 0.00303f
C3778 c_9_9/BLB c_8_10/QB 0
C3779 c_9_3/BLB c_1_9/WL 0.00159f
C3780 c_12_15/QB c_13_15/Q 0
C3781 c_13_9/VDD c_12_6/QB 0.00969f
C3782 c_3_0/QB c_9_1/BL 0.00303f
C3783 c_4_9/WL c_3_9/WL 0.8704f
C3784 c_14_1/QB c_13_1/QB 0.0025f
C3785 c_13_14/Q c_12_9/WL 0
C3786 c_9_12/BL c_9_9/VDD -0.004f
C3787 c_11_9/WL c_9_11/BL 0.00159f
C3788 c_15_1/Q c_15_9/WL 0
C3789 c_9_4/BLB c_14_9/WL 0.00159f
C3790 c_11_3/Q c_10_3/QB 0
C3791 c_7_9/VDD c_6_8/QB 0.00969f
C3792 c_15_9/VDD c_9_5/BLB -0.004f
C3793 c_13_12/QB c_13_13/Q 0.01135f
C3794 c_12_4/QB c_13_4/QB 0.01281f
C3795 c_6_15/Q c_9_14/BLB 0.00303f
C3796 c_5_9/QB c_4_9/WL 0
C3797 c_11_9/WL c_10_1/Q 0
C3798 c_5_9/WL c_4_0/Q 0
C3799 c_6_2/QB c_9_1/BLB 0
C3800 c_6_9/WL c_5_2/QB 0
C3801 c_9_7/BLB c_5_8/Q 0.00303f
C3802 c_1_13/Q c_0_9/WL 0
C3803 c_10_2/Q c_9_2/Q 0.00634f
C3804 c_9_14/BLB c_9_15/Q 0.00303f
C3805 c_4_5/QB c_9_6/BL 0.00303f
C3806 c_4_6/QB c_4_9/WL 0
C3807 c_10_3/Q c_11_9/VDD 0.00756f
C3808 c_11_9/VDD c_9_14/BL -0.004f
C3809 c_5_8/QB c_9_7/BLB 0
C3810 c_8_9/WL c_7_2/QB 0
C3811 c_9_0/BLB c_4_1/Q 0.00303f
C3812 c_12_2/QB c_12_1/QB 0
C3813 c_1_10/QB c_2_9/WL 0
C3814 c_14_9/WL c_9_7/BL 0.00159f
C3815 c_2_12/Q c_3_9/WL 0
C3816 c_13_9/VDD c_9_2/BL -0.004f
C3817 c_8_15/Q c_9_15/QB 0
C3818 c_3_0/QB c_2_9/WL 0
C3819 c_9_6/BL c_15_9/VDD -0.004f
C3820 c_11_14/QB c_11_9/WL 0
C3821 c_9_3/BL c_5_9/VDD -0.004f
C3822 c_9_1/BLB c_7_9/WL 0.00159f
C3823 c_13_9/WL c_13_1/QB 0
C3824 c_5_4/QB c_4_9/WL 0
C3825 c_9_4/BL c_8_3/QB 0.00303f
C3826 c_7_11/QB c_7_10/Q 0.00377f
C3827 c_9_2/BLB c_0_3/Q 0.00303f
C3828 c_6_9/WL c_7_6/QB 0
C3829 c_9_12/BL c_4_9/WL 0.00159f
C3830 c_7_9/VDD c_7_10/Q 0.00756f
C3831 c_4_2/QB c_4_1/Q 0.00377f
C3832 c_0_9/WL c_9_14/BLB 0.00122f
C3833 c_4_10/QB c_9_9/BLB 0
C3834 c_1_3/Q c_1_9/WL 0
C3835 c_11_9/WL c_11_7/QB 0
C3836 c_10_7/Q c_11_7/QB 0
C3837 c_9_7/QB c_9_9/VDD 0.00969f
C3838 c_11_4/QB c_11_3/QB 0
C3839 c_9_1/BL c_5_0/QB 0.00303f
C3840 c_9_4/Q c_9_3/BLB 0.00303f
C3841 c_6_4/QB c_9_5/BL 0.00303f
C3842 c_13_2/Q c_9_1/BLB 0.00303f
C3843 c_1_9/WL c_1_14/QB 0
C3844 c_9_12/Q c_9_13/QB 0.00377f
C3845 c_8_0/Q c_9_1/BL 0
C3846 c_4_10/QB c_3_10/QB 0.0025f
C3847 c_4_0/QB c_4_1/QB 0
C3848 c_8_9/WL c_9_13/BLB 0.00159f
C3849 c_3_2/QB c_3_9/WL 0
C3850 c_10_10/Q c_9_9/BLB 0.00303f
C3851 c_15_9/VDD c_14_15/Q 0.00565f
C3852 c_10_6/QB c_9_6/QB 0.0025f
C3853 c_0_13/Q c_1_9/WL 0
C3854 c_2_12/Q c_3_9/VDD 0.00756f
C3855 c_9_3/BL c_3_9/WL 0.00159f
C3856 c_5_9/WL c_5_7/QB 0
C3857 c_9_9/BL c_4_8/Q 0
C3858 c_12_6/Q c_11_6/Q 0.00634f
C3859 c_8_10/QB c_8_9/Q 0.00377f
C3860 c_9_15/BL c_6_14/Q 0
C3861 c_3_5/QB c_3_4/Q 0.00377f
C3862 c_3_4/Q c_2_9/WL 0
C3863 c_1_13/Q c_9_12/BLB 0.00303f
C3864 c_9_1/BL c_10_9/WL 0.00159f
C3865 c_9_7/Q c_8_7/Q 0.00654f
C3866 c_5_9/WL c_6_12/Q 0
C3867 c_14_9/QB c_15_9/Q 0
C3868 c_11_12/Q c_11_11/QB 0.01135f
C3869 c_7_12/QB c_8_12/QB 0.0025f
C3870 c_10_11/Q c_9_11/QB 0
C3871 c_14_11/QB c_14_9/WL 0
C3872 c_6_2/Q c_5_2/Q 0.00634f
C3873 c_7_9/VDD c_6_1/Q 0.00756f
C3874 c_14_4/QB c_13_9/WL 0
C3875 c_9_0/BLB c_13_1/QB 0
C3876 c_13_2/Q c_12_9/WL 0
C3877 c_1_9/Q c_1_10/Q 0
C3878 c_4_9/WL c_3_6/Q 0
C3879 c_13_8/QB c_14_8/QB 0.0025f
C3880 c_13_9/WL c_12_1/QB 0
C3881 c_1_9/VDD c_9_10/BLB -0.004f
C3882 c_9_14/BL c_6_13/Q 0
C3883 c_9_4/BLB c_8_5/QB 0
C3884 c_1_12/Q c_2_12/QB 0
C3885 c_4_12/Q c_5_12/Q 0.00654f
C3886 c_9_12/BL c_6_12/QB 0
C3887 c_7_11/Q c_9_10/BLB 0.00303f
C3888 c_4_2/QB c_5_2/QB 0.01281f
C3889 c_15_9/QB c_15_10/QB 0
C3890 c_15_9/VDD c_15_4/Q 0.00756f
C3891 c_13_9/WL c_12_2/Q 0
C3892 c_8_12/QB c_9_11/BLB 0
C3893 c_5_15/Q c_6_15/QB 0
C3894 c_9_2/BLB c_15_9/WL 0.00122f
C3895 c_0_9/WL c_0_10/QB 0
C3896 c_11_10/QB c_11_9/QB 0
C3897 c_3_15/QB c_4_9/WL 0
C3898 c_3_2/QB c_3_9/VDD 0.00969f
C3899 c_14_9/WL c_9_1/BLB 0.00159f
C3900 c_9_12/QB c_8_12/QB 0.01281f
C3901 c_10_9/WL c_9_10/Q 0
C3902 c_13_12/Q c_12_9/WL 0
C3903 c_7_11/QB c_9_12/BL 0.00303f
C3904 c_1_13/Q c_1_12/Q 0
C3905 c_9_3/BL c_3_9/VDD -0.004f
C3906 c_7_9/VDD c_9_12/BL -0.004f
C3907 c_2_11/Q c_3_9/WL 0
C3908 c_5_13/Q c_5_12/QB 0.01135f
C3909 c_3_12/Q c_9_11/BLB 0.00303f
C3910 c_5_9/WL c_6_2/Q 0
C3911 c_9_9/BL c_2_9/WL 0.00159f
C3912 c_10_12/Q c_9_11/BLB 0.00303f
C3913 c_9_12/BL c_15_11/QB 0.00303f
C3914 c_13_13/Q c_14_13/Q 0.00634f
C3915 c_12_0/Q c_11_9/WL 0
C3916 c_13_14/QB c_13_15/QB 0
C3917 c_9_14/QB c_9_13/Q 0.00377f
C3918 c_9_14/Q c_9_13/QB 0.01135f
C3919 c_0_9/WL c_9_2/BL 0.00122f
C3920 c_6_9/WL c_9_13/BL 0.00159f
C3921 c_10_9/WL c_11_12/Q 0
C3922 c_9_0/BL c_6_9/WL 0
C3923 c_9_12/Q c_10_12/QB 0
C3924 c_9_12/QB c_10_12/Q 0
C3925 c_15_6/Q c_9_5/BLB 0.00303f
C3926 c_11_3/Q c_10_9/WL 0
C3927 c_6_8/Q c_7_8/QB 0
C3928 c_7_15/QB c_9_14/BLB 0
C3929 c_13_9/WL c_9_13/BL 0.00159f
C3930 c_9_12/BLB c_14_13/Q 0.00303f
C3931 c_10_4/Q c_11_4/Q 0.00654f
C3932 c_14_4/QB c_9_5/BL 0.00303f
C3933 c_9_0/BL c_13_9/WL 0
C3934 c_3_3/Q c_4_9/WL 0
C3935 c_7_12/QB c_7_13/QB 0
C3936 c_9_0/BLB c_12_1/QB 0
C3937 c_14_11/Q c_14_9/WL 0
C3938 c_6_5/Q c_7_9/WL 0
C3939 c_6_6/QB c_5_6/QB 0.0025f
C3940 c_0_15/QB c_1_15/QB 0.01281f
C3941 c_2_11/Q c_9_12/BL 0
C3942 c_2_11/Q c_3_9/VDD 0.00756f
C3943 c_6_9/WL c_7_8/QB 0
C3944 c_1_7/Q c_0_9/WL 0
C3945 c_3_7/Q c_3_9/WL 0
C3946 c_6_1/Q c_7_1/Q 0.00654f
C3947 c_9_12/BL c_13_11/Q 0
C3948 c_7_15/Q c_8_15/Q 0.00634f
C3949 c_0_8/Q c_0_9/QB 0.00377f
C3950 c_3_10/QB c_9_9/BLB 0
C3951 c_15_7/Q c_15_9/WL 0
C3952 c_9_14/QB c_9_9/VDD 0.00969f
C3953 c_7_1/QB c_6_1/QB 0.01281f
C3954 c_2_3/Q c_2_2/QB 0.01135f
C3955 c_8_3/QB c_8_4/Q 0.01135f
C3956 c_7_9/WL c_9_10/BLB 0.00159f
C3957 c_9_10/BL c_15_9/WL 0.00122f
C3958 c_9_4/QB c_10_9/WL 0
C3959 c_7_15/Q c_7_9/WL 0
C3960 c_8_9/WL c_9_8/BL 0.00159f
C3961 c_12_11/QB c_13_11/Q 0
C3962 c_14_0/QB c_9_1/BL 0.00303f
C3963 c_8_1/QB c_9_2/BL 0.00303f
C3964 c_0_6/QB c_1_9/VDD 0.00969f
C3965 c_4_5/QB c_4_9/WL 0
C3966 c_13_12/QB c_12_9/WL 0
C3967 c_3_4/QB c_9_3/BLB 0
C3968 c_0_0/Q c_1_9/WL 0
C3969 c_0_9/Q c_1_9/WL 0
C3970 c_11_3/Q c_11_4/QB 0.00377f
C3971 c_5_9/WL c_6_10/QB 0
C3972 c_0_12/Q c_0_11/Q 0
C3973 c_13_4/Q c_12_9/WL 0
C3974 c_8_9/WL c_9_8/QB 0
C3975 c_4_10/Q c_3_10/Q 0.00634f
C3976 c_9_8/BLB c_15_9/WL 0.00122f
C3977 c_14_9/WL c_15_15/QB 0
C3978 c_3_7/Q c_3_9/VDD 0.00756f
C3979 c_9_0/BL c_9_0/BLB -0
C3980 c_11_9/WL c_9_3/BLB 0.00159f
C3981 c_14_10/Q c_15_9/WL 0
C3982 c_11_9/VDD c_10_14/QB 0.00969f
C3983 c_11_9/Q c_11_8/QB 0.01135f
C3984 c_0_9/WL c_0_1/QB 0
C3985 c_1_9/Q c_1_8/QB 0.01135f
C3986 c_11_9/VDD c_11_4/Q 0.00756f
C3987 c_6_9/WL c_9_5/BLB 0.00159f
C3988 c_14_9/Q c_15_9/QB 0
C3989 c_3_3/Q c_3_2/QB 0.01135f
C3990 c_2_9/QB c_2_10/QB 0
C3991 c_12_6/QB c_12_5/QB 0
C3992 c_9_3/BLB c_8_4/QB 0
C3993 c_4_0/QB c_4_9/WL 0
C3994 c_12_6/QB c_9_7/BL 0.00303f
C3995 c_4_6/Q c_4_5/Q 0
C3996 c_6_12/Q c_6_13/Q 0
C3997 c_6_10/Q c_5_10/QB 0
C3998 c_6_10/QB c_5_10/Q 0
C3999 c_1_9/VDD c_9_15/BLB -0.01128f
C4000 c_13_9/WL c_9_5/BLB 0.00159f
C4001 c_15_10/QB c_15_11/Q 0.01135f
C4002 c_15_10/Q c_15_11/QB 0.00377f
C4003 c_9_9/BL c_12_8/QB 0.00303f
C4004 c_7_10/QB c_7_9/QB 0
C4005 c_11_9/WL c_10_0/QB 0
C4006 c_8_9/QB c_9_9/VDD 0.00969f
C4007 c_1_0/QB c_0_0/QB 0.01281f
C4008 c_1_1/Q c_1_9/WL 0
C4009 c_5_9/WL c_4_12/QB 0
C4010 c_8_5/Q c_8_4/Q 0
C4011 c_7_2/QB c_8_2/Q 0
C4012 c_15_14/Q c_14_14/Q 0.00654f
C4013 c_12_0/QB c_12_1/QB 0
C4014 c_10_9/WL c_9_5/QB 0
C4015 c_6_9/WL c_9_6/BL 0.00159f
C4016 c_2_12/QB c_1_9/WL 0
C4017 c_7_9/WL c_8_7/QB 0
C4018 c_8_9/WL c_9_1/QB 0
C4019 c_12_8/QB c_12_7/QB 0
C4020 c_8_14/Q c_8_13/Q 0
C4021 c_7_9/Q c_7_9/WL 0
C4022 c_9_6/BLB c_5_9/VDD -0.004f
C4023 c_7_5/QB c_7_6/QB 0
C4024 c_13_9/VDD c_9_9/BL -0.004f
C4025 c_11_10/Q c_11_11/QB 0.00377f
C4026 c_14_9/WL c_9_10/BLB 0.00159f
C4027 c_14_9/WL c_15_2/Q 0
C4028 c_10_9/WL c_10_13/QB 0
C4029 c_10_9/Q c_10_9/WL 0
C4030 c_1_10/QB c_0_9/WL 0
C4031 c_1_13/QB c_2_13/QB 0.0025f
C4032 c_9_8/BL c_14_7/Q 0
C4033 c_13_9/WL c_9_6/BL 0.00159f
C4034 c_7_12/QB c_9_11/BLB 0
C4035 c_1_13/Q c_1_9/WL 0
C4036 c_5_9/WL c_5_4/Q 0
C4037 c_8_12/QB c_9_13/BL 0.00303f
C4038 c_11_6/QB c_10_6/Q 0
C4039 c_9_15/QB c_9_14/BLB 0
C4040 c_9_12/BL c_9_11/Q 0
C4041 c_3_7/Q c_3_6/Q 0
C4042 c_5_9/WL c_6_14/Q 0
C4043 c_15_8/Q c_15_9/VDD 0.00756f
C4044 c_15_3/Q c_15_9/WL 0
C4045 c_13_14/Q c_13_13/QB 0.01135f
C4046 c_12_4/QB c_9_3/BLB 0
C4047 c_12_4/Q c_12_3/Q 0
C4048 c_6_7/Q c_7_9/WL 0
C4049 c_15_5/Q c_14_5/Q 0.00654f
C4050 c_13_9/VDD c_12_7/QB 0.00969f
C4051 c_0_12/Q c_1_12/QB 0
C4052 c_1_0/QB c_1_1/QB 0
C4053 c_3_1/Q c_2_9/WL 0
C4054 c_12_14/QB c_12_9/WL 0
C4055 c_14_12/Q c_9_11/BLB 0.00303f
C4056 c_0_11/Q c_1_11/QB 0
C4057 c_2_0/QB c_1_0/Q 0
C4058 c_4_6/Q c_9_5/BLB 0.00303f
C4059 c_9_12/QB c_9_11/BLB 0
C4060 c_10_4/QB c_9_9/WL 0
C4061 c_11_10/QB c_9_11/BL 0.00303f
C4062 c_9_9/WL c_9_13/BLB 0.00159f
C4063 c_9_13/BL c_3_12/Q 0
C4064 c_9_3/BL c_15_9/VDD -0.004f
C4065 c_13_11/QB c_13_10/QB 0
C4066 c_10_12/Q c_9_13/BL 0
C4067 c_15_14/QB c_9_13/BLB 0
C4068 c_9_5/BL c_9_5/BLB -0
C4069 c_9_6/Q c_10_6/Q 0.00634f
C4070 c_8_2/QB c_8_3/Q 0.01135f
C4071 c_9_6/BLB c_14_7/QB 0
C4072 c_8_10/Q c_7_10/QB 0
C4073 c_2_7/Q c_2_9/WL 0
C4074 c_12_9/WL c_9_14/BLB 0.00159f
C4075 c_9_6/BLB c_3_9/WL 0.00159f
C4076 c_15_9/VDD c_14_14/QB 0.00969f
C4077 c_9_1/BL c_13_0/QB 0.00303f
C4078 c_9_14/BLB c_1_9/WL 0.00159f
C4079 c_6_2/Q c_7_2/Q 0.00654f
C4080 c_13_9/WL c_14_15/Q 0
C4081 c_5_7/QB c_5_6/QB 0
C4082 c_5_12/QB c_5_11/Q 0.00377f
C4083 c_7_7/QB c_7_6/QB 0
C4084 c_15_5/QB c_14_5/QB 0.01281f
C4085 c_8_13/Q c_7_9/WL 0
C4086 c_2_7/QB c_1_9/WL 0
C4087 c_9_8/Q c_9_9/VDD 0.00756f
C4088 c_9_11/BL c_5_9/VDD -0.004f
C4089 c_15_9/VDD c_15_11/QB 0.00969f
C4090 c_11_10/Q c_10_9/WL 0
C4091 c_1_10/QB c_1_11/Q 0.01135f
C4092 c_8_4/QB c_7_9/WL 0
C4093 c_9_11/BL c_7_10/Q 0
C4094 c_11_7/Q c_9_8/BL 0
C4095 c_15_5/Q c_9_4/BLB 0.00303f
C4096 c_9_1/BLB c_2_2/Q 0.00303f
C4097 c_8_6/Q c_8_7/Q 0
C4098 c_4_12/QB c_3_12/QB 0.0025f
C4099 c_1_3/QB c_2_3/QB 0.0025f
C4100 c_5_1/QB c_5_9/VDD 0.00969f
C4101 c_10_3/Q c_9_4/BL 0
C4102 c_4_10/QB c_4_9/QB 0
C4103 c_12_0/Q c_12_1/Q 0
C4104 c_9_15/BLB c_7_9/WL 0
C4105 c_3_2/Q c_2_9/WL 0
C4106 c_10_9/WL c_9_15/Q 0
C4107 c_9_9/WL c_10_6/Q 0
C4108 c_3_11/QB c_3_12/QB 0
C4109 c_11_8/QB c_11_9/QB 0
C4110 c_10_3/Q c_11_3/QB 0
C4111 c_8_9/WL c_9_6/Q 0
C4112 c_11_0/Q c_11_1/QB 0.00377f
C4113 c_3_10/Q c_4_9/WL 0
C4114 c_7_8/Q c_8_8/Q 0.00634f
C4115 c_9_12/BL c_6_11/Q 0
C4116 c_0_5/QB c_0_4/Q 0.00377f
C4117 c_8_6/Q c_9_7/BL 0
C4118 c_11_13/QB c_10_9/WL 0
C4119 c_3_9/VDD c_9_6/BLB -0.004f
C4120 c_11_5/Q c_10_9/WL 0
C4121 c_0_1/QB c_0_2/QB 0
C4122 c_1_9/VDD c_0_2/Q 0.00756f
C4123 c_9_11/BL c_3_9/WL 0.00159f
C4124 c_12_8/QB c_13_8/QB 0.01281f
C4125 c_14_6/Q c_14_7/Q 0
C4126 c_9_0/BLB c_4_1/QB 0
C4127 c_12_9/WL c_11_15/QB 0
C4128 c_11_9/WL c_10_0/Q 0
C4129 c_9_1/BLB c_9_2/BL 2.55595f
C4130 c_14_4/Q c_15_9/VDD 0.00756f
C4131 c_9_11/BL c_12_10/QB 0.00303f
C4132 c_12_6/QB c_12_9/WL 0
C4133 c_10_7/QB c_10_9/WL 0
C4134 c_1_4/QB c_2_4/QB 0.0025f
C4135 c_1_6/Q c_2_9/WL 0
C4136 c_14_9/QB c_15_9/WL 0
C4137 c_9_7/BLB c_10_8/QB 0
C4138 c_1_12/QB c_1_11/QB 0
C4139 c_9_15/BL c_8_9/WL 0.00159f
C4140 c_2_2/Q c_1_9/WL 0
C4141 c_6_9/WL c_7_13/Q 0
C4142 c_5_15/Q c_4_15/Q 0.00654f
C4143 c_1_3/Q c_2_3/Q 0.00634f
C4144 c_0_10/QB c_1_9/WL 0
C4145 c_15_15/QB c_9_14/BLB 0
C4146 c_13_6/Q c_9_5/BLB 0.00303f
C4147 c_0_9/WL c_9_9/BL 0.00122f
C4148 c_4_2/Q c_5_9/VDD 0.00756f
C4149 c_4_2/QB c_4_1/QB 0
C4150 c_13_9/VDD c_13_8/QB 0.00969f
C4151 c_1_10/QB c_2_10/Q 0
C4152 c_1_10/Q c_2_10/QB 0
C4153 c_6_9/WL c_7_5/Q 0
C4154 c_10_9/WL c_11_2/QB 0
C4155 c_2_9/QB c_2_9/WL 0
C4156 c_11_5/QB c_11_6/QB 0
C4157 c_5_13/Q c_5_12/Q 0
C4158 c_12_12/Q c_11_12/QB 0
C4159 c_8_9/WL c_9_9/WL 0.06483f
C4160 c_8_9/WL c_8_2/Q 0
C4161 c_8_1/Q c_7_9/WL 0
C4162 c_0_14/QB c_1_14/Q 0
C4163 c_6_9/WL c_7_0/QB 0
C4164 c_13_9/WL c_13_10/QB 0
C4165 c_6_12/Q c_6_11/QB 0.01135f
C4166 c_9_5/QB c_8_5/Q 0
C4167 c_9_5/Q c_8_5/QB 0
C4168 c_4_11/Q c_4_12/QB 0.00377f
C4169 c_6_1/Q c_5_1/QB 0
C4170 c_10_1/QB c_9_0/BLB 0
C4171 c_1_5/Q c_2_9/WL 0
C4172 c_14_12/QB c_15_9/WL 0
C4173 c_9_4/BL c_0_3/Q 0
C4174 c_9_2/BL c_12_9/WL 0.00159f
C4175 c_5_3/QB c_5_9/VDD 0.00969f
C4176 c_14_4/Q c_15_4/QB 0
C4177 c_9_2/BL c_1_9/WL 0.00159f
C4178 c_4_11/QB c_3_11/Q 0
C4179 c_4_11/Q c_3_11/QB 0
C4180 c_9_11/BL c_3_9/VDD -0.004f
C4181 c_13_13/QB c_13_12/Q 0.00377f
C4182 c_9_7/QB c_9_6/BLB 0
C4183 c_9_5/BL c_15_4/Q 0
C4184 c_14_9/WL c_9_15/BLB 0
C4185 c_14_9/WL c_15_14/Q 0
C4186 c_8_1/QB c_8_0/Q 0.00377f
C4187 c_0_5/QB c_0_9/WL 0
C4188 c_8_0/QB c_8_9/WL 0
C4189 c_13_9/VDD c_12_14/Q 0.00756f
C4190 c_4_2/Q c_3_9/WL 0
C4191 c_6_9/Q c_6_10/Q 0
C4192 c_1_6/QB c_0_6/Q 0
C4193 c_2_6/QB c_3_6/QB 0.01281f
C4194 c_11_5/Q c_11_4/QB 0.01135f
C4195 c_8_8/QB c_9_9/BL 0.00303f
C4196 c_14_12/QB c_15_12/QB 0.01281f
C4197 c_9_7/Q c_8_7/QB 0
C4198 c_4_3/Q c_4_4/Q 0
C4199 c_6_9/WL c_7_7/Q 0
C4200 c_9_3/Q c_9_9/VDD 0.00756f
C4201 c_13_10/Q c_12_10/QB 0
C4202 c_13_10/QB c_12_10/Q 0
C4203 c_7_15/Q c_9_14/BLB 0.00303f
C4204 c_13_2/Q c_13_1/Q 0
C4205 c_6_14/Q c_6_13/Q 0
C4206 c_14_9/WL c_15_6/QB 0
C4207 c_9_9/WL c_9_8/BL 0.00159f
C4208 c_9_5/QB c_9_6/QB 0
C4209 c_4_14/QB c_4_13/Q 0.00377f
C4210 c_12_7/QB c_13_7/Q 0
C4211 c_6_3/Q c_6_9/WL 0
C4212 c_14_9/WL c_13_13/QB 0
C4213 c_1_7/Q c_1_9/WL 0
C4214 c_8_10/Q c_8_11/QB 0.00377f
C4215 c_14_2/Q c_15_9/WL 0
C4216 c_11_7/Q c_11_6/QB 0.01135f
C4217 c_7_7/QB c_7_8/QB 0
C4218 c_6_9/WL c_5_13/QB 0
C4219 c_7_12/QB c_9_13/BL 0.00303f
C4220 c_15_9/VDD c_15_0/QB 0.00777f
C4221 c_9_12/BLB c_10_9/WL 0.00159f
C4222 c_2_12/Q c_2_13/Q 0
C4223 c_11_9/VDD c_11_1/QB 0.00969f
C4224 c_5_9/WL c_6_15/QB 0
C4225 c_9_8/QB c_9_9/WL 0
C4226 c_2_2/QB c_3_9/WL 0
C4227 c_5_9/WL c_4_3/QB 0
C4228 c_5_9/WL c_4_4/Q 0
C4229 c_1_9/Q c_2_9/Q 0.00634f
C4230 c_2_9/Q c_3_9/Q 0.00654f
C4231 c_13_1/QB c_12_1/QB 0.01281f
C4232 c_2_6/QB c_2_9/WL 0
C4233 c_8_13/Q c_8_12/Q 0
C4234 c_13_9/Q c_13_8/Q 0
C4235 c_6_6/Q c_9_7/BL 0
C4236 c_14_12/Q c_9_13/BL 0
C4237 c_0_8/Q c_1_9/VDD 0.00756f
C4238 c_2_9/WL c_2_1/Q 0
C4239 c_2_9/Q c_9_10/BL 0
C4240 c_11_13/QB c_11_12/QB 0
C4241 c_9_4/BL c_15_9/WL 0.00122f
C4242 c_12_2/QB c_12_3/Q 0.01135f
C4243 c_9_12/QB c_9_13/BL 0.00303f
C4244 c_11_13/QB c_11_14/Q 0.01135f
C4245 c_9_3/BL c_12_2/QB 0.00303f
C4246 c_15_10/QB c_15_9/Q 0.00377f
C4247 c_2_1/QB c_1_9/WL 0
C4248 c_5_14/Q c_5_13/QB 0.01135f
C4249 c_9_7/Q c_10_7/Q 0.00634f
C4250 c_10_9/WL c_9_9/QB 0
C4251 c_14_8/QB c_15_9/WL 0
C4252 c_6_1/Q c_6_0/QB 0.01135f
C4253 c_9_7/BLB c_7_8/QB 0
C4254 c_9_4/BLB c_10_9/WL 0.00159f
C4255 c_0_8/QB c_1_8/QB 0.01281f
C4256 c_5_14/Q c_4_9/WL 0
C4257 c_13_9/VDD c_13_0/QB 0.00777f
C4258 c_4_3/QB c_9_2/BLB 0
C4259 c_5_4/QB c_5_3/QB 0
C4260 c_12_14/QB c_12_15/QB 0
C4261 c_9_5/BL c_9_9/VDD -0.004f
C4262 c_7_5/QB c_9_6/BL 0.00303f
C4263 c_15_0/QB c_15_1/QB 0
C4264 c_9_0/BLB c_9_9/VDD -0.004f
C4265 c_9_14/BL c_2_9/WL 0.00159f
C4266 c_5_9/WL c_9_13/BLB 0.00159f
C4267 c_14_9/WL c_13_1/Q 0
C4268 c_9_2/QB c_9_3/Q 0.01135f
C4269 c_2_9/Q c_9_8/BLB 0.00303f
C4270 c_9_2/BL c_11_1/Q 0
C4271 c_8_10/QB c_9_9/VDD 0.00969f
C4272 c_0_1/QB c_1_9/WL 0
C4273 c_12_15/Q c_13_15/Q 0.00654f
C4274 c_13_13/QB c_13_12/QB 0
C4275 c_13_9/VDD c_12_6/Q 0.00756f
C4276 c_9_1/QB c_9_9/WL 0
C4277 c_3_9/VDD c_2_2/QB 0.00969f
C4278 c_12_15/QB c_9_14/BLB 0
C4279 c_3_0/Q c_9_1/BL 0
C4280 c_8_4/QB c_8_5/QB 0
C4281 c_14_9/WL c_15_5/QB 0
C4282 c_4_9/WL c_5_8/Q 0
C4283 c_13_9/WL c_12_7/Q 0
C4284 c_11_3/Q c_10_3/Q 0.00654f
C4285 c_10_9/WL c_9_7/BL 0.00159f
C4286 c_9_1/BL c_4_0/Q 0
C4287 c_7_9/VDD c_6_8/Q 0.00756f
C4288 c_12_4/Q c_13_4/QB 0
C4289 c_12_4/QB c_13_4/Q 0
C4290 c_11_9/VDD c_11_15/Q 0.00565f
C4291 c_6_11/QB c_6_10/QB 0
C4292 c_9_12/QB c_9_11/QB 0
C4293 c_8_1/QB c_7_1/QB 0.0025f
C4294 c_5_9/WL c_5_10/QB 0
C4295 c_6_9/WL c_6_12/QB 0
C4296 c_9_11/BL c_15_10/Q 0
C4297 c_5_8/QB c_4_9/WL 0
C4298 c_4_6/Q c_4_9/WL 0
C4299 c_11_9/WL c_12_14/QB 0
C4300 c_4_9/WL c_9_5/BL 0.00159f
C4301 c_8_1/QB c_8_2/QB 0
C4302 c_0_5/QB c_9_4/BLB 0
C4303 c_11_0/QB c_11_9/VDD 0.00777f
C4304 c_9_0/BLB c_4_9/WL 0.00159f
C4305 c_13_8/QB c_13_7/Q 0.00377f
C4306 c_6_9/WL c_9_3/BL 0.00159f
C4307 c_6_9/WL c_7_11/QB 0
C4308 c_12_2/Q c_12_1/QB 0.01135f
C4309 c_1_10/Q c_2_9/WL 0
C4310 c_1_0/QB c_1_9/VDD 0.00777f
C4311 c_7_9/VDD c_6_9/WL 0.04545f
C4312 c_3_0/Q c_2_9/WL 0
C4313 c_9_6/BLB c_15_9/VDD -0.004f
C4314 c_1_10/QB c_1_9/WL 0
C4315 c_3_14/QB c_4_9/WL 0
C4316 c_9_3/BLB c_5_9/VDD -0.004f
C4317 c_11_9/WL c_9_14/BLB 0.00159f
C4318 c_13_9/WL c_9_3/BL 0.00159f
C4319 c_13_9/WL c_12_3/Q 0
C4320 c_7_11/Q c_7_10/Q 0
C4321 c_6_9/WL c_7_6/Q 0
C4322 c_8_12/QB c_9_9/VDD 0.00969f
C4323 c_4_2/QB c_4_9/WL 0
C4324 c_12_15/QB c_11_15/QB 0.0025f
C4325 c_2_7/QB c_2_8/Q 0.01135f
C4326 c_13_14/QB c_13_9/WL 0
C4327 c_13_9/WL c_14_14/QB 0
C4328 c_8_13/QB c_8_14/QB 0
C4329 c_10_4/QB c_11_9/VDD 0.00969f
C4330 c_5_6/Q c_5_9/VDD 0.00756f
C4331 c_11_9/VDD c_9_13/BLB -0.004f
C4332 c_11_4/Q c_11_3/QB 0.01135f
C4333 c_7_9/VDD c_6_9/QB 0.00969f
C4334 c_9_1/BL c_5_0/Q 0
C4335 c_14_11/QB c_15_11/Q 0
C4336 c_10_3/QB c_10_2/Q 0.00377f
C4337 c_9_4/BLB c_5_5/QB 0
C4338 c_5_12/Q c_5_11/Q 0
C4339 c_2_5/QB c_3_9/WL 0
C4340 c_4_10/Q c_9_9/BLB 0.00303f
C4341 c_13_2/QB c_12_2/QB 0.01281f
C4342 c_9_3/BLB c_3_9/WL 0.00159f
C4343 c_9_1/BL c_15_9/WL 0.00122f
C4344 c_9_6/Q c_9_9/WL 0
C4345 c_7_15/QB c_7_14/Q 0.00377f
C4346 c_9_11/BL c_15_9/VDD -0.004f
C4347 c_12_9/WL c_11_11/QB 0
C4348 c_11_8/QB c_11_7/QB 0
C4349 c_3_5/Q c_3_4/Q 0
C4350 c_13_9/VDD c_12_11/Q 0.00756f
C4351 c_4_10/QB c_4_9/WL 0
C4352 c_6_8/QB c_7_9/WL 0
C4353 c_9_1/BLB c_10_9/WL 0.00159f
C4354 c_14_9/Q c_15_9/Q 0.00654f
C4355 c_12_12/Q c_12_11/Q 0
C4356 c_11_9/WL c_12_6/QB 0
C4357 c_8_9/WL c_9_10/QB 0
C4358 c_4_10/Q c_3_10/QB 0
C4359 c_11_9/VDD c_10_6/Q 0.00756f
C4360 c_10_11/Q c_9_11/Q 0.00634f
C4361 c_3_9/QB c_3_8/Q 0.00377f
C4362 c_8_9/WL c_9_2/BLB 0.00159f
C4363 c_10_9/WL c_9_15/QB 0
C4364 c_9_15/BL c_9_9/WL 0.00159f
C4365 c_14_4/Q c_13_9/WL 0
C4366 c_13_9/WL c_13_11/Q 0
C4367 c_9_15/BL c_15_14/QB 0.00303f
C4368 c_7_9/VDD c_9_5/BL -0.004f
C4369 c_9_4/BLB c_8_5/Q 0.00303f
C4370 c_7_9/VDD c_9_0/BLB -0.004f
C4371 c_1_6/Q c_0_9/WL 0
C4372 c_4_9/WL c_3_12/Q 0
C4373 c_0_4/QB c_9_5/BL 0.00303f
C4374 c_0_9/WL c_0_10/Q 0
C4375 c_6_9/WL c_7_1/Q 0
C4376 c_4_6/QB c_5_6/Q 0
C4377 c_8_2/Q c_9_9/WL 0
C4378 c_3_15/Q c_4_9/WL 0
C4379 c_9_12/BL c_1_9/VDD -0.004f
C4380 c_5_13/Q c_9_14/BL 0
C4381 c_3_9/VDD c_2_5/QB 0.00969f
C4382 c_4_2/QB c_3_2/QB 0.0025f
C4383 c_5_4/QB c_9_3/BLB 0
C4384 c_5_9/WL c_9_8/BL 0.00159f
C4385 c_5_9/WL c_4_11/QB 0
C4386 c_7_6/QB c_9_5/BLB 0
C4387 c_15_9/VDD c_14_3/QB 0.00969f
C4388 c_15_15/QB c_14_15/QB 0.01281f
C4389 c_9_12/Q c_8_12/QB 0
C4390 c_13_13/QB c_14_13/Q 0
C4391 c_13_9/VDD c_9_14/BL -0.004f
C4392 c_9_3/BLB c_3_9/VDD -0.004f
C4393 c_7_11/Q c_9_12/BL 0
C4394 c_2_5/QB c_2_4/QB 0
C4395 c_4_2/QB c_9_3/BL 0.00303f
C4396 c_7_10/Q c_7_9/WL 0
C4397 c_13_10/QB c_9_9/BLB 0
C4398 c_11_9/WL c_9_2/BL 0.00159f
C4399 c_9_3/BLB c_2_4/QB 0
C4400 c_9_14/BL c_10_13/QB 0.00303f
C4401 c_9_7/BLB c_3_8/QB 0
C4402 c_14_11/Q c_15_11/Q 0.00654f
C4403 c_13_14/Q c_13_15/QB 0.00377f
C4404 c_9_9/BL c_12_9/WL 0.00159f
C4405 c_2_9/WL c_1_2/QB 0
C4406 c_1_5/Q c_0_9/WL 0
C4407 c_7_3/QB c_6_9/WL 0
C4408 c_9_9/BL c_1_9/WL 0.00159f
C4409 c_8_9/WL c_9_0/QB 0
C4410 c_2_12/Q c_3_12/Q 0.00654f
C4411 c_9_12/Q c_10_12/Q 0.00634f
C4412 c_13_1/Q c_14_1/Q 0.00634f
C4413 c_8_0/QB c_9_9/WL 0
C4414 c_5_9/WL c_5_15/Q 0
C4415 c_10_5/QB c_9_6/BL 0.00303f
C4416 c_0_7/QB c_9_8/BL 0.00303f
C4417 c_2_2/QB c_2_3/QB 0
C4418 c_13_2/QB c_13_9/WL 0
C4419 c_2_5/Q c_3_5/QB 0
C4420 c_6_2/Q c_6_1/QB 0.01135f
C4421 c_6_2/QB c_6_1/Q 0.00377f
C4422 c_0_6/Q c_1_9/VDD 0.00756f
C4423 c_5_15/QB c_4_9/WL 0
C4424 c_2_9/WL c_1_8/QB 0
C4425 c_6_9/WL c_7_14/QB 0
C4426 c_12_7/QB c_12_9/WL 0
C4427 c_2_5/Q c_2_9/WL 0
C4428 c_14_4/Q c_9_5/BL 0
C4429 c_10_14/Q c_9_13/BLB 0.00303f
C4430 c_8_6/Q c_8_7/QB 0.00377f
C4431 c_9_9/BLB c_9_9/VDD -0.004f
C4432 c_4_7/Q c_5_9/VDD 0.00756f
C4433 c_0_15/Q c_1_15/QB 0
C4434 c_7_12/QB c_7_13/Q 0.01135f
C4435 c_14_9/WL c_14_8/Q 0
C4436 c_2_9/WL c_1_14/Q 0
C4437 c_6_6/Q c_6_5/Q 0
C4438 c_9_1/BLB c_8_2/QB 0
C4439 c_0_5/QB c_1_9/WL 0
C4440 c_6_1/Q c_7_9/WL 0
C4441 c_14_3/Q c_15_9/WL 0
C4442 c_9_7/BL c_9_6/QB 0.00303f
C4443 c_8_9/WL c_9_10/BL 0.00159f
C4444 c_9_12/QB c_9_13/Q 0.01135f
C4445 c_0_8/Q c_0_9/Q 0
C4446 c_11_9/VDD c_9_8/BL -0.004f
C4447 c_9_0/BLB c_7_1/Q 0.00303f
C4448 c_2_3/Q c_2_2/Q 0
C4449 c_5_9/WL c_6_9/Q 0
C4450 c_11_4/QB c_12_9/WL 0
C4451 c_4_14/QB c_5_9/VDD 0.00969f
C4452 c_4_14/Q c_4_9/WL 0
C4453 c_9_10/BLB c_11_11/QB 0
C4454 c_11_5/QB c_11_9/VDD 0.00969f
C4455 c_9_4/Q c_10_9/WL 0
C4456 c_3_9/QB c_9_10/BL 0.00303f
C4457 c_1_5/Q c_0_5/Q 0.00654f
C4458 c_5_9/WL c_4_15/Q 0
C4459 c_8_9/WL c_9_8/BLB 0.00159f
C4460 c_9_8/QB c_10_8/Q 0
C4461 c_2_14/Q c_2_15/QB 0.00377f
C4462 c_4_9/WL c_9_9/BLB 0.00159f
C4463 c_3_10/Q c_9_11/BL 0
C4464 c_4_7/Q c_3_9/WL 0
C4465 c_14_0/Q c_9_1/BL 0
C4466 c_8_1/Q c_9_2/BL 0
C4467 c_9_12/BL c_7_9/WL 0.00159f
C4468 c_10_2/Q c_10_9/WL 0
C4469 c_6_13/QB c_9_14/BL 0.00303f
C4470 c_9_7/BLB c_9_9/VDD -0.004f
C4471 c_5_14/QB c_4_14/QB 0.01281f
C4472 c_9_2/BLB c_15_3/QB 0
C4473 c_5_9/WL c_6_10/Q 0
C4474 c_11_13/QB c_9_14/BL 0.00303f
C4475 c_11_9/WL c_10_3/QB 0
C4476 c_11_3/Q c_11_4/Q 0
C4477 c_10_9/WL c_11_1/Q 0
C4478 c_3_9/QB c_9_8/BLB 0
C4479 c_14_9/WL c_15_15/Q 0
C4480 c_0_4/Q c_0_3/Q 0
C4481 c_15_7/Q c_9_8/BL 0
C4482 c_9_11/BLB c_9_9/VDD -0.004f
C4483 c_8_13/QB c_9_14/BL 0.00303f
C4484 c_4_9/WL c_3_10/QB 0
C4485 c_4_6/QB c_4_7/Q 0.01135f
C4486 c_0_14/QB c_9_13/BLB 0
C4487 c_9_2/BL c_13_1/Q 0
C4488 c_0_9/WL c_9_14/BL 0.00122f
C4489 c_13_9/Q c_9_10/BL 0
C4490 c_5_11/QB c_4_9/WL 0
C4491 c_2_9/QB c_2_10/Q 0.01135f
C4492 c_2_9/Q c_2_10/QB 0.00377f
C4493 c_4_14/QB c_3_9/WL 0
C4494 c_15_2/QB c_15_9/WL 0
C4495 c_11_9/VDD c_11_11/Q 0.00756f
C4496 c_9_12/QB c_9_9/VDD 0.00969f
C4497 c_12_6/QB c_12_5/Q 0.00377f
C4498 c_12_6/Q c_12_5/QB 0.01135f
C4499 c_15_11/Q c_9_10/BLB 0.00303f
C4500 c_14_9/WL c_14_7/QB 0
C4501 c_12_6/Q c_9_7/BL 0
C4502 c_7_9/VDD c_7_13/QB 0.00969f
C4503 c_11_12/QB c_12_9/WL 0
C4504 c_6_10/Q c_5_10/Q 0.00634f
C4505 c_15_7/Q c_14_7/Q 0.00654f
C4506 c_8_9/WL c_7_4/Q 0
C4507 c_15_10/QB c_15_9/WL 0
C4508 c_14_9/WL c_15_13/QB 0
C4509 c_12_9/WL c_11_14/Q 0
C4510 c_10_9/WL c_9_10/BLB 0.00159f
C4511 c_4_1/Q c_4_9/WL 0
C4512 c_13_8/QB c_12_9/WL 0
C4513 c_1_5/Q c_9_4/BLB 0.00303f
C4514 c_1_6/Q c_9_7/BL 0
C4515 c_9_3/QB c_9_9/VDD 0.00969f
C4516 c_8_9/WL c_7_2/Q 0
C4517 c_9_9/BL c_12_8/Q 0
C4518 c_7_10/QB c_7_9/Q 0.00377f
C4519 c_13_9/Q c_9_8/BLB 0.00303f
C4520 c_8_9/Q c_9_9/VDD 0.00756f
C4521 c_1_0/QB c_0_0/Q 0
C4522 c_9_7/BLB c_4_9/WL 0.00159f
C4523 c_9_1/QB c_9_0/QB 0
C4524 c_6_9/WL c_6_11/Q 0
C4525 c_7_9/VDD c_7_5/QB 0.00969f
C4526 c_9_8/BL c_9_8/BLB -0
C4527 c_2_12/QB c_2_13/QB 0
C4528 c_15_5/Q c_15_6/QB 0.00377f
C4529 c_11_7/Q c_11_9/VDD 0.00756f
C4530 c_10_9/WL c_9_5/Q 0
C4531 c_6_9/WL c_9_6/BLB 0.00159f
C4532 c_14_4/QB c_15_4/Q 0
C4533 c_5_14/QB c_6_14/QB 0.0025f
C4534 c_8_9/WL c_9_1/Q 0
C4535 c_4_9/WL c_9_11/BLB 0.00159f
C4536 c_12_8/Q c_12_7/QB 0.01135f
C4537 c_13_9/WL c_13_4/QB 0
C4538 c_11_13/Q c_11_9/VDD 0.00756f
C4539 c_7_5/Q c_7_6/QB 0.00377f
C4540 c_7_5/QB c_7_6/Q 0.01135f
C4541 c_6_4/QB c_6_3/Q 0.00377f
C4542 c_1_13/Q c_2_13/QB 0
C4543 c_1_13/QB c_2_13/Q 0
C4544 c_10_9/WL c_10_13/Q 0
C4545 c_1_10/Q c_0_9/WL 0
C4546 c_13_9/WL c_9_6/BLB 0.00159f
C4547 c_4_5/Q c_9_6/BL 0
C4548 c_15_9/VDD c_14_5/QB 0.00969f
C4549 c_4_13/QB c_9_14/BL 0.00303f
C4550 c_11_6/Q c_10_6/Q 0.00654f
C4551 c_5_9/WL c_9_15/BL 0.00159f
C4552 c_12_14/Q c_12_9/WL 0
C4553 c_12_4/Q c_9_3/BLB 0.00303f
C4554 c_15_7/QB c_15_9/WL 0
C4555 c_9_14/BL c_13_13/Q 0
C4556 c_14_9/WL c_9_12/BL 0.00159f
C4557 c_7_9/VDD c_9_9/BLB -0.004f
C4558 c_10_9/WL c_10_10/QB 0
C4559 c_1_0/QB c_1_1/Q 0.01135f
C4560 c_0_9/WL c_0_3/Q 0
C4561 c_14_9/WL c_13_15/QB 0
C4562 c_6_6/Q c_6_7/Q 0
C4563 c_2_9/WL c_3_11/QB 0
C4564 c_0_9/WL c_0_12/QB 0
C4565 c_2_12/Q c_9_11/BLB 0.00303f
C4566 c_10_4/Q c_9_9/WL 0
C4567 c_7_9/VDD c_7_7/QB 0.00969f
C4568 c_9_12/Q c_9_11/BLB 0.00303f
C4569 c_11_8/Q c_9_7/BLB 0.00303f
C4570 c_3_2/Q c_9_1/BLB 0.00303f
C4571 c_13_11/QB c_13_10/Q 0.00377f
C4572 c_9_3/BLB c_15_9/VDD -0.004f
C4573 c_6_9/Q c_9_10/BL 0
C4574 c_5_2/QB c_4_9/WL 0
C4575 c_11_9/VDD c_11_6/QB 0.00969f
C4576 c_6_9/WL c_9_11/BL 0.00159f
C4577 c_9_1/BL c_13_0/Q 0
C4578 c_8_11/QB c_9_10/BLB 0
C4579 c_9_2/QB c_9_3/QB 0
C4580 c_15_9/VDD c_14_14/Q 0.00756f
C4581 c_11_9/WL c_11_11/QB 0
C4582 c_7_7/QB c_7_6/Q 0.00377f
C4583 c_7_7/Q c_7_6/QB 0.01135f
C4584 c_15_8/Q c_9_7/BLB 0.00303f
C4585 c_10_1/QB c_10_2/QB 0
C4586 c_6_5/Q c_5_5/QB 0
C4587 c_2_7/Q c_1_9/WL 0
C4588 c_7_12/QB c_6_12/QB 0.01281f
C4589 c_2_9/WL c_2_15/Q 0
C4590 c_6_2/Q c_6_3/QB 0.00377f
C4591 c_1_10/Q c_1_11/Q 0
C4592 c_13_9/WL c_9_11/BL 0.00159f
C4593 c_14_2/QB c_14_3/Q 0.01135f
C4594 c_1_9/WL c_2_15/QB 0
C4595 c_6_9/WL c_5_1/QB 0
C4596 c_9_9/WL c_9_10/QB 0
C4597 c_4_7/QB c_5_7/Q 0
C4598 c_6_9/Q c_9_8/BLB 0.00303f
C4599 c_13_4/QB c_9_5/BL 0.00303f
C4600 c_9_2/BL c_12_1/Q 0
C4601 c_9_9/WL c_9_2/BLB 0.00159f
C4602 c_7_8/Q c_8_9/WL 0
C4603 c_7_12/QB c_7_11/QB 0
C4604 c_6_12/QB c_9_11/BLB 0
C4605 c_1_3/Q c_2_3/QB 0
C4606 c_5_1/Q c_5_9/VDD 0.00756f
C4607 c_7_12/QB c_7_9/VDD 0.00969f
C4608 c_9_6/BL c_9_5/BLB 2.55595f
C4609 c_7_9/VDD c_9_7/BLB -0.004f
C4610 c_9_4/BL c_4_3/QB 0.00303f
C4611 c_13_6/QB c_14_9/WL 0
C4612 c_10_14/QB c_10_13/QB 0
C4613 c_1_4/QB c_9_5/BL 0.00303f
C4614 c_3_3/QB c_3_4/Q 0.01135f
C4615 c_2_6/QB c_9_7/BL 0.00303f
C4616 c_3_14/Q c_9_13/BLB 0.00303f
C4617 c_3_11/Q c_3_12/QB 0.00377f
C4618 c_2_12/QB c_3_9/WL 0
C4619 c_9_3/BLB c_15_4/QB 0
C4620 c_6_12/Q c_6_13/QB 0.00377f
C4621 c_6_6/QB c_9_7/BL 0.00303f
C4622 c_13_0/QB c_12_9/WL 0
C4623 c_8_14/Q c_9_14/QB 0
C4624 c_7_9/VDD c_9_11/BLB -0.004f
C4625 c_9_14/BLB c_5_9/VDD -0.004f
C4626 c_9_15/BL c_11_9/VDD -0.004f
C4627 c_12_13/QB c_12_14/QB 0
C4628 c_13_9/WL c_13_15/Q 0
C4629 c_0_1/QB c_0_2/Q 0.01135f
C4630 c_12_8/Q c_13_8/QB 0
C4631 c_7_15/Q c_7_14/Q 0
C4632 c_3_8/QB c_3_7/QB 0
C4633 c_7_4/QB c_8_9/WL 0
C4634 c_13_9/WL c_14_3/QB 0
C4635 c_11_9/WL c_10_9/WL 0.06483f
C4636 c_1_1/QB c_9_0/BLB 0
C4637 c_4_10/Q c_4_9/QB 0.01135f
C4638 c_9_11/BL c_12_10/Q 0
C4639 c_12_6/Q c_12_9/WL 0
C4640 c_10_7/Q c_10_9/WL 0
C4641 c_6_4/QB c_7_9/VDD 0.00969f
C4642 c_7_13/QB c_7_14/QB 0
C4643 c_1_4/QB c_2_4/Q 0
C4644 c_14_9/Q c_15_9/WL 0
C4645 c_11_9/WL c_9_9/BL 0.00159f
C4646 c_10_8/Q c_9_9/WL 0
C4647 c_10_9/WL c_11_2/Q 0
C4648 c_9_0/QB c_9_9/WL 0
C4649 c_1_6/Q c_1_9/WL 0
C4650 c_9_9/BL c_2_8/Q 0
C4651 c_0_10/Q c_1_9/WL 0
C4652 c_15_15/Q c_9_14/BLB 0.00303f
C4653 c_14_2/QB c_15_2/QB 0.01281f
C4654 c_2_7/QB c_2_8/QB 0
C4655 c_3_1/QB c_3_9/WL 0
C4656 c_1_10/Q c_2_10/Q 0.00634f
C4657 c_11_5/QB c_11_6/Q 0.01135f
C4658 c_2_9/Q c_2_9/WL 0
C4659 c_0_9/WL c_1_2/QB 0
C4660 c_9_3/BL c_5_2/QB 0.00303f
C4661 c_13_7/QB c_9_8/BL 0.00303f
C4662 c_11_9/WL c_12_7/QB 0
C4663 c_10_9/WL c_9_15/BLB 0
C4664 c_0_14/Q c_1_14/Q 0.00654f
C4665 c_13_9/WL c_13_10/Q 0
C4666 c_2_9/QB c_1_9/WL 0
C4667 c_3_9/VDD c_2_12/QB 0.00969f
C4668 c_9_5/Q c_8_5/Q 0.00654f
C4669 c_9_11/BL c_8_10/QB 0.00303f
C4670 c_6_9/WL c_5_3/QB 0
C4671 c_6_1/Q c_5_1/Q 0.00634f
C4672 c_10_1/Q c_9_0/BLB 0.00303f
C4673 c_9_13/BL c_9_9/VDD -0.004f
C4674 c_9_14/BLB c_3_9/WL 0.00159f
C4675 c_2_7/QB c_3_9/WL 0
C4676 c_14_9/WL c_15_10/Q 0
C4677 c_14_9/QB c_13_9/Q 0
C4678 c_9_0/BL c_9_9/VDD -0.01128f
C4679 c_0_5/QB c_0_6/QB 0
C4680 c_1_5/Q c_1_9/WL 0
C4681 c_0_9/WL c_1_8/QB 0
C4682 c_5_9/Q c_5_10/QB 0.00377f
C4683 c_9_0/BLB c_5_1/QB 0
C4684 c_4_11/Q c_3_11/Q 0.00634f
C4685 c_13_7/QB c_14_7/Q 0
C4686 c_14_9/QB c_14_10/QB 0
C4687 c_11_8/Q c_10_8/QB 0
C4688 c_8_0/QB c_9_0/QB 0.01281f
C4689 c_0_12/QB c_1_12/Q 0
C4690 c_6_9/WL c_6_0/QB 0
C4691 c_9_10/BL c_9_9/WL 0.00159f
C4692 c_8_1/Q c_8_0/Q 0
C4693 c_13_9/WL c_13_9/QB 0
C4694 c_0_3/Q c_0_2/QB 0.01135f
C4695 c_0_9/WL c_1_14/Q 0
C4696 c_2_6/Q c_3_6/QB 0
C4697 c_11_5/Q c_11_4/Q 0
C4698 c_7_9/VDD c_7_6/QB 0.00969f
C4699 c_3_13/QB c_3_12/QB 0
C4700 c_11_9/WL c_11_4/QB 0
C4701 c_6_9/WL c_6_5/QB 0
C4702 c_3_1/QB c_3_9/VDD 0.00969f
C4703 c_15_13/QB c_14_13/Q 0
C4704 c_14_5/Q c_15_9/WL 0
C4705 c_13_10/Q c_12_10/Q 0.00654f
C4706 c_4_9/WL c_9_13/BL 0.00159f
C4707 c_9_12/BLB c_15_9/WL 0.00122f
C4708 c_9_9/WL c_9_8/BLB 0.00159f
C4709 c_9_11/QB c_9_9/VDD 0.00969f
C4710 c_9_5/Q c_9_6/QB 0.00377f
C4711 c_8_3/QB c_8_4/QB 0
C4712 c_9_0/BL c_4_9/WL 0
C4713 c_3_9/VDD c_9_14/BLB -0.004f
C4714 c_4_14/QB c_4_15/QB 0
C4715 c_8_10/Q c_8_11/Q 0
C4716 c_7_7/Q c_7_8/QB 0.00377f
C4717 c_9_2/BLB c_13_3/QB 0
C4718 c_11_7/Q c_11_6/Q 0
C4719 c_2_7/QB c_3_9/VDD 0.00969f
C4720 c_9_2/BL c_5_9/VDD -0.004f
C4721 c_4_10/QB c_9_11/BL 0.00303f
C4722 c_15_9/VDD c_15_0/Q 0.00266f
C4723 c_13_15/QB c_9_14/BLB 0
C4724 c_12_11/Q c_12_9/WL 0
C4725 c_2_2/Q c_3_9/WL 0
C4726 c_5_9/WL c_5_2/Q 0
C4727 c_9_4/BL c_8_9/WL 0.00159f
C4728 c_11_0/QB c_9_1/BL 0.00303f
C4729 c_0_9/WL c_0_11/QB 0
C4730 c_5_9/WL c_4_3/Q 0
C4731 c_12_0/Q c_13_9/WL 0
C4732 c_14_12/QB c_14_13/QB 0
C4733 c_9_15/BL c_10_14/Q 0
C4734 c_8_9/QB c_7_9/WL 0
C4735 c_2_6/Q c_2_9/WL 0
C4736 c_5_9/WL c_4_8/QB 0
C4737 c_14_9/WL c_15_9/VDD 0.04545f
C4738 c_2_6/QB c_1_9/WL 0
C4739 c_2_12/Q c_9_13/BL 0
C4740 c_4_5/Q c_4_9/WL 0
C4741 c_9_4/BLB c_15_9/WL 0.00122f
C4742 c_9_11/BL c_10_10/Q 0
C4743 c_9_3/BL c_12_2/Q 0
C4744 c_12_2/Q c_12_3/Q 0
C4745 c_9_12/Q c_9_13/BL 0
C4746 c_10_2/QB c_9_2/QB 0.0025f
C4747 c_2_1/Q c_1_9/WL 0
C4748 c_4_8/QB c_3_8/Q 0
C4749 c_11_9/WL c_11_12/QB 0
C4750 c_10_14/Q c_9_9/WL 0
C4751 c_10_9/WL c_9_9/Q 0
C4752 c_12_14/Q c_12_15/QB 0.00377f
C4753 c_11_9/WL c_11_14/Q 0
C4754 c_6_1/Q c_6_0/Q 0
C4755 c_10_9/QB c_9_9/WL 0
C4756 c_8_8/Q c_8_7/Q 0
C4757 c_4_9/WL c_3_7/QB 0
C4758 c_7_2/Q c_8_2/Q 0.00634f
C4759 c_13_9/VDD c_13_0/Q 0.00266f
C4760 c_4_3/Q c_9_2/BLB 0.00303f
C4761 c_12_14/QB c_12_15/Q 0.01135f
C4762 c_9_5/BLB c_9_9/VDD -0.004f
C4763 c_9_2/BL c_3_9/WL 0.00159f
C4764 c_7_5/Q c_9_6/BL 0
C4765 c_15_0/Q c_15_1/QB 0.00377f
C4766 c_12_4/QB c_11_4/QB 0.0025f
C4767 c_6_7/Q c_5_7/Q 0.00634f
C4768 c_9_2/Q c_9_3/Q 0
C4769 c_9_14/BL c_12_9/WL 0.00159f
C4770 c_9_14/BL c_1_9/WL 0.00159f
C4771 c_4_9/QB c_4_9/WL 0
C4772 c_9_7/BL c_15_9/WL 0.00122f
C4773 c_9_1/Q c_9_9/WL 0
C4774 c_3_9/VDD c_2_2/Q 0.00756f
C4775 c_12_15/Q c_9_14/BLB 0.00303f
C4776 c_6_12/QB c_9_13/BL 0.00303f
C4777 c_1_11/Q c_0_11/QB 0
C4778 c_6_1/Q c_9_2/BL 0
C4779 c_8_4/QB c_8_5/Q 0.01135f
C4780 c_14_9/WL c_15_1/QB 0
C4781 c_4_11/QB c_4_12/Q 0.01135f
C4782 c_14_9/WL c_15_4/QB 0
C4783 c_13_2/QB c_13_1/QB 0
C4784 c_3_15/QB c_9_14/BLB 0
C4785 c_12_4/Q c_13_4/Q 0.00654f
C4786 c_6_11/QB c_6_10/Q 0.00377f
C4787 c_1_2/QB c_0_2/QB 0.01281f
C4788 c_2_5/Q c_9_4/BLB 0.00303f
C4789 c_9_12/QB c_9_11/Q 0.00377f
C4790 c_9_12/Q c_9_11/QB 0.01135f
C4791 c_8_1/Q c_7_1/QB 0
C4792 c_9_6/BL c_9_9/VDD -0.004f
C4793 c_5_9/WL c_9_2/BLB 0.00159f
C4794 c_5_9/WL c_5_10/Q 0
C4795 c_10_11/QB c_11_11/Q 0
C4796 c_2_11/QB c_3_11/QB 0.01281f
C4797 c_2_9/WL c_9_13/BLB 0.00159f
C4798 c_13_9/WL c_14_5/QB 0
C4799 c_11_9/WL c_12_14/Q 0
C4800 c_7_9/VDD c_9_13/BL -0.004f
C4801 c_6_15/Q c_6_14/Q 0
C4802 c_14_9/WL c_15_8/QB 0
C4803 c_9_0/BL c_7_9/VDD -0.01128f
C4804 c_9_15/BL c_0_14/QB 0.00303f
C4805 c_4_9/WL c_9_5/BLB 0.00159f
C4806 c_11_0/Q c_11_9/VDD 0.00266f
C4807 c_8_1/Q c_8_2/QB 0.00377f
C4808 c_10_2/QB c_9_3/BL 0.00303f
C4809 c_6_9/WL c_9_3/BLB 0.00159f
C4810 c_6_9/WL c_7_11/Q 0
C4811 c_7_7/QB c_9_6/BLB 0
C4812 c_14_7/Q c_14_8/QB 0.00377f
C4813 c_9_2/BL c_3_9/VDD -0.004f
C4814 c_1_10/Q c_1_9/WL 0
C4815 c_6_11/Q c_5_11/QB 0
C4816 c_6_13/QB c_6_14/Q 0.01135f
C4817 c_10_6/QB c_11_6/QB 0.01281f
C4818 c_5_12/QB c_5_9/VDD 0.00969f
C4819 c_13_9/WL c_9_3/BLB 0.00159f
C4820 c_1_15/Q c_2_9/WL 0
C4821 c_13_6/QB c_12_6/QB 0.01281f
C4822 c_13_3/QB c_12_3/QB 0.01281f
C4823 c_14_6/QB c_14_5/Q 0.00377f
C4824 c_6_9/WL c_5_6/Q 0
C4825 c_12_15/Q c_11_15/QB 0
C4826 c_2_7/Q c_2_8/Q 0
C4827 c_7_9/VDD c_7_8/QB 0.00969f
C4828 c_13_9/WL c_14_14/Q 0
C4829 c_13_14/Q c_13_9/WL 0
C4830 c_8_13/Q c_8_14/QB 0.00377f
C4831 c_1_9/WL c_0_3/Q 0
C4832 c_2_1/QB c_3_9/WL 0
C4833 c_10_4/Q c_11_9/VDD 0.00756f
C4834 c_9_6/BL c_4_9/WL 0.00159f
C4835 c_5_5/Q c_5_4/Q 0
C4836 c_14_11/QB c_15_9/WL 0
C4837 c_0_12/QB c_1_9/WL 0
C4838 c_8_7/Q c_8_6/QB 0.01135f
C4839 c_2_14/Q c_1_14/Q 0.00634f
C4840 c_8_9/WL c_9_1/BL 0.00159f
C4841 c_6_5/Q c_6_6/QB 0.00377f
C4842 c_10_3/Q c_10_2/Q 0
C4843 c_12_11/Q c_9_10/BLB 0.00303f
C4844 c_10_6/QB c_9_6/Q 0
C4845 c_9_4/BL c_15_3/QB 0.00303f
C4846 c_15_12/Q c_15_13/QB 0.00377f
C4847 c_4_9/WL c_4_1/QB 0
C4848 c_7_12/Q c_6_9/WL 0
C4849 c_4_13/QB c_4_12/QB 0
C4850 c_13_2/Q c_12_2/QB 0
C4851 c_13_2/QB c_12_2/Q 0
C4852 c_5_9/Q c_6_9/Q 0.00634f
C4853 c_9_1/BLB c_15_9/WL 0.00122f
C4854 c_9_11/BL c_3_10/QB 0.00303f
C4855 c_11_9/VDD c_9_2/BLB -0.004f
C4856 c_6_2/QB c_6_9/WL 0
C4857 c_9_7/BL c_8_6/QB 0.00303f
C4858 c_9_4/QB c_10_4/QB 0.0025f
C4859 c_13_11/QB c_13_12/Q 0.01135f
C4860 c_6_8/Q c_7_9/WL 0
C4861 c_3_3/QB c_3_2/Q 0.00377f
C4862 c_1_6/Q c_0_6/QB 0
C4863 c_9_14/BL c_3_13/Q 0
C4864 c_13_7/QB c_13_8/Q 0.01135f
C4865 c_11_9/WL c_12_6/Q 0
C4866 c_8_9/WL c_9_10/Q 0
C4867 c_3_9/Q c_3_8/Q 0
C4868 c_1_9/VDD c_9_5/BL -0.004f
C4869 c_3_9/VDD c_2_1/QB 0.00969f
C4870 c_5_9/WL c_9_10/BL 0.00159f
C4871 c_4_15/QB c_9_14/BLB 0
C4872 c_8_9/WL c_8_4/Q 0
C4873 c_9_0/BLB c_1_9/VDD -0.004f
C4874 c_10_6/QB c_9_9/WL 0
C4875 c_9_1/BLB c_1_2/QB 0
C4876 c_7_9/VDD c_9_5/BLB -0.004f
C4877 c_15_6/Q c_14_9/WL 0
C4878 c_9_13/Q c_9_9/VDD 0.00756f
C4879 c_11_10/QB c_11_11/QB 0
C4880 c_9_7/BL c_14_6/QB 0.00303f
C4881 c_6_9/WL c_7_9/WL 0.06483f
C4882 c_0_8/Q c_9_9/BL 0
C4883 c_4_6/Q c_5_6/Q 0.00654f
C4884 c_4_10/Q c_4_9/WL 0
C4885 c_6_4/Q c_5_4/Q 0.00634f
C4886 c_3_9/QB c_2_9/WL 0
C4887 c_4_1/Q c_5_1/QB 0
C4888 c_15_9/VDD c_9_14/BLB -0.004f
C4889 c_2_0/QB c_2_1/QB 0
C4890 c_5_9/WL c_9_8/BLB 0.00159f
C4891 c_5_9/WL c_4_11/Q 0
C4892 c_7_6/Q c_9_5/BLB 0.00303f
C4893 c_15_15/Q c_14_15/QB 0
C4894 c_13_11/QB c_14_9/WL 0
C4895 c_2_9/QB c_2_8/Q 0.00377f
C4896 c_3_0/QB c_3_9/WL 0
C4897 c_9_11/BL c_9_11/BLB -0
C4898 c_11_9/VDD c_10_8/Q 0.00756f
C4899 c_3_8/QB c_4_9/WL 0
C4900 c_6_8/QB c_6_7/QB 0
C4901 c_2_5/QB c_2_4/Q 0.00377f
C4902 c_14_1/Q c_15_9/VDD 0.00756f
C4903 c_6_2/Q c_9_1/BLB 0.00303f
C4904 c_2_9/WL c_1_11/QB 0
C4905 c_13_10/Q c_9_9/BLB 0.00303f
C4906 c_9_3/BLB c_2_4/Q 0.00303f
C4907 c_14_11/Q c_15_9/WL 0
C4908 c_9_14/BL c_10_13/Q 0
C4909 c_5_9/WL c_6_13/Q 0
C4910 c_7_9/VDD c_9_6/BL -0.004f
C4911 c_3_14/Q c_9_15/BL 0
C4912 c_7_3/Q c_6_9/WL 0
C4913 c_2_9/WL c_1_2/Q 0
C4914 c_6_9/QB c_7_9/WL 0
C4915 c_9_2/BLB c_12_3/QB 0
C4916 c_1_2/QB c_1_9/WL 0
C4917 c_5_0/QB c_5_9/VDD 0.00777f
C4918 c_6_8/QB c_9_9/BL 0.00303f
C4919 c_9_9/WL c_10_11/QB 0
C4920 c_2_9/WL c_9_8/BL 0.00159f
C4921 c_15_9/VDD c_14_13/Q 0.00756f
C4922 c_2_2/Q c_2_3/QB 0.00377f
C4923 c_7_5/QB c_6_5/QB 0.01281f
C4924 c_10_5/Q c_9_6/BL 0
C4925 c_0_7/Q c_9_8/BL 0
C4926 c_13_9/VDD c_9_13/BLB -0.004f
C4927 c_13_2/Q c_13_9/WL 0
C4928 c_2_5/Q c_3_5/Q 0.00654f
C4929 c_9_9/BL c_14_8/Q 0
C4930 c_11_10/QB c_10_9/WL 0
C4931 c_4_7/QB c_5_7/QB 0.01281f
C4932 c_13_9/VDD c_13_5/QB 0.00969f
C4933 c_1_9/WL c_1_8/QB 0
C4934 c_11_1/QB c_11_2/QB 0
C4935 c_2_5/Q c_1_9/WL 0
C4936 c_4_2/Q c_4_1/Q 0
C4937 c_14_1/Q c_15_1/QB 0
C4938 c_14_9/WL c_14_1/QB 0
C4939 c_11_9/VDD c_9_10/BL -0.004f
C4940 c_3_0/QB c_3_9/VDD 0.00777f
C4941 c_0_4/QB c_0_3/QB 0
C4942 c_9_4/QB c_8_9/WL 0
C4943 c_13_9/WL c_13_12/Q 0
C4944 c_3_4/Q c_3_9/WL 0
C4945 c_6_7/Q c_6_6/QB 0.01135f
C4946 c_14_15/Q c_14_14/QB 0.01135f
C4947 c_13_11/QB c_13_12/QB 0
C4948 c_13_1/Q c_13_0/QB 0.01135f
C4949 c_5_2/QB c_5_1/QB 0
C4950 c_11_9/WL c_12_11/Q 0
C4951 c_9_9/BL c_5_9/VDD -0.004f
C4952 c_9_4/BL c_9_9/WL 0.00159f
C4953 c_1_9/WL c_1_14/Q 0
C4954 c_2_14/QB c_1_14/QB 0.0025f
C4955 c_14_4/QB c_13_4/QB 0.0025f
C4956 c_12_12/QB c_11_12/Q 0
C4957 c_9_12/Q c_9_13/Q 0
C4958 c_9_7/Q c_9_8/Q 0
C4959 c_9_5/BL c_7_9/WL 0.00159f
C4960 c_11_9/VDD c_9_8/BLB -0.004f
C4961 c_3_0/QB c_2_0/QB 0.01281f
C4962 c_9_0/BLB c_7_9/WL 0.00159f
C4963 c_8_9/WL c_8_3/Q 0
C4964 c_14_15/QB c_13_15/QB 0.0025f
C4965 c_12_9/QB c_13_9/Q 0
C4966 c_11_4/Q c_12_9/WL 0
C4967 c_8_10/QB c_7_9/WL 0
C4968 c_1_9/Q c_9_10/BL 0
C4969 c_3_9/Q c_9_10/BL 0
C4970 c_3_14/Q c_3_13/QB 0.01135f
C4971 c_3_4/QB c_4_4/QB 0.0025f
C4972 c_9_9/BL c_2_8/QB 0.00303f
C4973 c_2_14/Q c_2_15/Q 0
C4974 c_5_3/Q c_5_4/Q 0
C4975 c_14_9/WL c_13_9/WL 0.8704f
C4976 c_9_2/BL c_15_9/VDD -0.004f
C4977 c_11_12/Q c_11_11/Q 0
C4978 c_7_12/Q c_8_12/QB 0
C4979 c_5_14/Q c_4_14/QB 0
C4980 c_9_12/BL c_11_11/QB 0.00303f
C4981 c_1_3/QB c_0_3/QB 0.01281f
C4982 c_9_2/BLB c_15_3/Q 0.00303f
C4983 c_11_9/WL c_10_3/Q 0
C4984 c_0_11/QB c_1_9/WL 0
C4985 c_5_9/WL c_5_6/QB 0
C4986 c_13_8/Q c_14_8/QB 0
C4987 c_11_9/WL c_9_14/BL 0.00159f
C4988 c_14_2/QB c_9_1/BLB 0
C4989 c_9_2/QB c_9_9/VDD 0.00969f
C4990 c_1_9/Q c_9_8/BLB 0.00303f
C4991 c_3_4/Q c_3_9/VDD 0.00756f
C4992 c_9_9/BL c_3_9/WL 0.00159f
C4993 c_3_9/Q c_9_8/BLB 0.00303f
C4994 c_4_2/Q c_5_2/QB 0
C4995 c_15_9/QB c_15_10/Q 0.01135f
C4996 c_8_13/Q c_9_14/BL 0
C4997 c_0_14/Q c_9_13/BLB 0.00303f
C4998 c_4_6/Q c_4_7/Q 0
C4999 c_11_9/VDD c_10_14/Q 0.00756f
C5000 c_3_4/Q c_2_4/QB 0
C5001 c_10_9/QB c_11_9/VDD 0.00969f
C5002 c_8_9/WL c_9_5/QB 0
C5003 c_10_9/QB c_10_8/Q 0.00377f
C5004 c_9_10/BLB c_15_9/WL 0.00122f
C5005 c_15_2/Q c_15_9/WL 0
C5006 c_2_9/Q c_2_10/Q 0
C5007 c_12_6/Q c_12_5/Q 0
C5008 c_9_12/Q c_9_9/VDD 0.00756f
C5009 c_6_9/WL c_6_14/QB 0
C5010 c_12_11/QB c_11_11/QB 0.0025f
C5011 c_5_13/QB c_4_9/WL 0
C5012 c_2_9/WL c_1_4/Q 0
C5013 c_11_13/Q c_11_12/Q 0
C5014 c_14_9/WL c_15_13/Q 0
C5015 c_7_9/VDD c_7_13/Q 0.00756f
C5016 c_5_3/QB c_5_2/QB 0
C5017 c_10_9/WL c_9_13/QB 0
C5018 c_9_2/BL c_15_1/QB 0.00303f
C5019 c_8_12/QB c_7_9/WL 0
C5020 c_9_12/BL c_15_11/Q 0
C5021 c_9_1/Q c_9_0/QB 0.01135f
C5022 c_9_14/Q c_9_13/Q 0
C5023 c_7_9/VDD c_7_5/Q 0.00756f
C5024 c_2_12/QB c_2_13/Q 0.01135f
C5025 c_6_4/QB c_6_5/QB 0
C5026 c_9_12/BL c_10_9/WL 0.00159f
C5027 c_0_9/WL c_9_13/BLB 0.00122f
C5028 c_13_9/WL c_13_12/QB 0
C5029 c_7_9/VDD c_7_0/QB 0.00777f
C5030 c_14_4/Q c_15_4/Q 0.00654f
C5031 c_13_8/QB c_14_8/Q 0
C5032 c_5_14/Q c_6_14/QB 0
C5033 c_5_9/VDD c_5_5/QB 0.00969f
C5034 c_14_9/WL c_9_5/BL 0.00159f
C5035 c_9_9/BL c_3_9/VDD -0.004f
C5036 c_13_9/WL c_13_4/Q 0
C5037 c_14_9/WL c_9_0/BLB 0.00159f
C5038 c_7_5/Q c_7_6/Q 0
C5039 c_9_14/BL c_13_13/QB 0.00303f
C5040 c_1_13/Q c_2_13/Q 0.00634f
C5041 c_3_14/QB c_4_14/QB 0.0025f
C5042 c_14_4/QB c_14_3/QB 0
C5043 c_10_9/QB c_9_10/BL 0.00303f
C5044 c_0_15/QB c_1_9/VDD 0.00479f
C5045 c_4_13/Q c_9_14/BL 0
C5046 c_1_9/VDD c_9_9/BLB -0.004f
C5047 c_9_3/BL c_9_9/VDD -0.004f
C5048 c_5_9/WL c_6_11/QB 0
C5049 c_1_12/QB c_2_9/WL 0
C5050 c_14_3/Q c_15_3/QB 0
C5051 c_15_10/QB c_14_10/QB 0.01281f
C5052 c_13_9/VDD c_13_9/Q 0.00756f
C5053 c_7_12/Q c_7_13/QB 0.00377f
C5054 c_13_9/VDD c_9_8/BL -0.004f
C5055 c_0_9/WL c_1_15/Q 0
C5056 c_1_15/QB c_1_9/VDD 0.00479f
C5057 c_9_6/BLB c_3_7/QB 0
C5058 c_15_5/Q c_15_9/VDD 0.00756f
C5059 c_8_9/WL c_7_9/QB 0
C5060 c_15_12/Q c_15_9/VDD 0.00756f
C5061 c_15_9/QB c_15_9/VDD 0.00969f
C5062 c_10_7/QB c_10_6/Q 0.00377f
C5063 c_9_1/BL c_9_9/WL 0.00159f
C5064 c_2_9/WL c_3_11/Q 0
C5065 c_9_4/BL c_13_3/QB 0.00303f
C5066 c_0_9/WL c_0_12/Q 0
C5067 c_5_12/Q c_5_9/VDD 0.00756f
C5068 c_10_9/QB c_9_8/BLB 0
C5069 c_7_9/VDD c_7_7/Q 0.00756f
C5070 c_3_7/Q c_3_8/QB 0.00377f
C5071 c_12_12/QB c_13_9/VDD 0.00969f
C5072 c_13_10/QB c_13_11/Q 0.01135f
C5073 c_9_14/Q c_9_9/VDD 0.00756f
C5074 c_7_1/QB c_6_1/Q 0
C5075 c_11_9/VDD c_11_6/Q 0.00756f
C5076 c_8_8/Q c_8_7/QB 0.01135f
C5077 c_8_11/Q c_9_10/BLB 0.00303f
C5078 c_9_2/Q c_9_3/QB 0.00377f
C5079 c_9_7/QB c_10_9/WL 0
C5080 c_8_9/WL c_9_15/Q 0
C5081 c_9_15/BL c_2_9/WL 0.00159f
C5082 c_6_3/Q c_7_9/VDD 0.00756f
C5083 c_7_7/Q c_7_6/Q 0
C5084 c_10_1/Q c_10_2/QB 0.00377f
C5085 c_3_2/QB c_4_9/WL 0
C5086 c_6_7/Q c_5_7/QB 0
C5087 c_15_7/QB c_9_8/BL 0.00303f
C5088 c_7_13/QB c_7_9/WL 0
C5089 c_9_3/BL c_4_9/WL 0.00159f
C5090 c_9_12/BL c_8_11/QB 0.00303f
C5091 c_7_15/QB c_6_15/QB 0.01281f
C5092 c_1_9/WL c_2_15/Q 0
C5093 c_6_9/WL c_5_1/Q 0
C5094 c_5_7/Q c_5_9/VDD 0.00756f
C5095 c_10_9/WL c_10_12/QB 0
C5096 c_9_9/WL c_9_10/Q 0
C5097 c_9_7/BLB c_1_9/VDD -0.004f
C5098 c_0_11/QB c_9_10/BLB 0
C5099 c_13_4/Q c_9_5/BL 0
C5100 c_15_5/Q c_15_4/QB 0.01135f
C5101 c_8_0/QB c_9_1/BL 0.00303f
C5102 c_9_9/WL c_8_4/Q 0
C5103 c_7_12/QB c_7_11/Q 0.00377f
C5104 c_15_2/QB c_15_3/QB 0
C5105 c_13_5/QB c_14_5/Q 0
C5106 c_10_14/QB c_10_13/Q 0.00377f
C5107 c_9_4/BL c_4_3/Q 0
C5108 c_13_6/Q c_14_9/WL 0
C5109 c_7_5/QB c_7_9/WL 0
C5110 c_8_9/WL c_8_13/QB 0
C5111 c_2_6/Q c_9_7/BL 0
C5112 c_15_7/QB c_14_7/Q 0
C5113 c_1_9/VDD c_9_11/BLB -0.004f
C5114 c_3_3/Q c_3_4/Q 0
C5115 c_13_9/WL c_12_14/QB 0
C5116 c_11_9/Q c_11_8/Q 0
C5117 c_9_3/BL c_9_2/QB 0.00303f
C5118 c_0_5/QB c_0_6/Q 0.01135f
C5119 c_6_9/WL c_9_14/BLB 0.00159f
C5120 c_7_0/QB c_7_1/Q 0.01135f
C5121 c_1_9/Q c_1_8/Q 0
C5122 c_5_4/QB c_5_5/QB 0
C5123 c_12_13/QB c_12_14/Q 0.01135f
C5124 c_13_0/Q c_12_9/WL 0
C5125 c_15_9/QB c_15_8/QB 0
C5126 c_2_11/QB c_1_11/QB 0.0025f
C5127 c_8_15/QB c_9_9/VDD 0.00479f
C5128 c_8_9/WL c_8_10/Q 0
C5129 c_12_13/Q c_12_14/QB 0.00377f
C5130 c_10_6/QB c_11_9/VDD 0.00969f
C5131 c_13_9/WL c_9_14/BLB 0.00159f
C5132 c_6_4/QB c_9_3/BLB 0
C5133 c_1_1/Q c_9_0/BLB 0.00303f
C5134 c_1_15/QB c_1_14/QB 0
C5135 c_3_0/QB c_4_0/QB 0.0025f
C5136 c_5_11/Q c_5_10/QB 0.01135f
C5137 c_15_10/Q c_15_11/Q 0
C5138 c_1_6/QB c_9_5/BLB 0
C5139 c_14_15/QB c_15_9/VDD 0.00479f
C5140 c_9_6/BL c_9_6/BLB -0
C5141 c_5_9/WL c_9_4/BL 0.00159f
C5142 c_13_9/WL c_14_1/Q 0
C5143 c_0_8/QB c_0_7/QB 0
C5144 c_7_14/QB c_7_13/Q 0.00377f
C5145 c_9_9/BLB c_7_9/WL 0.00159f
C5146 c_5_9/WL c_5_9/Q 0
C5147 c_5_9/WL c_4_12/Q 0
C5148 c_0_9/WL c_1_11/QB 0
C5149 c_9_15/BLB c_15_9/WL 0
C5150 c_14_2/QB c_15_2/Q 0
C5151 c_9_4/BLB c_13_5/QB 0
C5152 c_12_0/Q c_12_1/QB 0.00377f
C5153 c_11_13/Q c_10_13/QB 0
C5154 c_3_9/QB c_4_9/Q 0
C5155 c_15_14/Q c_15_9/WL 0
C5156 c_3_13/QB c_2_9/WL 0
C5157 c_14_9/QB c_9_10/BL 0.00303f
C5158 c_2_7/Q c_2_8/QB 0.00377f
C5159 c_3_1/Q c_3_9/WL 0
C5160 c_4_3/QB c_5_3/Q 0
C5161 c_7_7/QB c_7_9/WL 0
C5162 c_0_9/WL c_1_2/Q 0
C5163 c_5_15/Q c_6_15/Q 0.00634f
C5164 c_11_10/Q c_11_11/Q 0
C5165 c_8_9/WL c_8_8/QB 0
C5166 c_10_7/QB c_9_8/BL 0.00303f
C5167 c_2_9/Q c_1_9/WL 0
C5168 c_13_9/WL c_14_13/Q 0
C5169 c_7_9/VDD c_6_12/QB 0.00969f
C5170 c_11_8/QB c_10_9/WL 0
C5171 c_7_12/Q c_9_11/BLB 0.00303f
C5172 c_8_6/QB c_8_7/QB 0
C5173 c_0_9/WL c_9_8/BL 0.00122f
C5174 c_3_2/QB c_9_3/BL 0.00303f
C5175 c_2_8/Q c_1_8/QB 0
C5176 c_2_7/Q c_3_9/WL 0
C5177 c_15_6/QB c_15_9/WL 0
C5178 c_14_9/Q c_13_9/Q 0.00634f
C5179 c_13_5/QB c_12_5/QB 0.01281f
C5180 c_5_9/Q c_5_10/Q 0
C5181 c_14_9/QB c_9_8/BLB 0
C5182 c_11_8/QB c_9_9/BL 0.00303f
C5183 c_9_0/BLB c_5_1/Q 0.00303f
C5184 c_11_9/VDD c_10_11/QB 0.00969f
C5185 c_9_4/QB c_9_9/WL 0
C5186 c_2_11/Q c_2_12/Q 0
C5187 c_9_13/BLB c_2_14/Q 0.00303f
C5188 c_7_9/VDD c_9_3/BL -0.004f
C5189 c_14_9/Q c_14_10/QB 0.00377f
C5190 c_14_9/QB c_14_10/Q 0.01135f
C5191 c_7_9/VDD c_7_11/QB 0.00969f
C5192 c_3_9/WL c_2_15/QB 0
C5193 c_0_12/Q c_1_12/Q 0.00654f
C5194 c_9_0/BLB c_3_1/QB 0
C5195 c_11_1/QB c_12_9/WL 0
C5196 c_8_1/QB c_8_9/WL 0
C5197 c_9_2/BL c_14_1/QB 0.00303f
C5198 c_9_2/BLB c_11_3/QB 0
C5199 c_13_9/WL c_12_6/QB 0
C5200 c_2_0/Q c_1_0/Q 0.00634f
C5201 c_7_12/QB c_7_9/WL 0
C5202 c_6_9/Q c_7_9/QB 0
C5203 c_3_11/QB c_9_10/BLB 0
C5204 c_9_7/BLB c_7_9/WL 0.00159f
C5205 c_13_14/QB c_14_14/QB 0.0025f
C5206 c_9_12/BLB c_8_9/WL 0.00159f
C5207 c_0_3/Q c_0_2/Q 0
C5208 c_1_4/Q c_0_4/Q 0.00654f
C5209 c_7_3/QB c_6_3/Q 0
C5210 c_7_9/VDD c_7_6/Q 0.00756f
C5211 c_9_9/WL c_8_3/Q 0
C5212 c_1_5/QB c_9_6/BL 0.00303f
C5213 c_3_7/Q c_4_9/WL 0
C5214 c_11_9/WL c_10_14/QB 0
C5215 c_8_2/Q c_8_3/Q 0
C5216 c_11_9/WL c_11_4/Q 0
C5217 c_3_2/Q c_3_9/WL 0
C5218 c_5_0/QB c_4_0/QB 0.01281f
C5219 c_3_1/Q c_3_9/VDD 0.00756f
C5220 c_15_13/Q c_14_13/Q 0.00654f
C5221 c_9_6/Q c_9_5/QB 0.01135f
C5222 c_15_6/Q c_15_5/Q 0
C5223 c_9_0/BLB c_14_1/Q 0.00303f
C5224 c_9_11/BLB c_7_9/WL 0.00159f
C5225 c_14_4/QB c_14_5/QB 0
C5226 c_15_9/VDD c_15_11/Q 0.00756f
C5227 c_6_9/WL c_9_2/BL 0.00159f
C5228 c_9_8/BL c_13_7/Q 0
C5229 c_9_11/Q c_9_9/VDD 0.00756f
C5230 c_9_7/BL c_10_6/Q 0
C5231 c_9_4/BL c_11_9/VDD -0.004f
C5232 c_9_1/BLB c_7_2/QB 0
C5233 c_10_12/QB c_11_12/QB 0.01281f
C5234 c_6_2/QB c_5_2/QB 0.0025f
C5235 c_2_7/Q c_3_9/VDD 0.00756f
C5236 c_6_4/QB c_7_9/WL 0
C5237 c_7_15/QB c_8_9/WL 0
C5238 c_4_12/Q c_3_12/QB 0
C5239 c_14_9/WL c_9_9/BLB 0.00159f
C5240 c_9_14/QB c_10_9/WL 0
C5241 c_8_9/WL c_9_9/QB 0
C5242 c_9_9/BL c_15_9/VDD -0.004f
C5243 c_5_1/QB c_4_1/QB 0.01281f
C5244 c_13_9/WL c_9_2/BL 0.00159f
C5245 c_3_9/VDD c_2_15/QB 0.00479f
C5246 c_9_4/BLB c_8_9/WL 0.00159f
C5247 c_9_15/BL c_13_9/VDD -0.004f
C5248 c_11_9/VDD c_11_3/QB 0.00969f
C5249 c_11_0/Q c_9_1/BL 0
C5250 c_14_7/Q c_13_7/Q 0.00634f
C5251 c_9_8/QB c_8_8/QB 0.01281f
C5252 c_0_9/WL c_0_11/Q 0
C5253 c_2_9/QB c_2_8/QB 0
C5254 c_3_12/Q c_2_12/QB 0
C5255 c_8_9/WL c_8_7/Q 0
C5256 c_8_9/Q c_7_9/WL 0
C5257 c_14_4/QB c_9_3/BLB 0
C5258 c_11_7/Q c_10_7/QB 0
C5259 c_5_9/WL c_4_8/Q 0
C5260 c_11_8/Q c_11_9/QB 0.00377f
C5261 c_9_5/QB c_9_9/WL 0
C5262 c_2_6/Q c_1_9/WL 0
C5263 c_15_5/QB c_15_9/WL 0
C5264 c_10_2/QB c_9_2/Q 0
C5265 c_4_11/QB c_5_11/Q 0
C5266 c_3_2/Q c_3_9/VDD 0.00756f
C5267 c_2_9/QB c_3_9/WL 0
C5268 c_4_8/Q c_3_8/Q 0.00634f
C5269 c_4_10/Q c_9_11/BL 0
C5270 c_12_8/QB c_13_8/Q 0
C5271 c_12_9/WL c_11_15/Q 0
C5272 c_13_12/Q c_9_11/BLB 0.00303f
C5273 c_12_14/Q c_12_15/Q 0
C5274 c_13_13/Q c_14_13/QB 0
C5275 c_9_9/WL c_10_13/QB 0
C5276 c_10_9/Q c_9_9/WL 0
C5277 c_8_9/WL c_9_7/BL 0.00159f
C5278 c_5_9/WL c_9_1/BL 0.00159f
C5279 c_14_12/Q c_13_12/Q 0.00634f
C5280 c_1_12/Q c_1_11/QB 0.01135f
C5281 c_14_15/Q c_13_15/Q 0.00634f
C5282 c_12_4/QB c_11_4/Q 0
C5283 c_12_4/Q c_11_4/QB 0
C5284 c_5_9/Q c_9_10/BL 0
C5285 c_0_9/WL c_1_4/Q 0
C5286 c_9_14/BL c_2_13/QB 0.00303f
C5287 c_7_9/VDD c_7_1/Q 0.00756f
C5288 c_9_7/QB c_9_6/QB 0
C5289 c_11_0/QB c_12_9/WL 0
C5290 c_4_2/Q c_4_1/QB 0.01135f
C5291 c_14_9/WL c_9_7/BLB 0.00159f
C5292 c_13_9/VDD c_13_8/Q 0.00756f
C5293 c_9_12/BLB c_14_13/QB 0
C5294 c_9_4/BL c_12_3/QB 0.00303f
C5295 c_11_5/Q c_11_6/QB 0.00377f
C5296 c_1_11/Q c_0_11/Q 0.00654f
C5297 c_9_9/BL c_15_8/QB 0.00303f
C5298 c_7_6/QB c_7_9/WL 0
C5299 c_5_9/WL c_6_1/QB 0
C5300 c_13_2/Q c_13_1/QB 0.01135f
C5301 c_9_8/BL c_8_7/Q 0
C5302 c_5_9/Q c_9_8/BLB 0.00303f
C5303 c_4_11/Q c_4_12/Q 0
C5304 c_14_9/WL c_9_11/BLB 0.00159f
C5305 c_1_9/VDD c_9_13/BL -0.004f
C5306 c_3_15/Q c_9_14/BLB 0.00303f
C5307 c_14_3/Q c_13_3/QB 0
C5308 c_1_2/Q c_0_2/QB 0
C5309 c_1_2/QB c_0_2/Q 0
C5310 c_13_2/QB c_9_3/BL 0.00303f
C5311 c_11_5/QB c_9_4/BLB 0
C5312 c_11_3/QB c_12_3/QB 0.0025f
C5313 c_9_12/Q c_9_11/Q 0
C5314 c_9_6/BLB c_9_9/VDD -0.004f
C5315 c_7_3/QB c_7_9/VDD 0.00969f
C5316 c_14_12/Q c_14_9/WL 0
C5317 c_9_0/BL c_1_9/VDD -0.01128f
C5318 c_9_8/QB c_9_9/QB 0
C5319 c_2_11/QB c_3_11/Q 0
C5320 c_4_5/QB c_5_5/QB 0.01281f
C5321 c_15_6/QB c_14_6/QB 0.01281f
C5322 c_2_9/QB c_3_9/VDD 0.00969f
C5323 c_7_5/QB c_8_5/QB 0.0025f
C5324 c_9_13/BLB c_12_9/WL 0.00159f
C5325 c_9_13/BLB c_1_9/WL 0.00159f
C5326 c_3_15/QB c_2_15/QB 0.01281f
C5327 c_8_1/QB c_9_1/QB 0.01281f
C5328 c_2_9/WL c_3_8/Q 0
C5329 c_0_9/WL c_1_12/QB 0
C5330 c_9_15/BL c_0_14/Q 0
C5331 c_9_11/BL c_13_10/QB 0.00303f
C5332 c_13_5/QB c_12_9/WL 0
C5333 c_4_4/QB c_5_9/VDD 0.00969f
C5334 c_7_7/Q c_9_6/BLB 0.00303f
C5335 c_10_11/Q c_11_11/QB 0
C5336 c_9_6/BL c_6_5/QB 0.00303f
C5337 c_6_9/WL c_7_0/Q 0
C5338 c_7_9/VDD c_7_14/QB 0.00969f
C5339 c_6_9/WL c_5_12/QB 0
C5340 c_9_14/BL c_5_9/VDD -0.004f
C5341 c_11_5/QB c_12_5/QB 0.0025f
C5342 c_1_6/Q c_0_6/Q 0.00654f
C5343 c_10_3/QB c_9_3/Q 0
C5344 c_10_6/QB c_11_6/Q 0
C5345 c_12_11/Q c_12_10/QB 0.01135f
C5346 c_9_9/WL c_9_15/Q 0
C5347 c_2_9/WL c_9_2/BLB 0.00159f
C5348 c_13_6/Q c_12_6/QB 0
C5349 c_13_6/QB c_12_6/Q 0
C5350 c_14_6/Q c_14_5/Q 0
C5351 c_11_13/Q c_9_12/BLB 0.00303f
C5352 c_2_6/QB c_3_9/WL 0
C5353 c_5_15/QB c_9_14/BLB 0
C5354 c_11_9/VDD c_9_1/BL -0.004f
C5355 c_1_15/Q c_1_9/WL 0
C5356 c_12_13/QB c_9_14/BL 0.00303f
C5357 c_9_1/BL c_9_0/QB 0.00303f
C5358 c_2_1/Q c_3_9/WL 0
C5359 c_9_6/BLB c_4_9/WL 0.00159f
C5360 c_15_1/Q c_15_2/QB 0.00377f
C5361 c_14_0/QB c_15_9/VDD 0.00777f
C5362 c_9_15/BL c_0_9/WL 0.00122f
C5363 c_14_9/WL c_13_1/QB 0
C5364 c_9_11/BL c_9_9/VDD -0.004f
C5365 c_7_12/Q c_9_13/BL 0
C5366 c_0_12/Q c_1_9/WL 0
C5367 c_7_12/QB c_8_12/Q 0
C5368 c_13_12/QB c_9_11/BLB 0
C5369 c_8_9/WL c_9_1/BLB 0.00159f
C5370 c_9_4/BL c_15_3/Q 0
C5371 c_11_3/Q c_9_2/BLB 0.00303f
C5372 c_10_7/QB c_9_9/WL 0
C5373 c_4_4/QB c_3_9/WL 0
C5374 c_8_13/QB c_9_9/WL 0
C5375 c_14_12/Q c_13_12/QB 0
C5376 c_15_12/Q c_15_13/Q 0
C5377 c_9_8/Q c_10_9/WL 0
C5378 c_8_9/WL c_9_15/QB 0
C5379 c_1_11/Q c_1_12/QB 0.00377f
C5380 c_9_14/BL c_3_9/WL 0.00159f
C5381 c_8_12/Q c_9_11/BLB 0.00303f
C5382 c_10_11/Q c_10_9/WL 0
C5383 c_13_2/Q c_12_2/Q 0.00654f
C5384 c_4_13/Q c_4_12/QB 0.01135f
C5385 c_15_13/QB c_9_14/BL 0.00303f
C5386 c_9_0/BLB c_2_1/QB 0
C5387 c_9_12/BL c_12_11/Q 0
C5388 c_13_9/VDD c_13_3/QB 0.00969f
C5389 c_11_0/QB c_11_1/Q 0.01135f
C5390 c_8_10/Q c_9_9/WL 0
C5391 c_9_8/Q c_9_9/BL 0
C5392 c_15_10/Q c_15_9/Q 0
C5393 c_9_12/QB c_8_12/Q 0
C5394 c_9_4/QB c_10_4/Q 0
C5395 c_9_4/Q c_10_4/QB 0
C5396 c_3_3/Q c_3_2/Q 0
C5397 c_4_0/Q c_5_9/VDD 0.00266f
C5398 c_2_9/WL c_3_12/QB 0
C5399 c_0_8/QB c_1_8/Q 0
C5400 c_2_6/QB c_3_9/VDD 0.00969f
C5401 c_6_9/WL c_7_10/QB 0
C5402 c_12_7/Q c_9_6/BLB 0.00303f
C5403 c_0_15/QB c_9_14/BLB 0
C5404 c_9_13/BL c_7_9/WL 0.00159f
C5405 c_1_9/VDD c_9_5/BLB -0.004f
C5406 c_3_9/VDD c_2_1/Q 0.00756f
C5407 c_14_11/QB c_14_10/QB 0
C5408 c_11_9/VDD c_11_12/Q 0.00756f
C5409 c_7_15/Q c_6_15/QB 0
C5410 c_9_0/BLB c_0_1/QB 0
C5411 c_9_11/BL c_4_9/WL 0.00159f
C5412 c_9_0/BL c_7_9/WL 0
C5413 c_13_9/WL c_14_15/QB 0
C5414 c_9_1/BLB c_1_2/Q 0.00303f
C5415 c_9_6/BL c_14_5/QB 0.00303f
C5416 c_1_15/QB c_9_14/BLB 0
C5417 c_11_3/Q c_11_9/VDD 0.00756f
C5418 c_2_12/QB c_9_11/BLB 0
C5419 c_5_4/QB c_4_4/QB 0.01281f
C5420 c_14_3/Q c_9_2/BLB 0.00303f
C5421 c_13_3/Q c_9_2/BLB 0.00303f
C5422 c_9_14/BL c_9_13/QB 0.00303f
C5423 c_9_7/BL c_14_6/Q 0
C5424 c_6_11/Q c_6_12/QB 0.00377f
C5425 c_1_9/Q c_2_9/WL 0
C5426 c_8_8/QB c_9_9/WL 0
C5427 c_3_9/Q c_2_9/WL 0
C5428 c_13_10/QB c_13_9/QB 0
C5429 c_4_9/WL c_5_1/QB 0
C5430 c_4_1/Q c_5_1/Q 0.00654f
C5431 c_2_0/QB c_2_1/Q 0.01135f
C5432 c_9_14/BL c_3_9/VDD -0.004f
C5433 c_14_4/QB c_14_9/WL 0
C5434 c_6_6/Q c_6_9/WL 0
C5435 c_5_6/Q c_9_5/BLB 0.00303f
C5436 c_2_9/Q c_2_8/Q 0
C5437 c_3_1/QB c_4_1/Q 0
C5438 c_6_8/Q c_6_7/QB 0.01135f
C5439 c_9_6/BL c_2_5/QB 0.00303f
C5440 c_7_11/QB c_6_11/Q 0
C5441 c_9_6/BL c_1_9/VDD -0.004f
C5442 c_2_9/WL c_9_10/BL 0.00159f
C5443 c_4_0/Q c_3_9/WL 0
C5444 c_7_9/VDD c_6_11/Q 0.00756f
C5445 c_7_8/QB c_7_9/WL 0
C5446 c_9_14/QB c_8_14/QB 0.01281f
C5447 c_9_2/BLB c_8_3/Q 0.00303f
C5448 c_7_9/VDD c_9_6/BLB -0.004f
C5449 c_0_8/Q c_1_8/QB 0
C5450 c_1_11/QB c_1_9/WL 0
C5451 c_6_9/WL c_5_0/QB 0
C5452 c_14_8/Q c_15_9/WL 0
C5453 c_7_0/QB c_6_0/QB 0.01281f
C5454 c_11_9/WL c_11_1/QB 0
C5455 c_8_1/QB c_9_9/WL 0
C5456 c_8_1/QB c_8_2/Q 0.01135f
C5457 c_13_12/Q c_9_13/BL 0
C5458 c_13_8/Q c_13_7/Q 0
C5459 c_5_0/Q c_5_9/VDD 0.00266f
C5460 c_1_2/Q c_1_9/WL 0
C5461 c_1_4/QB c_0_4/QB 0.01281f
C5462 c_5_9/WL c_5_13/Q 0
C5463 c_9_7/BL c_11_6/QB 0.00303f
C5464 c_6_8/Q c_9_9/BL 0
C5465 c_9_12/BLB c_9_9/WL 0.00159f
C5466 c_2_9/WL c_9_8/BLB 0.00159f
C5467 c_7_5/Q c_6_5/QB 0
C5468 c_13_9/Q c_12_9/WL 0
C5469 c_2_6/QB c_3_6/Q 0
C5470 c_6_9/WL c_6_7/QB 0
C5471 c_9_8/BL c_12_9/WL 0.00159f
C5472 c_11_1/QB c_11_2/Q 0.01135f
C5473 c_1_9/VDD c_0_3/QB 0.00969f
C5474 c_15_9/VDD c_15_9/Q 0.00756f
C5475 c_9_8/BL c_1_9/WL 0.00159f
C5476 c_5_7/QB c_5_9/VDD 0.00969f
C5477 c_14_9/QB c_14_8/QB 0
C5478 c_13_9/VDD c_13_5/Q 0.00756f
C5479 c_11_5/QB c_12_9/WL 0
C5480 c_4_2/Q c_4_9/WL 0
C5481 c_12_15/QB c_11_15/Q 0
C5482 c_0_10/QB c_9_9/BLB 0
C5483 c_3_0/Q c_3_9/VDD 0.00266f
C5484 c_11_3/Q c_12_3/QB 0
C5485 c_3_13/QB c_4_13/QB 0.0025f
C5486 c_14_11/Q c_14_10/QB 0.01135f
C5487 c_12_12/QB c_12_9/WL 0
C5488 c_5_9/WL c_6_3/QB 0
C5489 c_9_4/Q c_8_9/WL 0
C5490 c_6_9/WL c_9_9/BL 0.00159f
C5491 c_6_3/Q c_5_3/QB 0
C5492 c_9_6/Q c_9_7/BL 0
C5493 c_14_9/WL c_9_13/BL 0.00159f
C5494 c_12_9/QB c_9_10/BL 0.00303f
C5495 c_8_0/QB c_8_1/QB 0
C5496 c_14_15/Q c_14_14/Q 0
C5497 c_7_10/QB c_8_10/QB 0.0025f
C5498 c_13_1/Q c_13_0/Q 0
C5499 c_9_9/QB c_9_9/WL 0
C5500 c_13_9/VDD c_9_2/BLB -0.004f
C5501 c_5_2/QB c_5_1/Q 0.00377f
C5502 c_9_0/BL c_14_9/WL 0
C5503 c_9_4/BLB c_9_9/WL 0.00159f
C5504 c_10_9/WL c_9_3/Q 0
C5505 c_14_4/Q c_13_4/QB 0
C5506 c_14_4/QB c_13_4/Q 0
C5507 c_7_9/VDD c_9_11/BL -0.004f
C5508 c_15_15/Q c_15_9/WL 0
C5509 c_5_3/QB c_4_9/WL 0
C5510 c_4_7/Q c_3_7/QB 0
C5511 c_9_9/WL c_8_7/Q 0
C5512 c_13_9/WL c_9_9/BL 0.00159f
C5513 c_1_4/QB c_1_3/QB 0
C5514 c_9_5/BLB c_7_9/WL 0.00159f
C5515 c_3_0/Q c_2_0/QB 0
C5516 c_11_7/QB c_12_7/Q 0
C5517 c_7_4/Q c_8_4/Q 0.00634f
C5518 c_12_9/Q c_13_9/Q 0.00654f
C5519 c_14_12/Q c_14_13/Q 0
C5520 c_12_9/QB c_9_8/BLB 0
C5521 c_3_13/QB c_9_12/BLB 0
C5522 c_12_9/WL c_11_11/Q 0
C5523 c_11_8/Q c_11_7/QB 0.01135f
C5524 c_4_7/QB c_9_8/BL 0.00303f
C5525 c_6_3/QB c_9_2/BLB 0
C5526 c_15_9/WL c_14_7/QB 0
C5527 c_3_4/Q c_9_5/BL 0
C5528 c_9_15/BL c_2_14/Q 0
C5529 c_11_9/WL c_11_15/Q 0
C5530 c_13_9/WL c_12_7/QB 0
C5531 c_3_4/QB c_4_4/Q 0
C5532 c_15_13/QB c_15_9/WL 0
C5533 c_15_9/Q c_15_8/QB 0.01135f
C5534 c_9_3/BLB c_15_4/Q 0.00303f
C5535 c_9_7/BL c_9_9/WL 0.00159f
C5536 c_13_3/Q c_12_3/QB 0
C5537 c_1_3/Q c_0_3/QB 0
C5538 c_10_1/QB c_10_0/QB 0
C5539 c_0_11/Q c_1_9/WL 0
C5540 c_9_6/BL c_7_9/WL 0.00159f
C5541 c_5_9/WL c_6_15/Q 0
C5542 c_8_9/WL c_9_10/BLB 0.00159f
C5543 c_14_1/Q c_13_1/QB 0
C5544 c_11_9/WL c_11_0/QB 0
C5545 c_11_7/Q c_12_9/WL 0
C5546 c_9_2/Q c_9_9/VDD 0.00756f
C5547 c_13_14/QB c_13_15/Q 0.01135f
C5548 c_7_15/Q c_8_9/WL 0
C5549 c_2_8/QB c_1_8/QB 0.0025f
C5550 c_9_9/BL c_5_8/Q 0
C5551 c_9_2/BL c_4_1/Q 0
C5552 c_3_4/Q c_2_4/Q 0.00654f
C5553 c_11_9/VDD c_10_13/QB 0.00969f
C5554 c_11_13/Q c_12_9/WL 0
C5555 c_10_9/Q c_11_9/VDD 0.00756f
C5556 c_3_7/Q c_9_6/BLB 0.00303f
C5557 c_8_9/WL c_9_5/Q 0
C5558 c_13_12/QB c_9_13/BL 0.00303f
C5559 c_10_9/Q c_10_8/Q 0
C5560 c_15_13/QB c_15_12/QB 0
C5561 c_4_2/Q c_3_2/QB 0
C5562 c_3_3/QB c_4_3/QB 0.0025f
C5563 c_5_9/WL c_6_13/QB 0
C5564 c_6_9/WL c_7_1/QB 0
C5565 c_10_9/WL c_9_5/BL 0.00159f
C5566 c_4_2/Q c_9_3/BL 0
C5567 c_5_8/QB c_9_9/BL 0.00303f
C5568 c_9_0/BLB c_10_9/WL 0.00159f
C5569 c_8_12/Q c_9_13/BL 0
C5570 c_2_5/Q c_3_9/WL 0
C5571 c_11_9/WL c_10_4/QB 0
C5572 c_8_3/QB c_9_3/Q 0
C5573 c_1_4/Q c_1_9/WL 0
C5574 c_1_11/QB c_9_10/BLB 0
C5575 c_9_12/BL c_15_9/WL 0.00122f
C5576 c_4_8/QB c_4_9/Q 0.01135f
C5577 c_11_9/WL c_9_13/BLB 0.00159f
C5578 c_9_0/Q c_9_9/VDD 0.00266f
C5579 c_6_9/WL c_5_5/QB 0
C5580 c_14_0/QB c_14_1/QB 0
C5581 c_1_13/QB c_0_13/QB 0.01281f
C5582 c_5_9/WL c_5_5/Q 0
C5583 c_13_9/VDD c_9_10/BL -0.004f
C5584 c_9_4/BL c_11_3/QB 0.00303f
C5585 c_14_9/WL c_9_5/BLB 0.00159f
C5586 c_3_2/QB c_2_2/QB 0.01281f
C5587 c_4_11/QB c_9_10/BLB 0
C5588 c_6_2/Q c_6_1/Q 0
C5589 c_0_0/QB c_1_0/Q 0
C5590 c_11_6/QB c_12_9/WL 0
C5591 c_6_9/WL c_7_14/Q 0
C5592 c_2_9/WL c_1_8/Q 0
C5593 c_5_9/WL c_4_9/Q 0
C5594 c_14_4/Q c_14_3/QB 0.01135f
C5595 c_0_15/Q c_1_9/VDD 0.00565f
C5596 c_9_3/BL c_2_2/QB 0.00303f
C5597 c_11_9/VDD c_11_10/Q 0.00756f
C5598 c_10_9/Q c_9_10/BL 0
C5599 c_4_5/QB c_4_4/QB 0
C5600 c_15_14/Q c_9_13/BLB 0.00303f
C5601 c_9_13/BL c_2_12/QB 0.00303f
C5602 c_13_9/VDD c_12_3/QB 0.00969f
C5603 c_9_3/BLB c_9_9/VDD -0.004f
C5604 c_14_3/Q c_15_3/Q 0.00654f
C5605 c_15_10/QB c_14_10/Q 0
C5606 c_7_9/VDD c_6_0/QB 0.00777f
C5607 c_8_9/WL c_8_7/QB 0
C5608 c_13_9/VDD c_9_8/BLB -0.004f
C5609 c_0_9/WL c_9_2/BLB 0.00122f
C5610 c_7_12/Q c_7_13/Q 0
C5611 c_1_12/QB c_1_9/WL 0
C5612 c_6_9/WL c_5_12/Q 0
C5613 c_11_9/WL c_10_6/Q 0
C5614 c_0_9/WL c_0_7/QB 0
C5615 c_2_5/Q c_3_9/VDD 0.00756f
C5616 c_8_10/Q c_9_10/QB 0
C5617 c_8_9/WL c_7_9/Q 0
C5618 c_10_7/Q c_10_6/Q 0
C5619 c_9_1/BLB c_9_9/WL 0.00159f
C5620 c_13_9/WL c_13_8/QB 0
C5621 c_14_9/WL c_9_6/BL 0.00159f
C5622 c_14_0/QB c_13_9/WL 0
C5623 c_9_1/BLB c_8_2/Q 0.00303f
C5624 c_10_9/Q c_9_8/BLB 0.00303f
C5625 c_5_13/Q c_6_13/Q 0.00634f
C5626 c_6_10/QB c_7_10/Q 0
C5627 c_2_5/Q c_2_4/QB 0.01135f
C5628 c_9_14/BL c_15_9/VDD -0.004f
C5629 c_7_9/VDD c_6_5/QB 0.00969f
C5630 c_13_10/Q c_13_11/Q 0
C5631 c_9_2/BL c_13_1/QB 0.00303f
C5632 c_11_4/QB c_9_5/BL 0.00303f
C5633 c_5_9/WL c_4_13/QB 0
C5634 c_7_4/QB c_8_4/Q 0
C5635 c_1_1/QB c_1_0/Q 0.00377f
C5636 c_8_11/QB c_8_10/QB 0
C5637 c_11_13/QB c_11_9/VDD 0.00969f
C5638 c_5_11/QB c_5_12/QB 0
C5639 c_9_10/BLB c_11_11/Q 0.00303f
C5640 c_11_5/Q c_11_9/VDD 0.00756f
C5641 c_6_9/WL c_5_7/Q 0
C5642 c_7_1/QB c_9_0/BLB 0
C5643 c_9_15/BL c_12_9/WL 0.00159f
C5644 c_8_14/Q c_9_9/VDD 0.00756f
C5645 c_14_6/QB c_14_7/QB 0
C5646 c_9_15/BL c_1_9/WL 0.00159f
C5647 c_11_9/VDD c_10_7/QB 0.00969f
C5648 c_10_1/QB c_10_0/Q 0.00377f
C5649 c_9_10/BL c_7_9/QB 0.00303f
C5650 c_9_3/BLB c_4_9/WL 0.00159f
C5651 c_5_9/WL c_6_4/Q 0
C5652 c_10_7/QB c_10_8/Q 0.01135f
C5653 c_9_12/BL c_8_11/Q 0
C5654 c_10_9/WL c_10_10/Q 0
C5655 c_1_10/QB c_9_9/BLB 0
C5656 c_10_9/WL c_10_12/Q 0
C5657 c_7_13/Q c_7_9/WL 0
C5658 c_0_11/Q c_9_10/BLB 0.00303f
C5659 c_14_9/WL c_14_15/Q 0
C5660 c_5_9/WL c_9_12/BLB 0.00159f
C5661 c_4_12/QB c_5_9/VDD 0.00969f
C5662 c_15_12/Q c_9_11/BLB 0.00303f
C5663 c_15_2/QB c_15_3/Q 0.01135f
C5664 c_15_2/Q c_15_3/QB 0.00377f
C5665 c_13_9/WL c_12_14/Q 0
C5666 c_5_9/WL c_5_11/Q 0
C5667 c_13_5/Q c_14_5/Q 0.00634f
C5668 c_10_14/Q c_10_13/QB 0.01135f
C5669 c_3_6/Q VSUBS 0
C5670 c_3_6/QB VSUBS 0
C5671 c_1_3/Q VSUBS 0
C5672 c_1_3/QB VSUBS 0
C5673 c_6_13/Q VSUBS 0
C5674 c_6_13/QB VSUBS 0
C5675 c_13_4/Q VSUBS 0
C5676 c_13_4/QB VSUBS 0
C5677 c_15_7/Q VSUBS 0
C5678 c_15_7/QB VSUBS 0
C5679 c_9_14/BLB VSUBS -2.67313f
C5680 c_9_14/BL VSUBS -2.67313f
C5681 c_0_14/Q VSUBS 0
C5682 c_0_14/QB VSUBS 0
C5683 c_5_9/Q VSUBS 0
C5684 c_5_9/QB VSUBS 0
C5685 c_9_12/Q VSUBS 0
C5686 c_9_12/QB VSUBS 0
C5687 c_3_13/Q VSUBS 0
C5688 c_3_13/QB VSUBS 0
C5689 c_1_2/Q VSUBS 0
C5690 c_1_2/QB VSUBS 0
C5691 c_6_12/Q VSUBS 0
C5692 c_6_12/QB VSUBS 0
C5693 c_11_9/WL VSUBS -2.03395f
C5694 c_11_0/Q VSUBS 0
C5695 c_11_0/QB VSUBS 0
C5696 c_11_9/VDD VSUBS -10.072f
C5697 c_13_3/Q VSUBS 0
C5698 c_13_3/QB VSUBS 0
C5699 c_3_5/Q VSUBS 0
C5700 c_3_5/QB VSUBS 0
C5701 c_15_6/Q VSUBS 0
C5702 c_15_6/QB VSUBS 0
C5703 c_9_13/BLB VSUBS -2.67313f
C5704 c_9_13/BL VSUBS -2.67313f
C5705 c_0_13/Q VSUBS 0
C5706 c_0_13/QB VSUBS 0
C5707 c_5_8/Q VSUBS 0
C5708 c_5_8/QB VSUBS 0
C5709 c_9_11/Q VSUBS 0
C5710 c_9_11/QB VSUBS 0
C5711 c_3_12/Q VSUBS 0
C5712 c_3_12/QB VSUBS 0
C5713 c_1_9/WL VSUBS -2.03395f
C5714 c_1_1/Q VSUBS 0
C5715 c_1_1/QB VSUBS 0
C5716 c_6_11/Q VSUBS 0
C5717 c_6_11/QB VSUBS 0
C5718 c_13_2/Q VSUBS 0
C5719 c_13_2/QB VSUBS 0
C5720 c_3_4/Q VSUBS 0
C5721 c_3_4/QB VSUBS 0
C5722 c_9_12/BLB VSUBS -2.67313f
C5723 c_9_12/BL VSUBS -2.67313f
C5724 c_0_12/Q VSUBS 0
C5725 c_0_12/QB VSUBS 0
C5726 c_5_7/Q VSUBS 0
C5727 c_5_7/QB VSUBS 0
C5728 c_9_10/Q VSUBS 0
C5729 c_9_10/QB VSUBS 0
C5730 c_15_5/Q VSUBS 0
C5731 c_15_5/QB VSUBS 0
C5732 c_3_11/Q VSUBS 0
C5733 c_3_11/QB VSUBS 0
C5734 c_1_0/Q VSUBS 0
C5735 c_1_0/QB VSUBS 0
C5736 c_6_10/Q VSUBS 0
C5737 c_6_10/QB VSUBS 0
C5738 c_13_1/Q VSUBS 0
C5739 c_13_1/QB VSUBS 0
C5740 c_3_3/Q VSUBS 0
C5741 c_3_3/QB VSUBS 0
C5742 c_15_4/Q VSUBS 0
C5743 c_15_4/QB VSUBS 0
C5744 c_9_11/BLB VSUBS -2.67313f
C5745 c_9_11/BL VSUBS -2.67313f
C5746 c_0_11/Q VSUBS 0
C5747 c_0_11/QB VSUBS 0
C5748 c_5_6/Q VSUBS 0
C5749 c_5_6/QB VSUBS 0
C5750 c_7_9/Q VSUBS 0
C5751 c_7_9/QB VSUBS 0
C5752 c_3_10/Q VSUBS 0
C5753 c_3_10/QB VSUBS 0
C5754 c_13_9/WL VSUBS -2.03395f
C5755 c_13_0/Q VSUBS 0
C5756 c_13_0/QB VSUBS 0
C5757 c_13_9/VDD VSUBS -10.072f
C5758 c_3_2/Q VSUBS 0
C5759 c_3_2/QB VSUBS 0
C5760 c_9_10/BLB VSUBS -2.67313f
C5761 c_9_10/BL VSUBS -2.67313f
C5762 c_0_10/Q VSUBS 0
C5763 c_0_10/QB VSUBS 0
C5764 c_5_5/Q VSUBS 0
C5765 c_5_5/QB VSUBS 0
C5766 c_15_3/Q VSUBS 0
C5767 c_15_3/QB VSUBS 0
C5768 c_7_8/Q VSUBS 0
C5769 c_7_8/QB VSUBS 0
C5770 c_3_9/WL VSUBS -2.03395f
C5771 c_3_1/Q VSUBS 0
C5772 c_3_1/QB VSUBS 0
C5773 c_13_15/Q VSUBS 0
C5774 c_13_15/QB VSUBS 0
C5775 c_15_2/Q VSUBS 0
C5776 c_15_2/QB VSUBS 0
C5777 c_5_4/Q VSUBS 0
C5778 c_5_4/QB VSUBS 0
C5779 c_7_7/Q VSUBS 0
C5780 c_7_7/QB VSUBS 0
C5781 c_10_15/Q VSUBS 0
C5782 c_10_15/QB VSUBS 0
C5783 c_13_14/Q VSUBS 0
C5784 c_13_14/QB VSUBS 0
C5785 c_5_3/Q VSUBS 0
C5786 c_5_3/QB VSUBS 0
C5787 c_3_0/Q VSUBS 0
C5788 c_3_0/QB VSUBS 0
C5789 c_15_1/Q VSUBS 0
C5790 c_15_1/QB VSUBS 0
C5791 c_7_6/Q VSUBS 0
C5792 c_7_6/QB VSUBS 0
C5793 c_10_14/Q VSUBS 0
C5794 c_10_14/QB VSUBS 0
C5795 c_9_9/Q VSUBS 0
C5796 c_9_9/QB VSUBS 0
C5797 c_13_13/Q VSUBS 0
C5798 c_13_13/QB VSUBS 0
C5799 c_15_9/WL VSUBS -0.59085f
C5800 c_15_0/Q VSUBS 0
C5801 c_15_0/QB VSUBS 0
C5802 c_15_9/VDD VSUBS -10.072f
C5803 c_5_2/Q VSUBS 0
C5804 c_5_2/QB VSUBS 0
C5805 c_7_5/Q VSUBS 0
C5806 c_7_5/QB VSUBS 0
C5807 c_9_8/Q VSUBS 0
C5808 c_9_8/QB VSUBS 0
C5809 c_10_13/Q VSUBS 0
C5810 c_10_13/QB VSUBS 0
C5811 c_13_12/Q VSUBS 0
C5812 c_13_12/QB VSUBS 0
C5813 c_10_9/Q VSUBS 0
C5814 c_10_9/QB VSUBS 0
C5815 c_7_4/Q VSUBS 0
C5816 c_7_4/QB VSUBS 0
C5817 c_5_9/WL VSUBS -2.03395f
C5818 c_5_1/Q VSUBS 0
C5819 c_5_1/QB VSUBS 0
C5820 c_9_7/Q VSUBS 0
C5821 c_9_7/QB VSUBS 0
C5822 c_10_12/Q VSUBS 0
C5823 c_10_12/QB VSUBS 0
C5824 c_13_11/Q VSUBS 0
C5825 c_13_11/QB VSUBS 0
C5826 c_5_0/Q VSUBS 0
C5827 c_5_0/QB VSUBS 0
C5828 c_10_8/Q VSUBS 0
C5829 c_10_8/QB VSUBS 0
C5830 c_7_3/Q VSUBS 0
C5831 c_7_3/QB VSUBS 0
C5832 c_9_6/Q VSUBS 0
C5833 c_9_6/QB VSUBS 0
C5834 c_8_15/Q VSUBS 0
C5835 c_8_15/QB VSUBS 0
C5836 c_10_11/Q VSUBS 0
C5837 c_10_11/QB VSUBS 0
C5838 c_13_10/Q VSUBS 0
C5839 c_13_10/QB VSUBS 0
C5840 c_5_15/Q VSUBS 0
C5841 c_5_15/QB VSUBS 0
C5842 c_10_7/Q VSUBS 0
C5843 c_10_7/QB VSUBS 0
C5844 c_7_2/Q VSUBS 0
C5845 c_7_2/QB VSUBS 0
C5846 c_9_9/BLB VSUBS -2.67313f
C5847 c_9_9/BL VSUBS -2.67313f
C5848 c_0_9/Q VSUBS 0
C5849 c_0_9/QB VSUBS 0
C5850 c_8_14/Q VSUBS 0
C5851 c_8_14/QB VSUBS 0
C5852 c_9_5/Q VSUBS 0
C5853 c_9_5/QB VSUBS 0
C5854 c_10_10/Q VSUBS 0
C5855 c_10_10/QB VSUBS 0
C5856 c_2_15/Q VSUBS 0
C5857 c_2_15/QB VSUBS 0
C5858 c_9_8/BLB VSUBS -2.67313f
C5859 c_9_8/BL VSUBS -2.67313f
C5860 c_0_8/Q VSUBS 0
C5861 c_0_8/QB VSUBS 0
C5862 c_5_14/Q VSUBS 0
C5863 c_5_14/QB VSUBS 0
C5864 c_10_6/Q VSUBS 0
C5865 c_10_6/QB VSUBS 0
C5866 c_12_9/Q VSUBS 0
C5867 c_12_9/QB VSUBS 0
C5868 c_7_9/WL VSUBS -2.03395f
C5869 c_7_1/Q VSUBS 0
C5870 c_7_1/QB VSUBS 0
C5871 c_8_13/Q VSUBS 0
C5872 c_8_13/QB VSUBS 0
C5873 c_2_14/Q VSUBS 0
C5874 c_2_14/QB VSUBS 0
C5875 c_9_4/Q VSUBS 0
C5876 c_9_4/QB VSUBS 0
C5877 c_5_13/Q VSUBS 0
C5878 c_5_13/QB VSUBS 0
C5879 c_10_5/Q VSUBS 0
C5880 c_10_5/QB VSUBS 0
C5881 c_7_0/Q VSUBS 0
C5882 c_7_0/QB VSUBS 0
C5883 c_9_7/BLB VSUBS -2.67313f
C5884 c_9_7/BL VSUBS -2.67313f
C5885 c_0_7/Q VSUBS 0
C5886 c_0_7/QB VSUBS 0
C5887 c_8_12/Q VSUBS 0
C5888 c_8_12/QB VSUBS 0
C5889 c_12_8/Q VSUBS 0
C5890 c_12_8/QB VSUBS 0
C5891 c_9_3/Q VSUBS 0
C5892 c_9_3/QB VSUBS 0
C5893 c_2_13/Q VSUBS 0
C5894 c_2_13/QB VSUBS 0
C5895 c_5_12/Q VSUBS 0
C5896 c_5_12/QB VSUBS 0
C5897 c_10_4/Q VSUBS 0
C5898 c_10_4/QB VSUBS 0
C5899 c_12_7/Q VSUBS 0
C5900 c_12_7/QB VSUBS 0
C5901 c_2_9/Q VSUBS 0
C5902 c_2_9/QB VSUBS 0
C5903 c_9_6/BLB VSUBS -2.67313f
C5904 c_9_6/BL VSUBS -2.67313f
C5905 c_0_6/Q VSUBS 0
C5906 c_0_6/QB VSUBS 0
C5907 c_8_11/Q VSUBS 0
C5908 c_8_11/QB VSUBS 0
C5909 c_2_12/Q VSUBS 0
C5910 c_2_12/QB VSUBS 0
C5911 c_9_2/Q VSUBS 0
C5912 c_9_2/QB VSUBS 0
C5913 c_5_11/Q VSUBS 0
C5914 c_5_11/QB VSUBS 0
C5915 c_10_3/Q VSUBS 0
C5916 c_10_3/QB VSUBS 0
C5917 c_9_5/BLB VSUBS -2.67313f
C5918 c_9_5/BL VSUBS -2.67313f
C5919 c_0_5/Q VSUBS 0
C5920 c_0_5/QB VSUBS 0
C5921 c_12_6/Q VSUBS 0
C5922 c_12_6/QB VSUBS 0
C5923 c_2_8/Q VSUBS 0
C5924 c_2_8/QB VSUBS 0
C5925 c_9_9/WL VSUBS -2.03395f
C5926 c_9_1/Q VSUBS 0
C5927 c_9_1/QB VSUBS 0
C5928 c_8_10/Q VSUBS 0
C5929 c_8_10/QB VSUBS 0
C5930 c_14_9/Q VSUBS 0
C5931 c_14_9/QB VSUBS 0
C5932 c_2_11/Q VSUBS 0
C5933 c_2_11/QB VSUBS 0
C5934 c_5_10/Q VSUBS 0
C5935 c_5_10/QB VSUBS 0
C5936 c_10_2/Q VSUBS 0
C5937 c_10_2/QB VSUBS 0
C5938 c_2_7/Q VSUBS 0
C5939 c_2_7/QB VSUBS 0
C5940 c_9_4/BLB VSUBS -2.67313f
C5941 c_9_4/BL VSUBS -2.67313f
C5942 c_0_4/Q VSUBS 0
C5943 c_0_4/QB VSUBS 0
C5944 c_12_5/Q VSUBS 0
C5945 c_12_5/QB VSUBS 0
C5946 c_14_8/Q VSUBS 0
C5947 c_14_8/QB VSUBS 0
C5948 c_2_10/Q VSUBS 0
C5949 c_2_10/QB VSUBS 0
C5950 c_9_0/Q VSUBS 0
C5951 c_9_0/QB VSUBS 0
C5952 c_10_1/Q VSUBS 0
C5953 c_10_1/QB VSUBS 0
C5954 c_9_3/BLB VSUBS -2.67313f
C5955 c_9_3/BL VSUBS -2.67313f
C5956 c_0_3/Q VSUBS 0
C5957 c_0_3/QB VSUBS 0
C5958 c_12_4/Q VSUBS 0
C5959 c_12_4/QB VSUBS 0
C5960 c_4_9/Q VSUBS 0
C5961 c_4_9/QB VSUBS 0
C5962 c_2_6/Q VSUBS 0
C5963 c_2_6/QB VSUBS 0
C5964 c_14_7/Q VSUBS 0
C5965 c_14_7/QB VSUBS 0
C5966 c_15_15/Q VSUBS 0
C5967 c_15_15/QB VSUBS 0
C5968 c_10_9/WL VSUBS -2.03395f
C5969 c_10_0/Q VSUBS 0
C5970 c_10_0/QB VSUBS 0
C5971 c_12_15/Q VSUBS 0
C5972 c_12_15/QB VSUBS 0
C5973 c_2_5/Q VSUBS 0
C5974 c_2_5/QB VSUBS 0
C5975 c_9_2/BLB VSUBS -2.67313f
C5976 c_9_2/BL VSUBS -2.67313f
C5977 c_0_2/Q VSUBS 0
C5978 c_0_2/QB VSUBS 0
C5979 c_12_3/Q VSUBS 0
C5980 c_12_3/QB VSUBS 0
C5981 c_14_6/Q VSUBS 0
C5982 c_14_6/QB VSUBS 0
C5983 c_15_14/Q VSUBS 0
C5984 c_15_14/QB VSUBS 0
C5985 c_4_8/Q VSUBS 0
C5986 c_4_8/QB VSUBS 0
C5987 c_9_1/BLB VSUBS -2.67313f
C5988 c_9_1/BL VSUBS -2.67313f
C5989 c_0_9/WL VSUBS -0.59085f
C5990 c_0_1/Q VSUBS 0
C5991 c_0_1/QB VSUBS 0
C5992 c_1_9/VDD VSUBS -10.072f
C5993 c_12_2/Q VSUBS 0
C5994 c_12_2/QB VSUBS 0
C5995 c_12_14/Q VSUBS 0
C5996 c_12_14/QB VSUBS 0
C5997 c_2_4/Q VSUBS 0
C5998 c_2_4/QB VSUBS 0
C5999 c_14_5/Q VSUBS 0
C6000 c_14_5/QB VSUBS 0
C6001 c_15_13/Q VSUBS 0
C6002 c_15_13/QB VSUBS 0
C6003 c_4_7/Q VSUBS 0
C6004 c_4_7/QB VSUBS 0
C6005 c_12_13/Q VSUBS 0
C6006 c_12_13/QB VSUBS 0
C6007 c_2_3/Q VSUBS 0
C6008 c_2_3/QB VSUBS 0
C6009 c_9_0/BLB VSUBS -2.67313f
C6010 c_9_0/BL VSUBS -0.47952f
C6011 c_0_0/Q VSUBS 0
C6012 c_0_0/QB VSUBS 0
C6013 c_12_1/Q VSUBS 0
C6014 c_12_1/QB VSUBS 0
C6015 c_14_4/Q VSUBS 0
C6016 c_14_4/QB VSUBS 0
C6017 c_15_12/Q VSUBS 0
C6018 c_15_12/QB VSUBS 0
C6019 c_4_6/Q VSUBS 0
C6020 c_4_6/QB VSUBS 0
C6021 c_6_9/Q VSUBS 0
C6022 c_6_9/QB VSUBS 0
C6023 c_12_9/WL VSUBS -2.03395f
C6024 c_12_0/Q VSUBS 0
C6025 c_12_0/QB VSUBS 0
C6026 c_12_12/Q VSUBS 0
C6027 c_12_12/QB VSUBS 0
C6028 c_2_2/Q VSUBS 0
C6029 c_2_2/QB VSUBS 0
C6030 c_14_3/Q VSUBS 0
C6031 c_14_3/QB VSUBS 0
C6032 c_15_11/Q VSUBS 0
C6033 c_15_11/QB VSUBS 0
C6034 c_4_5/Q VSUBS 0
C6035 c_4_5/QB VSUBS 0
C6036 c_6_8/Q VSUBS 0
C6037 c_6_8/QB VSUBS 0
C6038 c_12_11/Q VSUBS 0
C6039 c_12_11/QB VSUBS 0
C6040 c_15_10/Q VSUBS 0
C6041 c_15_10/QB VSUBS 0
C6042 c_4_4/Q VSUBS 0
C6043 c_4_4/QB VSUBS 0
C6044 c_2_9/WL VSUBS -2.03395f
C6045 c_2_1/Q VSUBS 0
C6046 c_2_1/QB VSUBS 0
C6047 c_3_9/VDD VSUBS -10.072f
C6048 c_7_15/Q VSUBS 0
C6049 c_7_15/QB VSUBS 0
C6050 c_14_2/Q VSUBS 0
C6051 c_14_2/QB VSUBS 0
C6052 c_6_7/Q VSUBS 0
C6053 c_6_7/QB VSUBS 0
C6054 c_12_10/Q VSUBS 0
C6055 c_12_10/QB VSUBS 0
C6056 c_4_15/Q VSUBS 0
C6057 c_4_15/QB VSUBS 0
C6058 c_2_0/Q VSUBS 0
C6059 c_2_0/QB VSUBS 0
C6060 c_14_1/Q VSUBS 0
C6061 c_14_1/QB VSUBS 0
C6062 c_4_3/Q VSUBS 0
C6063 c_4_3/QB VSUBS 0
C6064 c_6_6/Q VSUBS 0
C6065 c_6_6/QB VSUBS 0
C6066 c_7_14/Q VSUBS 0
C6067 c_7_14/QB VSUBS 0
C6068 c_1_15/Q VSUBS 0
C6069 c_1_15/QB VSUBS 0
C6070 c_8_9/Q VSUBS 0
C6071 c_8_9/QB VSUBS 0
C6072 c_4_14/Q VSUBS 0
C6073 c_4_14/QB VSUBS 0
C6074 c_4_2/Q VSUBS 0
C6075 c_4_2/QB VSUBS 0
C6076 c_7_13/Q VSUBS 0
C6077 c_7_13/QB VSUBS 0
C6078 c_14_9/WL VSUBS -2.03395f
C6079 c_14_0/Q VSUBS 0
C6080 c_14_0/QB VSUBS 0
C6081 c_6_5/Q VSUBS 0
C6082 c_6_5/QB VSUBS 0
C6083 c_1_14/Q VSUBS 0
C6084 c_1_14/QB VSUBS 0
C6085 c_8_8/Q VSUBS 0
C6086 c_8_8/QB VSUBS 0
C6087 c_4_13/Q VSUBS 0
C6088 c_4_13/QB VSUBS 0
C6089 c_4_9/WL VSUBS -2.03395f
C6090 c_4_1/Q VSUBS 0
C6091 c_4_1/QB VSUBS 0
C6092 c_5_9/VDD VSUBS -10.072f
C6093 c_7_12/Q VSUBS 0
C6094 c_7_12/QB VSUBS 0
C6095 c_6_4/Q VSUBS 0
C6096 c_6_4/QB VSUBS 0
C6097 c_1_13/Q VSUBS 0
C6098 c_1_13/QB VSUBS 0
C6099 c_8_7/Q VSUBS 0
C6100 c_8_7/QB VSUBS 0
C6101 c_4_12/Q VSUBS 0
C6102 c_4_12/QB VSUBS 0
C6103 c_4_0/Q VSUBS 0
C6104 c_4_0/QB VSUBS 0
C6105 c_7_11/Q VSUBS 0
C6106 c_7_11/QB VSUBS 0
C6107 c_6_3/Q VSUBS 0
C6108 c_6_3/QB VSUBS 0
C6109 c_1_12/Q VSUBS 0
C6110 c_1_12/QB VSUBS 0
C6111 c_8_6/Q VSUBS 0
C6112 c_8_6/QB VSUBS 0
C6113 c_4_11/Q VSUBS 0
C6114 c_4_11/QB VSUBS 0
C6115 c_7_10/Q VSUBS 0
C6116 c_7_10/QB VSUBS 0
C6117 c_6_2/Q VSUBS 0
C6118 c_6_2/QB VSUBS 0
C6119 c_1_11/Q VSUBS 0
C6120 c_1_11/QB VSUBS 0
C6121 c_8_5/Q VSUBS 0
C6122 c_8_5/QB VSUBS 0
C6123 c_4_10/Q VSUBS 0
C6124 c_4_10/QB VSUBS 0
C6125 c_6_9/WL VSUBS -2.03395f
C6126 c_6_1/Q VSUBS 0
C6127 c_6_1/QB VSUBS 0
C6128 c_7_9/VDD VSUBS -10.072f
C6129 c_11_9/Q VSUBS 0
C6130 c_11_9/QB VSUBS 0
C6131 c_1_10/Q VSUBS 0
C6132 c_1_10/QB VSUBS 0
C6133 c_8_4/Q VSUBS 0
C6134 c_8_4/QB VSUBS 0
C6135 c_11_8/Q VSUBS 0
C6136 c_11_8/QB VSUBS 0
C6137 c_14_15/Q VSUBS 0
C6138 c_14_15/QB VSUBS 0
C6139 c_6_0/Q VSUBS 0
C6140 c_6_0/QB VSUBS 0
C6141 c_8_3/Q VSUBS 0
C6142 c_8_3/QB VSUBS 0
C6143 c_11_15/Q VSUBS 0
C6144 c_11_15/QB VSUBS 0
C6145 c_11_7/Q VSUBS 0
C6146 c_11_7/QB VSUBS 0
C6147 c_14_14/Q VSUBS 0
C6148 c_14_14/QB VSUBS 0
C6149 c_1_9/Q VSUBS 0
C6150 c_1_9/QB VSUBS 0
C6151 c_8_2/Q VSUBS 0
C6152 c_8_2/QB VSUBS 0
C6153 c_11_14/Q VSUBS 0
C6154 c_11_14/QB VSUBS 0
C6155 c_11_6/Q VSUBS 0
C6156 c_11_6/QB VSUBS 0
C6157 c_14_13/Q VSUBS 0
C6158 c_14_13/QB VSUBS 0
C6159 c_1_8/Q VSUBS 0
C6160 c_1_8/QB VSUBS 0
C6161 c_13_9/Q VSUBS 0
C6162 c_13_9/QB VSUBS 0
C6163 c_8_9/WL VSUBS -2.03395f
C6164 c_8_1/Q VSUBS 0
C6165 c_8_1/QB VSUBS 0
C6166 c_9_9/VDD VSUBS -10.072f
C6167 c_11_13/Q VSUBS 0
C6168 c_11_13/QB VSUBS 0
C6169 c_11_5/Q VSUBS 0
C6170 c_11_5/QB VSUBS 0
C6171 c_14_12/Q VSUBS 0
C6172 c_14_12/QB VSUBS 0
C6173 c_1_7/Q VSUBS 0
C6174 c_1_7/QB VSUBS 0
C6175 c_8_0/Q VSUBS 0
C6176 c_8_0/QB VSUBS 0
C6177 c_13_8/Q VSUBS 0
C6178 c_13_8/QB VSUBS 0
C6179 c_11_12/Q VSUBS 0
C6180 c_11_12/QB VSUBS 0
C6181 c_11_4/Q VSUBS 0
C6182 c_11_4/QB VSUBS 0
C6183 c_14_11/Q VSUBS 0
C6184 c_14_11/QB VSUBS 0
C6185 c_1_6/Q VSUBS 0
C6186 c_1_6/QB VSUBS 0
C6187 c_13_7/Q VSUBS 0
C6188 c_13_7/QB VSUBS 0
C6189 c_3_9/Q VSUBS 0
C6190 c_3_9/QB VSUBS 0
C6191 c_9_15/Q VSUBS 0
C6192 c_9_15/QB VSUBS 0
C6193 c_11_11/Q VSUBS 0
C6194 c_11_11/QB VSUBS 0
C6195 c_11_3/Q VSUBS 0
C6196 c_11_3/QB VSUBS 0
C6197 c_14_10/Q VSUBS 0
C6198 c_14_10/QB VSUBS 0
C6199 c_3_8/Q VSUBS 0
C6200 c_3_8/QB VSUBS 0
C6201 c_1_5/Q VSUBS 0
C6202 c_1_5/QB VSUBS 0
C6203 c_6_15/Q VSUBS 0
C6204 c_6_15/QB VSUBS 0
C6205 c_13_6/Q VSUBS 0
C6206 c_13_6/QB VSUBS 0
C6207 c_15_9/Q VSUBS 0
C6208 c_15_9/QB VSUBS 0
C6209 c_9_14/Q VSUBS 0
C6210 c_9_14/QB VSUBS 0
C6211 c_11_10/Q VSUBS 0
C6212 c_11_10/QB VSUBS 0
C6213 c_3_15/Q VSUBS 0
C6214 c_3_15/QB VSUBS 0
C6215 c_1_4/Q VSUBS 0
C6216 c_1_4/QB VSUBS 0
C6217 c_6_14/Q VSUBS 0
C6218 c_6_14/QB VSUBS 0
C6219 c_11_2/Q VSUBS 0
C6220 c_11_2/QB VSUBS 0
C6221 c_13_5/Q VSUBS 0
C6222 c_13_5/QB VSUBS 0
C6223 c_3_7/Q VSUBS 0
C6224 c_3_7/QB VSUBS 0
C6225 c_9_13/Q VSUBS 0
C6226 c_9_13/QB VSUBS 0
C6227 c_15_8/Q VSUBS 0
C6228 c_15_8/QB VSUBS 0
C6229 c_9_15/BLB VSUBS -0.47952f
C6230 c_9_15/BL VSUBS -2.67313f
C6231 c_0_15/Q VSUBS 0
C6232 c_0_15/QB VSUBS 0
C6233 c_3_14/Q VSUBS 0
C6234 c_3_14/QB VSUBS 0
C6235 c_11_1/Q VSUBS 0
C6236 c_11_1/QB VSUBS 0
.ends
