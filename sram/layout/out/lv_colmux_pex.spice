* NGSPICE file created from lv_colmux.ext - technology: sky130A

.subckt colmux BL DL BLB DLB CSEL VSUBS
X0 DL CSEL BL VSUBS sky130_fd_pr__nfet_01v8 ad=0.3696 pd=2.56 as=0.3696 ps=2.56 w=0.84 l=0.15
X1 BLB CSEL DLB VSUBS sky130_fd_pr__nfet_01v8 ad=0.3696 pd=2.56 as=0.3696 ps=2.56 w=0.84 l=0.15
C0 DLB DL 0.00952f
C1 DL BL 0.03023f
C2 DL CSEL 0.00742f
C3 DL BLB 0.00206f
C4 DLB BL 0.00206f
C5 DLB CSEL 0.00742f
C6 CSEL BL 0.01148f
C7 DLB BLB 0.03023f
C8 BLB BL 0.01491f
C9 BLB CSEL 0.01148f
C10 BLB VSUBS 0.1624f
C11 DLB VSUBS 0.04371f
C12 DL VSUBS 0.2436f
C13 BL VSUBS 0.36229f
.ends

.subckt lv_colmux BL DL BLB DLB CSEL GND
Xu BL DL BLB DLB CSEL GND colmux
C0 BLB GND 0
C1 BL GND 0.00834f
C2 CSEL GND 0
.ends
