* NGSPICE file created from c1n.ext - technology: sky130A

.subckt c1n A B Y VDD GND
X0 GND B a_184_47# VSUBS sky130_fd_pr__nfet_01v8 ad=0.924 pd=4.46 as=0.6468 ps=2.45 w=1.68 l=0.15
X1 a_184_47# A Y VSUBS sky130_fd_pr__nfet_01v8 ad=0.6468 pd=2.45 as=0.924 ps=4.46 w=1.68 l=0.15
C0 VDD GND 0.02459f
C1 B VDD 0.00534f
C2 a_184_47# A 0
C3 a_184_47# GND 0.03091f
C4 B a_184_47# 0
C5 a_184_47# VDD 0.00909f
C6 Y A 0.00245f
C7 Y GND 0.02013f
C8 B Y 0
C9 Y VDD 0.00648f
C10 A GND 0.00878f
C11 Y a_184_47# 0.00465f
C12 B A 0.01263f
C13 A VDD 0.00534f
C14 B GND 0.01497f
C15 VDD VSUBS 0.19801f
C16 GND VSUBS 0.33466f
C17 Y VSUBS 0.08832f
C18 a_184_47# VSUBS 0.1296f
.ends
