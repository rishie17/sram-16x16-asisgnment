* NGSPICE file created from bondpad.ext - technology: sky130A

.subckt bondpad PAD
.ends
