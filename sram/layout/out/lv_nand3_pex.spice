* NGSPICE file created from lv_nand3.ext - technology: sky130A

.subckt nand3 A B C Y VDD GND w_0_397# VSUBS
X0 a_302_47# B a_162_47# VSUBS sky130_fd_pr__nfet_01v8 ad=0.3465 pd=1.81 as=0.3465 ps=1.81 w=1.26 l=0.15
X1 VDD C Y w_0_397# sky130_fd_pr__pfet_01v8 ad=0.3696 pd=2.56 as=0.231 ps=1.39 w=0.84 l=0.15
X2 Y B VDD w_0_397# sky130_fd_pr__pfet_01v8 ad=0.231 pd=1.39 as=0.231 ps=1.39 w=0.84 l=0.15
X3 VDD A Y w_0_397# sky130_fd_pr__pfet_01v8 ad=0.231 pd=1.39 as=0.3696 ps=2.56 w=0.84 l=0.15
X4 GND C a_302_47# VSUBS sky130_fd_pr__nfet_01v8 ad=0.5544 pd=3.4 as=0.3465 ps=1.81 w=1.26 l=0.15
X5 a_162_47# A Y VSUBS sky130_fd_pr__nfet_01v8 ad=0.3465 pd=1.81 as=0.5544 ps=3.4 w=1.26 l=0.15
C0 A a_162_47# 0
C1 Y B 0.01759f
C2 GND a_162_47# 0.01252f
C3 Y w_0_397# 0.02347f
C4 a_302_47# B 0
C5 GND A 0.00781f
C6 C Y 0.00565f
C7 VDD a_162_47# 0.00174f
C8 a_302_47# C 0
C9 VDD A 0.00885f
C10 GND VDD 0.01702f
C11 a_162_47# B 0
C12 A B 0.02319f
C13 a_302_47# Y 0.01336f
C14 A w_0_397# 0.0369f
C15 GND B 0.00842f
C16 GND w_0_397# 0.00518f
C17 GND C 0.01221f
C18 VDD B 0.00947f
C19 VDD w_0_397# 0.06869f
C20 VDD C 0.01435f
C21 Y a_162_47# 0.02045f
C22 A Y 0.04495f
C23 GND Y 0.03698f
C24 B w_0_397# 0.03593f
C25 C B 0.02319f
C26 a_302_47# GND 0.0149f
C27 C w_0_397# 0.0369f
C28 VDD Y 0.1587f
C29 a_302_47# VDD 0
C30 GND VSUBS 0.23601f
C31 VDD VSUBS 0.31826f
C32 Y VSUBS 0.28163f
C33 a_302_47# VSUBS 0.04262f
C34 a_162_47# VSUBS 0.04262f
C35 w_0_397# VSUBS 0.53899f
.ends

.subckt lv_nand3 A B C Y VDD GND
Xu A B C Y VDD GND VDD GND nand3
C0 Y VDD 0.0123f
C1 A VDD 0.00264f
C2 VDD GND -0.08734f
C3 Y GND -0.0123f
C4 C GND 0
C5 B GND 0
C6 A GND -0.00172f
.ends
