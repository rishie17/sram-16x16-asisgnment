* NGSPICE file created from tap.ext - technology: sky130A

.subckt tap VDD GND
.ends
