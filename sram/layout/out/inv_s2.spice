* NGSPICE file created from inv_s2.ext - technology: sky130A

.subckt inv_s2 A Y VDD GND
X0 Y A GND VSUBS sky130_fd_pr__nfet_01v8 ad=0.2688 pd=2.12 as=0.2688 ps=2.12 w=0.42 l=0.15
X1 Y A VDD w_0_397# sky130_fd_pr__pfet_01v8 ad=0.5376 pd=2.96 as=0.5376 ps=2.96 w=0.84 l=0.15
.ends
