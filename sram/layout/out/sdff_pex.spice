* NGSPICE file created from sdff.ext - technology: sky130A

.subckt tg A B GN GP VDD GND w_0_481# VSUBS
X0 B GN A VSUBS sky130_fd_pr__nfet_01v8 ad=0.4578 pd=3.02 as=0.2394 ps=1.98 w=0.42 l=0.15
X1 B GP A w_0_481# sky130_fd_pr__pfet_01v8 ad=0.2394 pd=1.98 as=0.4578 ps=3.02 w=0.42 l=0.15
C0 B w_0_481# 0.01217f
C1 GND w_0_481# 0.0031f
C2 VDD w_0_481# 0.03231f
C3 GP A 0.00829f
C4 GND B 0.01781f
C5 B VDD 0.01491f
C6 GND VDD 0.01581f
C7 A w_0_481# 0.0123f
C8 GN w_0_481# 0.00258f
C9 B A 0.03146f
C10 GN B 0.00669f
C11 GND A 0.01491f
C12 GP w_0_481# 0.03758f
C13 GN GND 0.00745f
C14 VDD A 0.01781f
C15 GN VDD 0.00121f
C16 B GP 0.0201f
C17 GND GP 0.00202f
C18 VDD GP 0.00717f
C19 GN A 0.01569f
C20 GND VSUBS 0.17277f
C21 VDD VSUBS 0.14358f
C22 B VSUBS 0.29365f
C23 A VSUBS 0.29383f
C24 w_0_481# VSUBS 0.30915f
.ends

.subckt inv_s1 A Y VDD GND w_0_313# VSUBS
X0 Y A GND VSUBS sky130_fd_pr__nfet_01v8 ad=0.3465 pd=2.36 as=0.3465 ps=2.36 w=0.63 l=0.15
X1 Y A VDD w_0_313# sky130_fd_pr__pfet_01v8 ad=0.693 pd=3.62 as=0.693 ps=3.62 w=1.26 l=0.15
C0 w_0_313# A 0.0382f
C1 Y w_0_313# 0.01763f
C2 VDD GND 0.01759f
C3 VDD A 0.01248f
C4 Y VDD 0.0445f
C5 GND A 0.01221f
C6 Y GND 0.03184f
C7 VDD w_0_313# 0.04241f
C8 GND w_0_313# 0.00599f
C9 Y A 0.02936f
C10 GND VSUBS 0.26227f
C11 Y VSUBS 0.25552f
C12 VDD VSUBS 0.14929f
C13 w_0_313# VSUBS 0.40256f
.ends

.subckt inv_ff A Y VDD GND w_0_397# VSUBS
X0 Y A GND VSUBS sky130_fd_pr__nfet_01v8 ad=0.231 pd=1.94 as=0.231 ps=1.94 w=0.42 l=0.15
X1 Y A VDD w_0_397# sky130_fd_pr__pfet_01v8 ad=0.462 pd=2.78 as=0.462 ps=2.78 w=0.84 l=0.15
C0 w_0_397# A 0.03521f
C1 Y w_0_397# 0.01488f
C2 VDD GND 0.01425f
C3 VDD A 0.01246f
C4 Y VDD 0.03866f
C5 GND A 0.01196f
C6 Y GND 0.02713f
C7 VDD w_0_397# 0.04107f
C8 GND w_0_397# 0.00415f
C9 Y A 0.03133f
C10 GND VSUBS 0.31212f
C11 Y VSUBS 0.31548f
C12 VDD VSUBS 0.15626f
C13 w_0_397# VSUBS 0.31738f
.ends

.subckt inv_s2 A Y VDD GND w_0_397# VSUBS
X0 Y A GND VSUBS sky130_fd_pr__nfet_01v8 ad=0.2688 pd=2.12 as=0.2688 ps=2.12 w=0.42 l=0.15
X1 Y A VDD w_0_397# sky130_fd_pr__pfet_01v8 ad=0.5376 pd=2.96 as=0.5376 ps=2.96 w=0.84 l=0.15
C0 w_0_397# A 0.03626f
C1 Y w_0_397# 0.01549f
C2 VDD GND 0.01608f
C3 VDD A 0.01186f
C4 Y VDD 0.03977f
C5 GND A 0.0115f
C6 Y GND 0.02796f
C7 VDD w_0_397# 0.04447f
C8 GND w_0_397# 0.00441f
C9 Y A 0.02658f
C10 GND VSUBS 0.32328f
C11 Y VSUBS 0.31422f
C12 VDD VSUBS 0.16419f
C13 w_0_397# VSUBS 0.35119f
.ends

.subckt sdff D CLK Q QB VDD GND
Xt1 D t2/B ci/Y t4/GP VDD GND t4/w_0_481# VSUBS tg
Xs1 t4/B Q VDD GND t4/w_0_481# VSUBS inv_s1
Xt2 t2/A t2/B t4/GP ci/Y VDD GND t4/w_0_481# VSUBS tg
Xci CLK ci/Y VDD GND t4/w_0_481# VSUBS inv_ff
Xs2 Q QB VDD GND t4/w_0_481# VSUBS inv_s2
Xt3 t3/A t4/B t4/GP ci/Y VDD GND t4/w_0_481# VSUBS tg
Xt4 QB t4/B ci/Y t4/GP VDD GND t4/w_0_481# VSUBS tg
Xm1 t2/B t3/A VDD GND t4/w_0_481# VSUBS inv_ff
Xm2 t3/A t2/A VDD GND t4/w_0_481# VSUBS inv_ff
Xci2 ci/Y t4/GP VDD GND t4/w_0_481# VSUBS inv_ff
C0 GND t2/A 0.00513f
C1 t4/B GND 0.0356f
C2 GND CLK 0
C3 t2/B t3/A 0.43417f
C4 Q t4/w_0_481# 0.03837f
C5 GND Q 0.02098f
C6 D ci/Y 0.02359f
C7 VDD QB 0.03157f
C8 t2/A QB 0
C9 t4/B QB 0.13468f
C10 QB Q 0.07273f
C11 ci/Y t4/w_0_481# 0.05475f
C12 t4/GP VDD 0.05068f
C13 GND ci/Y 0.37141f
C14 t4/GP t2/A 0.02302f
C15 t4/B t4/GP 0.44337f
C16 CLK t4/GP 0
C17 D t4/w_0_481# 0.00492f
C18 t2/B VDD 0.04746f
C19 t2/B t2/A 0.01509f
C20 GND D -0
C21 VDD t3/A 0.10931f
C22 t4/GP Q 0.02398f
C23 t2/B t4/B 0.00575f
C24 t2/B CLK 0
C25 t2/A t3/A 0.07388f
C26 t4/B t3/A 0.01039f
C27 CLK t3/A 0
C28 t2/B Q 0
C29 ci/Y QB 0.03505f
C30 Q t3/A 0.00441f
C31 GND t4/w_0_481# -0.0075f
C32 ci/Y t4/GP 1.1467f
C33 t2/B ci/Y 0.1398f
C34 D t4/GP 0.07483f
C35 ci/Y t3/A 0.08054f
C36 QB t4/w_0_481# 0.03183f
C37 VDD t2/A 0.02877f
C38 GND QB 0.00478f
C39 t4/B VDD 0.07493f
C40 t2/B D 0.00132f
C41 CLK VDD 0
C42 t4/B t2/A 0
C43 D t3/A 0.00277f
C44 VDD Q 0.09077f
C45 t2/A Q 0.00186f
C46 t4/B Q 0.08298f
C47 t4/GP t4/w_0_481# 0.05017f
C48 GND t4/GP 0.0766f
C49 t2/B t4/w_0_481# 0.02293f
C50 t3/A t4/w_0_481# 0.06077f
C51 t2/B GND 0.03114f
C52 GND t3/A 0.02131f
C53 ci/Y VDD 0.06848f
C54 ci/Y t2/A 0.02764f
C55 t4/GP QB 0.04899f
C56 t4/B ci/Y 0.10363f
C57 CLK ci/Y 0.01684f
C58 D VDD 0.00199f
C59 t2/B QB 0
C60 ci/Y Q 0.02462f
C61 QB t3/A 0.00626f
C62 t2/B t4/GP 0.44783f
C63 VDD t4/w_0_481# 0.05195f
C64 t2/A t4/w_0_481# 0.02174f
C65 t4/GP t3/A 0.10169f
C66 GND VDD -0.0601f
C67 t4/B t4/w_0_481# 0.03404f
C68 CLK t4/w_0_481# 0.00275f
C69 t4/GP VSUBS 0.31478f
C70 t4/w_0_481# VSUBS 0
C71 t2/A VSUBS -0.20785f
C72 t3/A VSUBS 0.0681f
C73 t4/B VSUBS 0.24318f
C74 QB VSUBS -0.06744f
C75 GND VSUBS -0.40661f
C76 ci/Y VSUBS 0.99901f
C77 VDD VSUBS -0.51915f
C78 CLK VSUBS -0.02159f
C79 Q VSUBS -0.10104f
C80 t2/B VSUBS -0
C81 D VSUBS -0.08626f
.ends
