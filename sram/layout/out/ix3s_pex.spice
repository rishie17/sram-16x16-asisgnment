* NGSPICE file created from ix3s.ext - technology: sky130A

.subckt ix3s A Y VDD GND
X0 GND A Y VSUBS sky130_fd_pr__nfet_01v8 ad=0.1155 pd=0.97 as=0.1155 ps=0.97 w=0.42 l=0.15
X1 Y A VDD w_0_397# sky130_fd_pr__pfet_01v8 ad=0.3696 pd=2.56 as=0.231 ps=1.39 w=0.84 l=0.15
X2 VDD A Y w_0_397# sky130_fd_pr__pfet_01v8 ad=0.231 pd=1.39 as=0.231 ps=1.39 w=0.84 l=0.15
X3 Y A VDD w_0_397# sky130_fd_pr__pfet_01v8 ad=0.231 pd=1.39 as=0.3696 ps=2.56 w=0.84 l=0.15
X4 Y A GND VSUBS sky130_fd_pr__nfet_01v8 ad=0.1848 pd=1.72 as=0.1155 ps=0.97 w=0.42 l=0.15
X5 Y A GND VSUBS sky130_fd_pr__nfet_01v8 ad=0.1155 pd=0.97 as=0.1848 ps=1.72 w=0.42 l=0.15
C0 GND VDD 0.01455f
C1 Y VDD 0.16477f
C2 Y GND 0.07486f
C3 VDD w_0_397# 0.06869f
C4 A VDD 0.03242f
C5 GND w_0_397# 0.00524f
C6 GND A 0.03906f
C7 Y w_0_397# 0.02803f
C8 Y A 0.13072f
C9 A w_0_397# 0.10767f
C10 GND VSUBS 0.56842f
C11 Y VSUBS 0.54867f
C12 VDD VSUBS 0.20762f
C13 w_0_397# VSUBS 0.53899f
.ends
