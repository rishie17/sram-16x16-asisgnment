* NGSPICE file created from c1n.ext - technology: sky130A

.subckt c1n A B Y VDD GND
X0 GND B a_184_47# VSUBS sky130_fd_pr__nfet_01v8 ad=0.924 pd=4.46 as=0.6468 ps=2.45 w=1.68 l=0.15
X1 a_184_47# A Y VSUBS sky130_fd_pr__nfet_01v8 ad=0.6468 pd=2.45 as=0.924 ps=4.46 w=1.68 l=0.15
.ends
