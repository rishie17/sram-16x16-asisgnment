* NGSPICE file created from rw_wr.ext - technology: sky130A

.subckt rw_wr WE DINB DIN DL DLB VDD GND WE_uq0
X0 GND DINB a_184_47# VSUBS sky130_fd_pr__nfet_01v8 ad=0.6468 pd=2.45 as=0.6468 ps=2.45 w=1.68 l=0.15
X1 a_184_47# WE DL VSUBS sky130_fd_pr__nfet_01v8 ad=0.6468 pd=2.45 as=0.924 ps=4.46 w=1.68 l=0.15
X2 a_552_47# DIN GND VSUBS sky130_fd_pr__nfet_01v8 ad=0.6468 pd=2.45 as=0.6468 ps=2.45 w=1.68 l=0.15
X3 DLB WE_uq0 a_552_47# VSUBS sky130_fd_pr__nfet_01v8 ad=0.924 pd=4.46 as=0.6468 ps=2.45 w=1.68 l=0.15
C0 a_184_47# WE 0
C1 DIN VDD 0.00534f
C2 GND WE 0.00878f
C3 DIN DINB 0.01263f
C4 DIN WE_uq0 0.01263f
C5 a_552_47# DLB 0.00465f
C6 a_184_47# DL 0.00465f
C7 GND DL 0.02013f
C8 DINB VDD 0.00534f
C9 WE_uq0 VDD 0.00534f
C10 a_184_47# GND 0.03091f
C11 DIN DLB 0
C12 DLB VDD 0.00648f
C13 a_552_47# GND 0.03091f
C14 DLB WE_uq0 0.00245f
C15 WE VDD 0.00534f
C16 WE DINB 0.01263f
C17 GND DIN 0.01497f
C18 DL VDD 0.00648f
C19 DINB DL 0
C20 a_184_47# VDD 0.00909f
C21 GND VDD 0.04012f
C22 a_184_47# DINB 0
C23 a_552_47# DIN 0
C24 GND DINB 0.01497f
C25 GND WE_uq0 0.00878f
C26 a_552_47# VDD 0.00909f
C27 WE DL 0.00245f
C28 a_552_47# WE_uq0 0
C29 GND DLB 0.02013f
C30 VDD VSUBS 0.31272f
C31 DLB VSUBS 0.08832f
C32 GND VSUBS 0.45031f
C33 DL VSUBS 0.08832f
C34 a_552_47# VSUBS 0.11864f
C35 a_184_47# VSUBS 0.11864f
.ends
