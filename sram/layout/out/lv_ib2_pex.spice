* NGSPICE file created from lv_ib2.ext - technology: sky130A

.subckt ib2 A Y VDD GND w_0_341# VSUBS
X0 Y A VDD w_0_341# sky130_fd_pr__pfet_01v8 ad=0.308 pd=1.67 as=0.4928 ps=3.12 w=1.12 l=0.15
X1 GND A Y VSUBS sky130_fd_pr__nfet_01v8 ad=0.154 pd=1.11 as=0.154 ps=1.11 w=0.56 l=0.15
X2 Y A GND VSUBS sky130_fd_pr__nfet_01v8 ad=0.2464 pd=2 as=0.154 ps=1.11 w=0.56 l=0.15
X3 Y A VDD w_0_341# sky130_fd_pr__pfet_01v8 ad=0.4928 pd=3.12 as=0.308 ps=1.67 w=1.12 l=0.15
X4 VDD A Y w_0_341# sky130_fd_pr__pfet_01v8 ad=0.308 pd=1.67 as=0.308 ps=1.67 w=1.12 l=0.15
X5 Y A GND VSUBS sky130_fd_pr__nfet_01v8 ad=0.154 pd=1.11 as=0.2464 ps=2 w=0.56 l=0.15
C0 A Y 0.12555f
C1 A w_0_341# 0.11912f
C2 w_0_341# Y 0.02983f
C3 A VDD 0.0323f
C4 GND A 0.03955f
C5 Y VDD 0.17724f
C6 GND Y 0.08294f
C7 w_0_341# VDD 0.0696f
C8 GND w_0_341# 0.00662f
C9 GND VDD 0.01808f
C10 GND VSUBS 0.2632f
C11 Y VSUBS 0.45334f
C12 VDD VSUBS 0.43414f
C13 w_0_341# VSUBS 0.63542f
.ends

.subckt lv_ib2 A Y VDD GND
Xu A Y VDD GND VDD GND ib2
C0 VDD A 0.00178f
C1 VDD Y 0.00535f
C2 Y GND -0.00535f
C3 VDD GND -0.09896f
C4 A GND -0.00112f
.ends
