* NGSPICE file created from rterm.ext - technology: sky130A

.subckt rterm A B
X0 A B sky130_fd_pr__res_generic_po w=8.2 l=3.4
.ends
