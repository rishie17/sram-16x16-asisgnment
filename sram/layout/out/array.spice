* NGSPICE file created from array.ext - technology: sky130A

.subckt bitcell BL BLB WL VDD GND Q QB
X0 QB Q VDD VDD sky130_fd_pr__pfet_01v8 ad=0.1848 pd=1.72 as=0.1155 ps=0.97 w=0.42 l=0.15
X1 VDD QB Q VDD sky130_fd_pr__pfet_01v8 ad=0.1155 pd=0.97 as=0.1848 ps=1.72 w=0.42 l=0.15
X2 GND QB Q GND sky130_fd_pr__nfet_01v8 ad=0.17325 pd=1.18 as=0.14437 ps=1.18 w=0.63 l=0.15
X3 Q WL BL GND sky130_fd_pr__nfet_01v8 ad=0.14437 pd=1.18 as=0.1848 ps=1.72 w=0.42 l=0.15
X4 QB Q GND GND sky130_fd_pr__nfet_01v8 ad=0.14437 pd=1.18 as=0.17325 ps=1.18 w=0.63 l=0.15
X5 BLB WL QB GND sky130_fd_pr__nfet_01v8 ad=0.1848 pd=1.72 as=0.14437 ps=1.18 w=0.42 l=0.15
.ends

.subckt array
Xc_11_1 c_9_1/BL c_9_1/BLB c_11_9/WL c_11_9/VDD VSUBS c_11_1/Q c_11_1/QB bitcell
Xc_3_14 c_9_14/BL c_9_14/BLB c_3_9/WL c_3_9/VDD VSUBS c_3_14/Q c_3_14/QB bitcell
Xc_0_15 c_9_15/BL c_9_15/BLB c_0_9/WL c_1_9/VDD VSUBS c_0_15/Q c_0_15/QB bitcell
Xc_15_8 c_9_8/BL c_9_8/BLB c_15_9/WL c_15_9/VDD VSUBS c_15_8/Q c_15_8/QB bitcell
Xc_9_13 c_9_13/BL c_9_13/BLB c_9_9/WL c_9_9/VDD VSUBS c_9_13/Q c_9_13/QB bitcell
Xc_3_7 c_9_7/BL c_9_7/BLB c_3_9/WL c_3_9/VDD VSUBS c_3_7/Q c_3_7/QB bitcell
Xc_13_5 c_9_5/BL c_9_5/BLB c_13_9/WL c_13_9/VDD VSUBS c_13_5/Q c_13_5/QB bitcell
Xc_11_2 c_9_2/BL c_9_2/BLB c_11_9/WL c_11_9/VDD VSUBS c_11_2/Q c_11_2/QB bitcell
Xc_6_14 c_9_14/BL c_9_14/BLB c_6_9/WL c_7_9/VDD VSUBS c_6_14/Q c_6_14/QB bitcell
Xc_1_4 c_9_4/BL c_9_4/BLB c_1_9/WL c_1_9/VDD VSUBS c_1_4/Q c_1_4/QB bitcell
Xc_3_15 c_9_15/BL c_9_15/BLB c_3_9/WL c_3_9/VDD VSUBS c_3_15/Q c_3_15/QB bitcell
Xc_11_10 c_9_10/BL c_9_10/BLB c_11_9/WL c_11_9/VDD VSUBS c_11_10/Q c_11_10/QB bitcell
Xc_9_14 c_9_14/BL c_9_14/BLB c_9_9/WL c_9_9/VDD VSUBS c_9_14/Q c_9_14/QB bitcell
Xc_15_9 c_9_9/BL c_9_9/BLB c_15_9/WL c_15_9/VDD VSUBS c_15_9/Q c_15_9/QB bitcell
Xc_13_6 c_9_6/BL c_9_6/BLB c_13_9/WL c_13_9/VDD VSUBS c_13_6/Q c_13_6/QB bitcell
Xc_6_15 c_9_15/BL c_9_15/BLB c_6_9/WL c_7_9/VDD VSUBS c_6_15/Q c_6_15/QB bitcell
Xc_1_5 c_9_5/BL c_9_5/BLB c_1_9/WL c_1_9/VDD VSUBS c_1_5/Q c_1_5/QB bitcell
Xc_3_8 c_9_8/BL c_9_8/BLB c_3_9/WL c_3_9/VDD VSUBS c_3_8/Q c_3_8/QB bitcell
Xc_14_10 c_9_10/BL c_9_10/BLB c_14_9/WL c_15_9/VDD VSUBS c_14_10/Q c_14_10/QB bitcell
Xc_11_3 c_9_3/BL c_9_3/BLB c_11_9/WL c_11_9/VDD VSUBS c_11_3/Q c_11_3/QB bitcell
Xc_11_11 c_9_11/BL c_9_11/BLB c_11_9/WL c_11_9/VDD VSUBS c_11_11/Q c_11_11/QB bitcell
Xc_9_15 c_9_15/BL c_9_15/BLB c_9_9/WL c_9_9/VDD VSUBS c_9_15/Q c_9_15/QB bitcell
Xc_3_9 c_9_9/BL c_9_9/BLB c_3_9/WL c_3_9/VDD VSUBS c_3_9/Q c_3_9/QB bitcell
Xc_13_7 c_9_7/BL c_9_7/BLB c_13_9/WL c_13_9/VDD VSUBS c_13_7/Q c_13_7/QB bitcell
Xc_1_6 c_9_6/BL c_9_6/BLB c_1_9/WL c_1_9/VDD VSUBS c_1_6/Q c_1_6/QB bitcell
Xc_14_11 c_9_11/BL c_9_11/BLB c_14_9/WL c_15_9/VDD VSUBS c_14_11/Q c_14_11/QB bitcell
Xc_11_4 c_9_4/BL c_9_4/BLB c_11_9/WL c_11_9/VDD VSUBS c_11_4/Q c_11_4/QB bitcell
Xc_11_12 c_9_12/BL c_9_12/BLB c_11_9/WL c_11_9/VDD VSUBS c_11_12/Q c_11_12/QB bitcell
Xc_13_8 c_9_8/BL c_9_8/BLB c_13_9/WL c_13_9/VDD VSUBS c_13_8/Q c_13_8/QB bitcell
Xc_8_0 c_9_0/BL c_9_0/BLB c_8_9/WL c_9_9/VDD VSUBS c_8_0/Q c_8_0/QB bitcell
Xc_1_7 c_9_7/BL c_9_7/BLB c_1_9/WL c_1_9/VDD VSUBS c_1_7/Q c_1_7/QB bitcell
Xc_14_12 c_9_12/BL c_9_12/BLB c_14_9/WL c_15_9/VDD VSUBS c_14_12/Q c_14_12/QB bitcell
Xc_11_5 c_9_5/BL c_9_5/BLB c_11_9/WL c_11_9/VDD VSUBS c_11_5/Q c_11_5/QB bitcell
Xc_11_13 c_9_13/BL c_9_13/BLB c_11_9/WL c_11_9/VDD VSUBS c_11_13/Q c_11_13/QB bitcell
Xc_8_1 c_9_1/BL c_9_1/BLB c_8_9/WL c_9_9/VDD VSUBS c_8_1/Q c_8_1/QB bitcell
Xc_13_9 c_9_9/BL c_9_9/BLB c_13_9/WL c_13_9/VDD VSUBS c_13_9/Q c_13_9/QB bitcell
Xc_1_8 c_9_8/BL c_9_8/BLB c_1_9/WL c_1_9/VDD VSUBS c_1_8/Q c_1_8/QB bitcell
Xc_14_13 c_9_13/BL c_9_13/BLB c_14_9/WL c_15_9/VDD VSUBS c_14_13/Q c_14_13/QB bitcell
Xc_11_6 c_9_6/BL c_9_6/BLB c_11_9/WL c_11_9/VDD VSUBS c_11_6/Q c_11_6/QB bitcell
Xc_11_14 c_9_14/BL c_9_14/BLB c_11_9/WL c_11_9/VDD VSUBS c_11_14/Q c_11_14/QB bitcell
Xc_8_2 c_9_2/BL c_9_2/BLB c_8_9/WL c_9_9/VDD VSUBS c_8_2/Q c_8_2/QB bitcell
Xc_1_9 c_9_9/BL c_9_9/BLB c_1_9/WL c_1_9/VDD VSUBS c_1_9/Q c_1_9/QB bitcell
Xc_14_14 c_9_14/BL c_9_14/BLB c_14_9/WL c_15_9/VDD VSUBS c_14_14/Q c_14_14/QB bitcell
Xc_11_7 c_9_7/BL c_9_7/BLB c_11_9/WL c_11_9/VDD VSUBS c_11_7/Q c_11_7/QB bitcell
Xc_11_15 c_9_15/BL c_9_15/BLB c_11_9/WL c_11_9/VDD VSUBS c_11_15/Q c_11_15/QB bitcell
Xc_8_3 c_9_3/BL c_9_3/BLB c_8_9/WL c_9_9/VDD VSUBS c_8_3/Q c_8_3/QB bitcell
Xc_6_0 c_9_0/BL c_9_0/BLB c_6_9/WL c_7_9/VDD VSUBS c_6_0/Q c_6_0/QB bitcell
Xc_14_15 c_9_15/BL c_9_15/BLB c_14_9/WL c_15_9/VDD VSUBS c_14_15/Q c_14_15/QB bitcell
Xc_11_8 c_9_8/BL c_9_8/BLB c_11_9/WL c_11_9/VDD VSUBS c_11_8/Q c_11_8/QB bitcell
Xc_8_4 c_9_4/BL c_9_4/BLB c_8_9/WL c_9_9/VDD VSUBS c_8_4/Q c_8_4/QB bitcell
Xc_1_10 c_9_10/BL c_9_10/BLB c_1_9/WL c_1_9/VDD VSUBS c_1_10/Q c_1_10/QB bitcell
Xc_11_9 c_9_9/BL c_9_9/BLB c_11_9/WL c_11_9/VDD VSUBS c_11_9/Q c_11_9/QB bitcell
Xc_6_1 c_9_1/BL c_9_1/BLB c_6_9/WL c_7_9/VDD VSUBS c_6_1/Q c_6_1/QB bitcell
Xc_4_10 c_9_10/BL c_9_10/BLB c_4_9/WL c_5_9/VDD VSUBS c_4_10/Q c_4_10/QB bitcell
Xc_8_5 c_9_5/BL c_9_5/BLB c_8_9/WL c_9_9/VDD VSUBS c_8_5/Q c_8_5/QB bitcell
Xc_1_11 c_9_11/BL c_9_11/BLB c_1_9/WL c_1_9/VDD VSUBS c_1_11/Q c_1_11/QB bitcell
Xc_6_2 c_9_2/BL c_9_2/BLB c_6_9/WL c_7_9/VDD VSUBS c_6_2/Q c_6_2/QB bitcell
Xc_7_10 c_9_10/BL c_9_10/BLB c_7_9/WL c_7_9/VDD VSUBS c_7_10/Q c_7_10/QB bitcell
Xc_4_11 c_9_11/BL c_9_11/BLB c_4_9/WL c_5_9/VDD VSUBS c_4_11/Q c_4_11/QB bitcell
Xc_8_6 c_9_6/BL c_9_6/BLB c_8_9/WL c_9_9/VDD VSUBS c_8_6/Q c_8_6/QB bitcell
Xc_1_12 c_9_12/BL c_9_12/BLB c_1_9/WL c_1_9/VDD VSUBS c_1_12/Q c_1_12/QB bitcell
Xc_6_3 c_9_3/BL c_9_3/BLB c_6_9/WL c_7_9/VDD VSUBS c_6_3/Q c_6_3/QB bitcell
Xc_7_11 c_9_11/BL c_9_11/BLB c_7_9/WL c_7_9/VDD VSUBS c_7_11/Q c_7_11/QB bitcell
Xc_4_0 c_9_0/BL c_9_0/BLB c_4_9/WL c_5_9/VDD VSUBS c_4_0/Q c_4_0/QB bitcell
Xc_4_12 c_9_12/BL c_9_12/BLB c_4_9/WL c_5_9/VDD VSUBS c_4_12/Q c_4_12/QB bitcell
Xc_8_7 c_9_7/BL c_9_7/BLB c_8_9/WL c_9_9/VDD VSUBS c_8_7/Q c_8_7/QB bitcell
Xc_1_13 c_9_13/BL c_9_13/BLB c_1_9/WL c_1_9/VDD VSUBS c_1_13/Q c_1_13/QB bitcell
Xc_6_4 c_9_4/BL c_9_4/BLB c_6_9/WL c_7_9/VDD VSUBS c_6_4/Q c_6_4/QB bitcell
Xc_7_12 c_9_12/BL c_9_12/BLB c_7_9/WL c_7_9/VDD VSUBS c_7_12/Q c_7_12/QB bitcell
Xc_4_1 c_9_1/BL c_9_1/BLB c_4_9/WL c_5_9/VDD VSUBS c_4_1/Q c_4_1/QB bitcell
Xc_4_13 c_9_13/BL c_9_13/BLB c_4_9/WL c_5_9/VDD VSUBS c_4_13/Q c_4_13/QB bitcell
Xc_8_8 c_9_8/BL c_9_8/BLB c_8_9/WL c_9_9/VDD VSUBS c_8_8/Q c_8_8/QB bitcell
Xc_1_14 c_9_14/BL c_9_14/BLB c_1_9/WL c_1_9/VDD VSUBS c_1_14/Q c_1_14/QB bitcell
Xc_6_5 c_9_5/BL c_9_5/BLB c_6_9/WL c_7_9/VDD VSUBS c_6_5/Q c_6_5/QB bitcell
Xc_14_0 c_9_0/BL c_9_0/BLB c_14_9/WL c_15_9/VDD VSUBS c_14_0/Q c_14_0/QB bitcell
Xc_7_13 c_9_13/BL c_9_13/BLB c_7_9/WL c_7_9/VDD VSUBS c_7_13/Q c_7_13/QB bitcell
Xc_4_2 c_9_2/BL c_9_2/BLB c_4_9/WL c_5_9/VDD VSUBS c_4_2/Q c_4_2/QB bitcell
Xc_4_14 c_9_14/BL c_9_14/BLB c_4_9/WL c_5_9/VDD VSUBS c_4_14/Q c_4_14/QB bitcell
Xc_8_9 c_9_9/BL c_9_9/BLB c_8_9/WL c_9_9/VDD VSUBS c_8_9/Q c_8_9/QB bitcell
Xc_1_15 c_9_15/BL c_9_15/BLB c_1_9/WL c_1_9/VDD VSUBS c_1_15/Q c_1_15/QB bitcell
Xc_7_14 c_9_14/BL c_9_14/BLB c_7_9/WL c_7_9/VDD VSUBS c_7_14/Q c_7_14/QB bitcell
Xc_6_6 c_9_6/BL c_9_6/BLB c_6_9/WL c_7_9/VDD VSUBS c_6_6/Q c_6_6/QB bitcell
Xc_4_3 c_9_3/BL c_9_3/BLB c_4_9/WL c_5_9/VDD VSUBS c_4_3/Q c_4_3/QB bitcell
Xc_14_1 c_9_1/BL c_9_1/BLB c_14_9/WL c_15_9/VDD VSUBS c_14_1/Q c_14_1/QB bitcell
Xc_2_0 c_9_0/BL c_9_0/BLB c_2_9/WL c_3_9/VDD VSUBS c_2_0/Q c_2_0/QB bitcell
Xc_4_15 c_9_15/BL c_9_15/BLB c_4_9/WL c_5_9/VDD VSUBS c_4_15/Q c_4_15/QB bitcell
Xc_12_10 c_9_10/BL c_9_10/BLB c_12_9/WL c_13_9/VDD VSUBS c_12_10/Q c_12_10/QB bitcell
Xc_6_7 c_9_7/BL c_9_7/BLB c_6_9/WL c_7_9/VDD VSUBS c_6_7/Q c_6_7/QB bitcell
Xc_14_2 c_9_2/BL c_9_2/BLB c_14_9/WL c_15_9/VDD VSUBS c_14_2/Q c_14_2/QB bitcell
Xc_7_15 c_9_15/BL c_9_15/BLB c_7_9/WL c_7_9/VDD VSUBS c_7_15/Q c_7_15/QB bitcell
Xc_2_1 c_9_1/BL c_9_1/BLB c_2_9/WL c_3_9/VDD VSUBS c_2_1/Q c_2_1/QB bitcell
Xc_4_4 c_9_4/BL c_9_4/BLB c_4_9/WL c_5_9/VDD VSUBS c_4_4/Q c_4_4/QB bitcell
Xc_15_10 c_9_10/BL c_9_10/BLB c_15_9/WL c_15_9/VDD VSUBS c_15_10/Q c_15_10/QB bitcell
Xc_12_11 c_9_11/BL c_9_11/BLB c_12_9/WL c_13_9/VDD VSUBS c_12_11/Q c_12_11/QB bitcell
Xc_6_8 c_9_8/BL c_9_8/BLB c_6_9/WL c_7_9/VDD VSUBS c_6_8/Q c_6_8/QB bitcell
Xc_4_5 c_9_5/BL c_9_5/BLB c_4_9/WL c_5_9/VDD VSUBS c_4_5/Q c_4_5/QB bitcell
Xc_15_11 c_9_11/BL c_9_11/BLB c_15_9/WL c_15_9/VDD VSUBS c_15_11/Q c_15_11/QB bitcell
Xc_14_3 c_9_3/BL c_9_3/BLB c_14_9/WL c_15_9/VDD VSUBS c_14_3/Q c_14_3/QB bitcell
Xc_2_2 c_9_2/BL c_9_2/BLB c_2_9/WL c_3_9/VDD VSUBS c_2_2/Q c_2_2/QB bitcell
Xc_12_12 c_9_12/BL c_9_12/BLB c_12_9/WL c_13_9/VDD VSUBS c_12_12/Q c_12_12/QB bitcell
Xc_12_0 c_9_0/BL c_9_0/BLB c_12_9/WL c_13_9/VDD VSUBS c_12_0/Q c_12_0/QB bitcell
Xc_6_9 c_9_9/BL c_9_9/BLB c_6_9/WL c_7_9/VDD VSUBS c_6_9/Q c_6_9/QB bitcell
Xc_4_6 c_9_6/BL c_9_6/BLB c_4_9/WL c_5_9/VDD VSUBS c_4_6/Q c_4_6/QB bitcell
Xc_15_12 c_9_12/BL c_9_12/BLB c_15_9/WL c_15_9/VDD VSUBS c_15_12/Q c_15_12/QB bitcell
Xc_14_4 c_9_4/BL c_9_4/BLB c_14_9/WL c_15_9/VDD VSUBS c_14_4/Q c_14_4/QB bitcell
Xc_12_1 c_9_1/BL c_9_1/BLB c_12_9/WL c_13_9/VDD VSUBS c_12_1/Q c_12_1/QB bitcell
Xc_0_0 c_9_0/BL c_9_0/BLB c_0_9/WL c_1_9/VDD VSUBS c_0_0/Q c_0_0/QB bitcell
Xc_2_3 c_9_3/BL c_9_3/BLB c_2_9/WL c_3_9/VDD VSUBS c_2_3/Q c_2_3/QB bitcell
Xc_12_13 c_9_13/BL c_9_13/BLB c_12_9/WL c_13_9/VDD VSUBS c_12_13/Q c_12_13/QB bitcell
Xc_4_7 c_9_7/BL c_9_7/BLB c_4_9/WL c_5_9/VDD VSUBS c_4_7/Q c_4_7/QB bitcell
Xc_15_13 c_9_13/BL c_9_13/BLB c_15_9/WL c_15_9/VDD VSUBS c_15_13/Q c_15_13/QB bitcell
Xc_14_5 c_9_5/BL c_9_5/BLB c_14_9/WL c_15_9/VDD VSUBS c_14_5/Q c_14_5/QB bitcell
Xc_2_4 c_9_4/BL c_9_4/BLB c_2_9/WL c_3_9/VDD VSUBS c_2_4/Q c_2_4/QB bitcell
Xc_12_14 c_9_14/BL c_9_14/BLB c_12_9/WL c_13_9/VDD VSUBS c_12_14/Q c_12_14/QB bitcell
Xc_12_2 c_9_2/BL c_9_2/BLB c_12_9/WL c_13_9/VDD VSUBS c_12_2/Q c_12_2/QB bitcell
Xc_0_1 c_9_1/BL c_9_1/BLB c_0_9/WL c_1_9/VDD VSUBS c_0_1/Q c_0_1/QB bitcell
Xc_4_8 c_9_8/BL c_9_8/BLB c_4_9/WL c_5_9/VDD VSUBS c_4_8/Q c_4_8/QB bitcell
Xc_15_14 c_9_14/BL c_9_14/BLB c_15_9/WL c_15_9/VDD VSUBS c_15_14/Q c_15_14/QB bitcell
Xc_14_6 c_9_6/BL c_9_6/BLB c_14_9/WL c_15_9/VDD VSUBS c_14_6/Q c_14_6/QB bitcell
Xc_12_3 c_9_3/BL c_9_3/BLB c_12_9/WL c_13_9/VDD VSUBS c_12_3/Q c_12_3/QB bitcell
Xc_0_2 c_9_2/BL c_9_2/BLB c_0_9/WL c_1_9/VDD VSUBS c_0_2/Q c_0_2/QB bitcell
Xc_2_5 c_9_5/BL c_9_5/BLB c_2_9/WL c_3_9/VDD VSUBS c_2_5/Q c_2_5/QB bitcell
Xc_12_15 c_9_15/BL c_9_15/BLB c_12_9/WL c_13_9/VDD VSUBS c_12_15/Q c_12_15/QB bitcell
Xc_10_0 c_9_0/BL c_9_0/BLB c_10_9/WL c_11_9/VDD VSUBS c_10_0/Q c_10_0/QB bitcell
Xc_15_15 c_9_15/BL c_9_15/BLB c_15_9/WL c_15_9/VDD VSUBS c_15_15/Q c_15_15/QB bitcell
Xc_14_7 c_9_7/BL c_9_7/BLB c_14_9/WL c_15_9/VDD VSUBS c_14_7/Q c_14_7/QB bitcell
Xc_2_6 c_9_6/BL c_9_6/BLB c_2_9/WL c_3_9/VDD VSUBS c_2_6/Q c_2_6/QB bitcell
Xc_4_9 c_9_9/BL c_9_9/BLB c_4_9/WL c_5_9/VDD VSUBS c_4_9/Q c_4_9/QB bitcell
Xc_12_4 c_9_4/BL c_9_4/BLB c_12_9/WL c_13_9/VDD VSUBS c_12_4/Q c_12_4/QB bitcell
Xc_0_3 c_9_3/BL c_9_3/BLB c_0_9/WL c_1_9/VDD VSUBS c_0_3/Q c_0_3/QB bitcell
Xc_10_1 c_9_1/BL c_9_1/BLB c_10_9/WL c_11_9/VDD VSUBS c_10_1/Q c_10_1/QB bitcell
Xc_9_0 c_9_0/BL c_9_0/BLB c_9_9/WL c_9_9/VDD VSUBS c_9_0/Q c_9_0/QB bitcell
Xc_2_10 c_9_10/BL c_9_10/BLB c_2_9/WL c_3_9/VDD VSUBS c_2_10/Q c_2_10/QB bitcell
Xc_14_8 c_9_8/BL c_9_8/BLB c_14_9/WL c_15_9/VDD VSUBS c_14_8/Q c_14_8/QB bitcell
Xc_12_5 c_9_5/BL c_9_5/BLB c_12_9/WL c_13_9/VDD VSUBS c_12_5/Q c_12_5/QB bitcell
Xc_0_4 c_9_4/BL c_9_4/BLB c_0_9/WL c_1_9/VDD VSUBS c_0_4/Q c_0_4/QB bitcell
Xc_2_7 c_9_7/BL c_9_7/BLB c_2_9/WL c_3_9/VDD VSUBS c_2_7/Q c_2_7/QB bitcell
Xc_10_2 c_9_2/BL c_9_2/BLB c_10_9/WL c_11_9/VDD VSUBS c_10_2/Q c_10_2/QB bitcell
Xc_5_10 c_9_10/BL c_9_10/BLB c_5_9/WL c_5_9/VDD VSUBS c_5_10/Q c_5_10/QB bitcell
Xc_2_11 c_9_11/BL c_9_11/BLB c_2_9/WL c_3_9/VDD VSUBS c_2_11/Q c_2_11/QB bitcell
Xc_14_9 c_9_9/BL c_9_9/BLB c_14_9/WL c_15_9/VDD VSUBS c_14_9/Q c_14_9/QB bitcell
Xc_8_10 c_9_10/BL c_9_10/BLB c_8_9/WL c_9_9/VDD VSUBS c_8_10/Q c_8_10/QB bitcell
Xc_9_1 c_9_1/BL c_9_1/BLB c_9_9/WL c_9_9/VDD VSUBS c_9_1/Q c_9_1/QB bitcell
Xc_2_8 c_9_8/BL c_9_8/BLB c_2_9/WL c_3_9/VDD VSUBS c_2_8/Q c_2_8/QB bitcell
Xc_12_6 c_9_6/BL c_9_6/BLB c_12_9/WL c_13_9/VDD VSUBS c_12_6/Q c_12_6/QB bitcell
Xc_0_5 c_9_5/BL c_9_5/BLB c_0_9/WL c_1_9/VDD VSUBS c_0_5/Q c_0_5/QB bitcell
Xc_10_3 c_9_3/BL c_9_3/BLB c_10_9/WL c_11_9/VDD VSUBS c_10_3/Q c_10_3/QB bitcell
Xc_5_11 c_9_11/BL c_9_11/BLB c_5_9/WL c_5_9/VDD VSUBS c_5_11/Q c_5_11/QB bitcell
Xc_9_2 c_9_2/BL c_9_2/BLB c_9_9/WL c_9_9/VDD VSUBS c_9_2/Q c_9_2/QB bitcell
Xc_2_12 c_9_12/BL c_9_12/BLB c_2_9/WL c_3_9/VDD VSUBS c_2_12/Q c_2_12/QB bitcell
Xc_8_11 c_9_11/BL c_9_11/BLB c_8_9/WL c_9_9/VDD VSUBS c_8_11/Q c_8_11/QB bitcell
Xc_0_6 c_9_6/BL c_9_6/BLB c_0_9/WL c_1_9/VDD VSUBS c_0_6/Q c_0_6/QB bitcell
Xc_2_9 c_9_9/BL c_9_9/BLB c_2_9/WL c_3_9/VDD VSUBS c_2_9/Q c_2_9/QB bitcell
Xc_12_7 c_9_7/BL c_9_7/BLB c_12_9/WL c_13_9/VDD VSUBS c_12_7/Q c_12_7/QB bitcell
Xc_10_4 c_9_4/BL c_9_4/BLB c_10_9/WL c_11_9/VDD VSUBS c_10_4/Q c_10_4/QB bitcell
Xc_5_12 c_9_12/BL c_9_12/BLB c_5_9/WL c_5_9/VDD VSUBS c_5_12/Q c_5_12/QB bitcell
Xc_2_13 c_9_13/BL c_9_13/BLB c_2_9/WL c_3_9/VDD VSUBS c_2_13/Q c_2_13/QB bitcell
Xc_9_3 c_9_3/BL c_9_3/BLB c_9_9/WL c_9_9/VDD VSUBS c_9_3/Q c_9_3/QB bitcell
Xc_12_8 c_9_8/BL c_9_8/BLB c_12_9/WL c_13_9/VDD VSUBS c_12_8/Q c_12_8/QB bitcell
Xc_8_12 c_9_12/BL c_9_12/BLB c_8_9/WL c_9_9/VDD VSUBS c_8_12/Q c_8_12/QB bitcell
Xc_0_7 c_9_7/BL c_9_7/BLB c_0_9/WL c_1_9/VDD VSUBS c_0_7/Q c_0_7/QB bitcell
Xc_7_0 c_9_0/BL c_9_0/BLB c_7_9/WL c_7_9/VDD VSUBS c_7_0/Q c_7_0/QB bitcell
Xc_10_5 c_9_5/BL c_9_5/BLB c_10_9/WL c_11_9/VDD VSUBS c_10_5/Q c_10_5/QB bitcell
Xc_5_13 c_9_13/BL c_9_13/BLB c_5_9/WL c_5_9/VDD VSUBS c_5_13/Q c_5_13/QB bitcell
Xc_9_4 c_9_4/BL c_9_4/BLB c_9_9/WL c_9_9/VDD VSUBS c_9_4/Q c_9_4/QB bitcell
Xc_2_14 c_9_14/BL c_9_14/BLB c_2_9/WL c_3_9/VDD VSUBS c_2_14/Q c_2_14/QB bitcell
Xc_8_13 c_9_13/BL c_9_13/BLB c_8_9/WL c_9_9/VDD VSUBS c_8_13/Q c_8_13/QB bitcell
Xc_7_1 c_9_1/BL c_9_1/BLB c_7_9/WL c_7_9/VDD VSUBS c_7_1/Q c_7_1/QB bitcell
Xc_12_9 c_9_9/BL c_9_9/BLB c_12_9/WL c_13_9/VDD VSUBS c_12_9/Q c_12_9/QB bitcell
Xc_10_6 c_9_6/BL c_9_6/BLB c_10_9/WL c_11_9/VDD VSUBS c_10_6/Q c_10_6/QB bitcell
Xc_5_14 c_9_14/BL c_9_14/BLB c_5_9/WL c_5_9/VDD VSUBS c_5_14/Q c_5_14/QB bitcell
Xc_0_8 c_9_8/BL c_9_8/BLB c_0_9/WL c_1_9/VDD VSUBS c_0_8/Q c_0_8/QB bitcell
Xc_2_15 c_9_15/BL c_9_15/BLB c_2_9/WL c_3_9/VDD VSUBS c_2_15/Q c_2_15/QB bitcell
Xc_10_10 c_9_10/BL c_9_10/BLB c_10_9/WL c_11_9/VDD VSUBS c_10_10/Q c_10_10/QB bitcell
Xc_9_5 c_9_5/BL c_9_5/BLB c_9_9/WL c_9_9/VDD VSUBS c_9_5/Q c_9_5/QB bitcell
Xc_8_14 c_9_14/BL c_9_14/BLB c_8_9/WL c_9_9/VDD VSUBS c_8_14/Q c_8_14/QB bitcell
Xc_0_9 c_9_9/BL c_9_9/BLB c_0_9/WL c_1_9/VDD VSUBS c_0_9/Q c_0_9/QB bitcell
Xc_7_2 c_9_2/BL c_9_2/BLB c_7_9/WL c_7_9/VDD VSUBS c_7_2/Q c_7_2/QB bitcell
Xc_10_7 c_9_7/BL c_9_7/BLB c_10_9/WL c_11_9/VDD VSUBS c_10_7/Q c_10_7/QB bitcell
Xc_5_15 c_9_15/BL c_9_15/BLB c_5_9/WL c_5_9/VDD VSUBS c_5_15/Q c_5_15/QB bitcell
Xc_13_10 c_9_10/BL c_9_10/BLB c_13_9/WL c_13_9/VDD VSUBS c_13_10/Q c_13_10/QB bitcell
Xc_10_11 c_9_11/BL c_9_11/BLB c_10_9/WL c_11_9/VDD VSUBS c_10_11/Q c_10_11/QB bitcell
Xc_8_15 c_9_15/BL c_9_15/BLB c_8_9/WL c_9_9/VDD VSUBS c_8_15/Q c_8_15/QB bitcell
Xc_9_6 c_9_6/BL c_9_6/BLB c_9_9/WL c_9_9/VDD VSUBS c_9_6/Q c_9_6/QB bitcell
Xc_7_3 c_9_3/BL c_9_3/BLB c_7_9/WL c_7_9/VDD VSUBS c_7_3/Q c_7_3/QB bitcell
Xc_10_8 c_9_8/BL c_9_8/BLB c_10_9/WL c_11_9/VDD VSUBS c_10_8/Q c_10_8/QB bitcell
Xc_5_0 c_9_0/BL c_9_0/BLB c_5_9/WL c_5_9/VDD VSUBS c_5_0/Q c_5_0/QB bitcell
Xc_13_11 c_9_11/BL c_9_11/BLB c_13_9/WL c_13_9/VDD VSUBS c_13_11/Q c_13_11/QB bitcell
Xc_10_12 c_9_12/BL c_9_12/BLB c_10_9/WL c_11_9/VDD VSUBS c_10_12/Q c_10_12/QB bitcell
Xc_9_7 c_9_7/BL c_9_7/BLB c_9_9/WL c_9_9/VDD VSUBS c_9_7/Q c_9_7/QB bitcell
Xc_5_1 c_9_1/BL c_9_1/BLB c_5_9/WL c_5_9/VDD VSUBS c_5_1/Q c_5_1/QB bitcell
Xc_7_4 c_9_4/BL c_9_4/BLB c_7_9/WL c_7_9/VDD VSUBS c_7_4/Q c_7_4/QB bitcell
Xc_10_9 c_9_9/BL c_9_9/BLB c_10_9/WL c_11_9/VDD VSUBS c_10_9/Q c_10_9/QB bitcell
Xc_13_12 c_9_12/BL c_9_12/BLB c_13_9/WL c_13_9/VDD VSUBS c_13_12/Q c_13_12/QB bitcell
Xc_10_13 c_9_13/BL c_9_13/BLB c_10_9/WL c_11_9/VDD VSUBS c_10_13/Q c_10_13/QB bitcell
Xc_9_8 c_9_8/BL c_9_8/BLB c_9_9/WL c_9_9/VDD VSUBS c_9_8/Q c_9_8/QB bitcell
Xc_7_5 c_9_5/BL c_9_5/BLB c_7_9/WL c_7_9/VDD VSUBS c_7_5/Q c_7_5/QB bitcell
Xc_5_2 c_9_2/BL c_9_2/BLB c_5_9/WL c_5_9/VDD VSUBS c_5_2/Q c_5_2/QB bitcell
Xc_15_0 c_9_0/BL c_9_0/BLB c_15_9/WL c_15_9/VDD VSUBS c_15_0/Q c_15_0/QB bitcell
Xc_13_13 c_9_13/BL c_9_13/BLB c_13_9/WL c_13_9/VDD VSUBS c_13_13/Q c_13_13/QB bitcell
Xc_9_9 c_9_9/BL c_9_9/BLB c_9_9/WL c_9_9/VDD VSUBS c_9_9/Q c_9_9/QB bitcell
Xc_10_14 c_9_14/BL c_9_14/BLB c_10_9/WL c_11_9/VDD VSUBS c_10_14/Q c_10_14/QB bitcell
Xc_7_6 c_9_6/BL c_9_6/BLB c_7_9/WL c_7_9/VDD VSUBS c_7_6/Q c_7_6/QB bitcell
Xc_15_1 c_9_1/BL c_9_1/BLB c_15_9/WL c_15_9/VDD VSUBS c_15_1/Q c_15_1/QB bitcell
Xc_3_0 c_9_0/BL c_9_0/BLB c_3_9/WL c_3_9/VDD VSUBS c_3_0/Q c_3_0/QB bitcell
Xc_5_3 c_9_3/BL c_9_3/BLB c_5_9/WL c_5_9/VDD VSUBS c_5_3/Q c_5_3/QB bitcell
Xc_13_14 c_9_14/BL c_9_14/BLB c_13_9/WL c_13_9/VDD VSUBS c_13_14/Q c_13_14/QB bitcell
Xc_10_15 c_9_15/BL c_9_15/BLB c_10_9/WL c_11_9/VDD VSUBS c_10_15/Q c_10_15/QB bitcell
Xc_7_7 c_9_7/BL c_9_7/BLB c_7_9/WL c_7_9/VDD VSUBS c_7_7/Q c_7_7/QB bitcell
Xc_5_4 c_9_4/BL c_9_4/BLB c_5_9/WL c_5_9/VDD VSUBS c_5_4/Q c_5_4/QB bitcell
Xc_15_2 c_9_2/BL c_9_2/BLB c_15_9/WL c_15_9/VDD VSUBS c_15_2/Q c_15_2/QB bitcell
Xc_13_15 c_9_15/BL c_9_15/BLB c_13_9/WL c_13_9/VDD VSUBS c_13_15/Q c_13_15/QB bitcell
Xc_3_1 c_9_1/BL c_9_1/BLB c_3_9/WL c_3_9/VDD VSUBS c_3_1/Q c_3_1/QB bitcell
Xc_7_8 c_9_8/BL c_9_8/BLB c_7_9/WL c_7_9/VDD VSUBS c_7_8/Q c_7_8/QB bitcell
Xc_15_3 c_9_3/BL c_9_3/BLB c_15_9/WL c_15_9/VDD VSUBS c_15_3/Q c_15_3/QB bitcell
Xc_5_5 c_9_5/BL c_9_5/BLB c_5_9/WL c_5_9/VDD VSUBS c_5_5/Q c_5_5/QB bitcell
Xc_0_10 c_9_10/BL c_9_10/BLB c_0_9/WL c_1_9/VDD VSUBS c_0_10/Q c_0_10/QB bitcell
Xc_3_2 c_9_2/BL c_9_2/BLB c_3_9/WL c_3_9/VDD VSUBS c_3_2/Q c_3_2/QB bitcell
Xc_13_0 c_9_0/BL c_9_0/BLB c_13_9/WL c_13_9/VDD VSUBS c_13_0/Q c_13_0/QB bitcell
Xc_3_10 c_9_10/BL c_9_10/BLB c_3_9/WL c_3_9/VDD VSUBS c_3_10/Q c_3_10/QB bitcell
Xc_7_9 c_9_9/BL c_9_9/BLB c_7_9/WL c_7_9/VDD VSUBS c_7_9/Q c_7_9/QB bitcell
Xc_5_6 c_9_6/BL c_9_6/BLB c_5_9/WL c_5_9/VDD VSUBS c_5_6/Q c_5_6/QB bitcell
Xc_0_11 c_9_11/BL c_9_11/BLB c_0_9/WL c_1_9/VDD VSUBS c_0_11/Q c_0_11/QB bitcell
Xc_15_4 c_9_4/BL c_9_4/BLB c_15_9/WL c_15_9/VDD VSUBS c_15_4/Q c_15_4/QB bitcell
Xc_3_3 c_9_3/BL c_9_3/BLB c_3_9/WL c_3_9/VDD VSUBS c_3_3/Q c_3_3/QB bitcell
Xc_13_1 c_9_1/BL c_9_1/BLB c_13_9/WL c_13_9/VDD VSUBS c_13_1/Q c_13_1/QB bitcell
Xc_6_10 c_9_10/BL c_9_10/BLB c_6_9/WL c_7_9/VDD VSUBS c_6_10/Q c_6_10/QB bitcell
Xc_1_0 c_9_0/BL c_9_0/BLB c_1_9/WL c_1_9/VDD VSUBS c_1_0/Q c_1_0/QB bitcell
Xc_3_11 c_9_11/BL c_9_11/BLB c_3_9/WL c_3_9/VDD VSUBS c_3_11/Q c_3_11/QB bitcell
Xc_15_5 c_9_5/BL c_9_5/BLB c_15_9/WL c_15_9/VDD VSUBS c_15_5/Q c_15_5/QB bitcell
Xc_9_10 c_9_10/BL c_9_10/BLB c_9_9/WL c_9_9/VDD VSUBS c_9_10/Q c_9_10/QB bitcell
Xc_5_7 c_9_7/BL c_9_7/BLB c_5_9/WL c_5_9/VDD VSUBS c_5_7/Q c_5_7/QB bitcell
Xc_0_12 c_9_12/BL c_9_12/BLB c_0_9/WL c_1_9/VDD VSUBS c_0_12/Q c_0_12/QB bitcell
Xc_3_4 c_9_4/BL c_9_4/BLB c_3_9/WL c_3_9/VDD VSUBS c_3_4/Q c_3_4/QB bitcell
Xc_13_2 c_9_2/BL c_9_2/BLB c_13_9/WL c_13_9/VDD VSUBS c_13_2/Q c_13_2/QB bitcell
Xc_6_11 c_9_11/BL c_9_11/BLB c_6_9/WL c_7_9/VDD VSUBS c_6_11/Q c_6_11/QB bitcell
Xc_1_1 c_9_1/BL c_9_1/BLB c_1_9/WL c_1_9/VDD VSUBS c_1_1/Q c_1_1/QB bitcell
Xc_3_12 c_9_12/BL c_9_12/BLB c_3_9/WL c_3_9/VDD VSUBS c_3_12/Q c_3_12/QB bitcell
Xc_9_11 c_9_11/BL c_9_11/BLB c_9_9/WL c_9_9/VDD VSUBS c_9_11/Q c_9_11/QB bitcell
Xc_5_8 c_9_8/BL c_9_8/BLB c_5_9/WL c_5_9/VDD VSUBS c_5_8/Q c_5_8/QB bitcell
Xc_0_13 c_9_13/BL c_9_13/BLB c_0_9/WL c_1_9/VDD VSUBS c_0_13/Q c_0_13/QB bitcell
Xc_15_6 c_9_6/BL c_9_6/BLB c_15_9/WL c_15_9/VDD VSUBS c_15_6/Q c_15_6/QB bitcell
Xc_3_5 c_9_5/BL c_9_5/BLB c_3_9/WL c_3_9/VDD VSUBS c_3_5/Q c_3_5/QB bitcell
Xc_13_3 c_9_3/BL c_9_3/BLB c_13_9/WL c_13_9/VDD VSUBS c_13_3/Q c_13_3/QB bitcell
Xc_11_0 c_9_0/BL c_9_0/BLB c_11_9/WL c_11_9/VDD VSUBS c_11_0/Q c_11_0/QB bitcell
Xc_6_12 c_9_12/BL c_9_12/BLB c_6_9/WL c_7_9/VDD VSUBS c_6_12/Q c_6_12/QB bitcell
Xc_1_2 c_9_2/BL c_9_2/BLB c_1_9/WL c_1_9/VDD VSUBS c_1_2/Q c_1_2/QB bitcell
Xc_3_13 c_9_13/BL c_9_13/BLB c_3_9/WL c_3_9/VDD VSUBS c_3_13/Q c_3_13/QB bitcell
Xc_9_12 c_9_12/BL c_9_12/BLB c_9_9/WL c_9_9/VDD VSUBS c_9_12/Q c_9_12/QB bitcell
Xc_5_9 c_9_9/BL c_9_9/BLB c_5_9/WL c_5_9/VDD VSUBS c_5_9/Q c_5_9/QB bitcell
Xc_0_14 c_9_14/BL c_9_14/BLB c_0_9/WL c_1_9/VDD VSUBS c_0_14/Q c_0_14/QB bitcell
Xc_15_7 c_9_7/BL c_9_7/BLB c_15_9/WL c_15_9/VDD VSUBS c_15_7/Q c_15_7/QB bitcell
Xc_13_4 c_9_4/BL c_9_4/BLB c_13_9/WL c_13_9/VDD VSUBS c_13_4/Q c_13_4/QB bitcell
Xc_6_13 c_9_13/BL c_9_13/BLB c_6_9/WL c_7_9/VDD VSUBS c_6_13/Q c_6_13/QB bitcell
Xc_1_3 c_9_3/BL c_9_3/BLB c_1_9/WL c_1_9/VDD VSUBS c_1_3/Q c_1_3/QB bitcell
Xc_3_6 c_9_6/BL c_9_6/BLB c_3_9/WL c_3_9/VDD VSUBS c_3_6/Q c_3_6/QB bitcell
.ends
