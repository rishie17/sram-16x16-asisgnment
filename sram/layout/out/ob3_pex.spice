* NGSPICE file created from ob3.ext - technology: sky130A

.subckt ob3 A Y VDD GND
X0 Y A GND GND sky130_fd_pr__nfet_01v8 ad=2.9568 pd=14.32 as=2.9568 ps=14.32 w=6.72 l=0.15
X1 Y A VDD VDD sky130_fd_pr__pfet_01v8 ad=5.9136 pd=27.76 as=5.9136 ps=27.76 w=13.44 l=0.15
C0 VDD A 0.21413f
C1 Y A 0.27313f
C2 VDD Y 1.12065f
C3 Y GND 2.30155f
C4 VDD GND 3.42509f
.ends
