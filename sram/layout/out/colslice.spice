* NGSPICE file created from colslice.ext - technology: sky130A

.subckt nand2 A B Y VDD GND w_0_397# VSUBS
X0 GND B a_162_47# VSUBS sky130_fd_pr__nfet_01v8 ad=0.3696 pd=2.56 as=0.231 ps=1.39 w=0.84 l=0.15
X1 Y B VDD w_0_397# sky130_fd_pr__pfet_01v8 ad=0.3696 pd=2.56 as=0.231 ps=1.39 w=0.84 l=0.15
X2 VDD A Y w_0_397# sky130_fd_pr__pfet_01v8 ad=0.231 pd=1.39 as=0.3696 ps=2.56 w=0.84 l=0.15
X3 a_162_47# A Y VSUBS sky130_fd_pr__nfet_01v8 ad=0.231 pd=1.39 as=0.3696 ps=2.56 w=0.84 l=0.15
.ends

.subckt csdrv A Y VDD GND w_0_397# VSUBS
X0 GND A Y VSUBS sky130_fd_pr__nfet_01v8 ad=0.231 pd=1.94 as=0.1617 ps=1.19 w=0.42 l=0.15
X1 Y A GND VSUBS sky130_fd_pr__nfet_01v8 ad=0.1617 pd=1.19 as=0.231 ps=1.94 w=0.42 l=0.15
X2 VDD A Y w_0_397# sky130_fd_pr__pfet_01v8 ad=0.462 pd=2.78 as=0.3234 ps=1.61 w=0.84 l=0.15
X3 Y A VDD w_0_397# sky130_fd_pr__pfet_01v8 ad=0.3234 pd=1.61 as=0.462 ps=2.78 w=0.84 l=0.15
.ends

.subckt colslice A B CSEL VDD GND
Xn A B n/Y VDD GND w_0_390# VSUBS nand2
Xd n/Y CSEL VDD d/GND w_0_390# VSUBS csdrv
.ends
