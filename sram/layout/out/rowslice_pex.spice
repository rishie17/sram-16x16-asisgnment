* NGSPICE file created from rowslice.ext - technology: sky130A

.subckt nand3 A B C Y VDD GND a_162_47# w_0_397# a_302_47# VSUBS
X0 a_302_47# B a_162_47# VSUBS sky130_fd_pr__nfet_01v8 ad=0.3465 pd=1.81 as=0.3465 ps=1.81 w=1.26 l=0.15
X1 VDD C Y w_0_397# sky130_fd_pr__pfet_01v8 ad=0.3696 pd=2.56 as=0.231 ps=1.39 w=0.84 l=0.15
X2 Y B VDD w_0_397# sky130_fd_pr__pfet_01v8 ad=0.231 pd=1.39 as=0.231 ps=1.39 w=0.84 l=0.15
X3 VDD A Y w_0_397# sky130_fd_pr__pfet_01v8 ad=0.231 pd=1.39 as=0.3696 ps=2.56 w=0.84 l=0.15
X4 GND C a_302_47# VSUBS sky130_fd_pr__nfet_01v8 ad=0.5544 pd=3.4 as=0.3465 ps=1.81 w=1.26 l=0.15
X5 a_162_47# A Y VSUBS sky130_fd_pr__nfet_01v8 ad=0.3465 pd=1.81 as=0.5544 ps=3.4 w=1.26 l=0.15
C0 C GND 0.01221f
C1 C B 0.02319f
C2 A w_0_397# 0.0369f
C3 GND a_162_47# 0.01252f
C4 a_162_47# B 0
C5 Y A 0.04495f
C6 GND a_302_47# 0.0149f
C7 a_302_47# B 0
C8 Y w_0_397# 0.02347f
C9 A VDD 0.00885f
C10 VDD w_0_397# 0.06869f
C11 Y VDD 0.1587f
C12 a_162_47# A 0
C13 C w_0_397# 0.0369f
C14 GND B 0.00842f
C15 C Y 0.00565f
C16 Y a_162_47# 0.02045f
C17 C VDD 0.01435f
C18 a_162_47# VDD 0.00174f
C19 Y a_302_47# 0.01336f
C20 a_302_47# VDD 0
C21 GND A 0.00781f
C22 A B 0.02319f
C23 GND w_0_397# 0.00518f
C24 B w_0_397# 0.03593f
C25 C a_302_47# 0
C26 GND Y 0.03698f
C27 Y B 0.01759f
C28 GND VDD 0.01702f
C29 VDD B 0.00947f
C30 GND VSUBS 0.23601f
C31 VDD VSUBS 0.31826f
C32 Y VSUBS 0.28163f
C33 a_302_47# VSUBS 0.04262f
C34 a_162_47# VSUBS 0.04262f
C35 w_0_397# VSUBS 0.53899f
.ends

.subckt wldrv A Y VDD GND w_0_397# VSUBS
X0 GND A Y VSUBS sky130_fd_pr__nfet_01v8 ad=0.1848 pd=1.72 as=0.1155 ps=0.97 w=0.42 l=0.15
X1 VDD A Y w_0_397# sky130_fd_pr__pfet_01v8 ad=0.3696 pd=2.56 as=0.231 ps=1.39 w=0.84 l=0.15
X2 Y A VDD w_0_397# sky130_fd_pr__pfet_01v8 ad=0.231 pd=1.39 as=0.3696 ps=2.56 w=0.84 l=0.15
X3 Y A GND VSUBS sky130_fd_pr__nfet_01v8 ad=0.1155 pd=0.97 as=0.1848 ps=1.72 w=0.42 l=0.15
C0 VDD A 0.02761f
C1 Y w_0_397# 0.01491f
C2 w_0_397# GND 0.00487f
C3 Y GND 0.0384f
C4 VDD w_0_397# 0.05909f
C5 VDD Y 0.05869f
C6 VDD GND 0.02086f
C7 w_0_397# A 0.06983f
C8 Y A 0.0755f
C9 GND A 0.02569f
C10 GND VSUBS 0.45666f
C11 Y VSUBS 0.35858f
C12 VDD VSUBS 0.20319f
C13 w_0_397# VSUBS 0.40753f
.ends

.subckt rowslice A B C WL VDD GND
Xn3 A B C wd/A VDD GND n3/a_162_47# VDD n3/a_302_47# GND nand3
Xwd wd/A WL VDD GND VDD GND wldrv
C0 VDD A 0.00264f
C1 wd/A C 0.03002f
C2 WL C 0.00383f
C3 wd/A n3/a_162_47# 0.00239f
C4 wd/A n3/a_302_47# 0.00778f
C5 wd/A WL 0.01639f
C6 n3/a_162_47# WL 0
C7 VDD C 0.00228f
C8 n3/a_302_47# WL 0.00166f
C9 VDD wd/A 0.07387f
C10 wd/A B 0.01097f
C11 VDD n3/a_302_47# -0
C12 VDD WL 0.00661f
C13 B WL 0
C14 A wd/A 0.00356f
C15 A WL 0
C16 WL GND -0.03926f
C17 wd/A GND 0.07188f
C18 C GND -0.02255f
C19 B GND 0
C20 A GND -0.00172f
C21 n3/a_302_47# GND -0
C22 VDD GND -0.24458f
.ends
