* NGSPICE file created from nand2.ext - technology: sky130A

.subckt nand2 A B Y VDD GND
X0 GND B a_162_47# VSUBS sky130_fd_pr__nfet_01v8 ad=0.3696 pd=2.56 as=0.231 ps=1.39 w=0.84 l=0.15
X1 Y B VDD w_0_397# sky130_fd_pr__pfet_01v8 ad=0.3696 pd=2.56 as=0.231 ps=1.39 w=0.84 l=0.15
X2 VDD A Y w_0_397# sky130_fd_pr__pfet_01v8 ad=0.231 pd=1.39 as=0.3696 ps=2.56 w=0.84 l=0.15
X3 a_162_47# A Y VSUBS sky130_fd_pr__nfet_01v8 ad=0.231 pd=1.39 as=0.3696 ps=2.56 w=0.84 l=0.15
C0 GND Y 0.04167f
C1 A VDD 0.00869f
C2 w_0_397# A 0.03444f
C3 GND VDD 0.00433f
C4 A a_162_47# 0
C5 w_0_397# GND 0.00442f
C6 VDD Y 0.14001f
C7 a_162_47# GND 0.01215f
C8 w_0_397# Y 0.02334f
C9 a_162_47# Y 0.01292f
C10 w_0_397# VDD 0.04634f
C11 a_162_47# VDD 0
C12 A B 0.0293f
C13 GND B 0.01195f
C14 Y B 0.01673f
C15 VDD B 0.00869f
C16 w_0_397# B 0.03444f
C17 a_162_47# B 0
C18 A GND 0.00866f
C19 A Y 0.0457f
C20 GND VSUBS 0.28843f
C21 VDD VSUBS 0.22995f
C22 Y VSUBS 0.281f
C23 a_162_47# VSUBS 0.08257f
C24 w_0_397# VSUBS 0.40753f
.ends
