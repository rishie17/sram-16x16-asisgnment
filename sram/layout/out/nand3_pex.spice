* NGSPICE file created from nand3.ext - technology: sky130A

.subckt nand3 A B C Y VDD GND
X0 a_302_47# B a_162_47# VSUBS sky130_fd_pr__nfet_01v8 ad=0.3465 pd=1.81 as=0.3465 ps=1.81 w=1.26 l=0.15
X1 VDD C Y w_0_397# sky130_fd_pr__pfet_01v8 ad=0.3696 pd=2.56 as=0.231 ps=1.39 w=0.84 l=0.15
X2 Y B VDD w_0_397# sky130_fd_pr__pfet_01v8 ad=0.231 pd=1.39 as=0.231 ps=1.39 w=0.84 l=0.15
X3 VDD A Y w_0_397# sky130_fd_pr__pfet_01v8 ad=0.231 pd=1.39 as=0.3696 ps=2.56 w=0.84 l=0.15
X4 GND C a_302_47# VSUBS sky130_fd_pr__nfet_01v8 ad=0.5544 pd=3.4 as=0.3465 ps=1.81 w=1.26 l=0.15
X5 a_162_47# A Y VSUBS sky130_fd_pr__nfet_01v8 ad=0.3465 pd=1.81 as=0.5544 ps=3.4 w=1.26 l=0.15
C0 GND B 0.00842f
C1 Y a_162_47# 0.02045f
C2 A B 0.02319f
C3 VDD C 0.01435f
C4 Y B 0.01759f
C5 GND VDD 0.01702f
C6 VDD A 0.00885f
C7 GND C 0.01221f
C8 VDD Y 0.1587f
C9 GND A 0.00781f
C10 Y C 0.00565f
C11 GND Y 0.03698f
C12 Y A 0.04495f
C13 w_0_397# B 0.03593f
C14 VDD w_0_397# 0.06869f
C15 w_0_397# C 0.0369f
C16 GND w_0_397# 0.00518f
C17 w_0_397# A 0.0369f
C18 w_0_397# Y 0.02347f
C19 a_302_47# B 0
C20 VDD a_302_47# 0
C21 a_302_47# C 0
C22 a_162_47# B 0
C23 GND a_302_47# 0.0149f
C24 a_302_47# Y 0.01336f
C25 VDD a_162_47# 0.00174f
C26 VDD B 0.00947f
C27 GND a_162_47# 0.01252f
C28 a_162_47# A 0
C29 C B 0.02319f
C30 GND VSUBS 0.23601f
C31 VDD VSUBS 0.31826f
C32 Y VSUBS 0.28163f
C33 a_302_47# VSUBS 0.04262f
C34 a_162_47# VSUBS 0.04262f
C35 w_0_397# VSUBS 0.53899f
.ends
