* NGSPICE file created from colslice.ext - technology: sky130A

.subckt nand2 A B Y VDD GND w_0_397# VSUBS
X0 GND B a_162_47# VSUBS sky130_fd_pr__nfet_01v8 ad=0.3696 pd=2.56 as=0.231 ps=1.39 w=0.84 l=0.15
X1 Y B VDD w_0_397# sky130_fd_pr__pfet_01v8 ad=0.3696 pd=2.56 as=0.231 ps=1.39 w=0.84 l=0.15
X2 VDD A Y w_0_397# sky130_fd_pr__pfet_01v8 ad=0.231 pd=1.39 as=0.3696 ps=2.56 w=0.84 l=0.15
X3 a_162_47# A Y VSUBS sky130_fd_pr__nfet_01v8 ad=0.231 pd=1.39 as=0.3696 ps=2.56 w=0.84 l=0.15
C0 A a_162_47# 0
C1 A Y 0.0457f
C2 w_0_397# Y 0.02334f
C3 A GND 0.00866f
C4 GND w_0_397# 0.00442f
C5 VDD a_162_47# 0
C6 B a_162_47# 0
C7 VDD Y 0.14001f
C8 B Y 0.01673f
C9 VDD GND 0.00433f
C10 A w_0_397# 0.03444f
C11 GND B 0.01195f
C12 A VDD 0.00869f
C13 A B 0.0293f
C14 VDD w_0_397# 0.04634f
C15 B w_0_397# 0.03444f
C16 Y a_162_47# 0.01292f
C17 VDD B 0.00869f
C18 GND a_162_47# 0.01215f
C19 GND Y 0.04167f
C20 GND VSUBS 0.28843f
C21 VDD VSUBS 0.22995f
C22 Y VSUBS 0.281f
C23 a_162_47# VSUBS 0.08257f
C24 w_0_397# VSUBS 0.40753f
.ends

.subckt csdrv A Y VDD GND w_0_397# VSUBS
X0 GND A Y VSUBS sky130_fd_pr__nfet_01v8 ad=0.231 pd=1.94 as=0.1617 ps=1.19 w=0.42 l=0.15
X1 Y A GND VSUBS sky130_fd_pr__nfet_01v8 ad=0.1617 pd=1.19 as=0.231 ps=1.94 w=0.42 l=0.15
X2 VDD A Y w_0_397# sky130_fd_pr__pfet_01v8 ad=0.462 pd=2.78 as=0.3234 ps=1.61 w=0.84 l=0.15
X3 Y A VDD w_0_397# sky130_fd_pr__pfet_01v8 ad=0.3234 pd=1.61 as=0.462 ps=2.78 w=0.84 l=0.15
C0 A w_0_397# 0.07896f
C1 A Y 0.066f
C2 GND w_0_397# 0.00551f
C3 VDD w_0_397# 0.06891f
C4 GND Y 0.04022f
C5 VDD Y 0.0613f
C6 A GND 0.02505f
C7 A VDD 0.02613f
C8 Y w_0_397# 0.01664f
C9 GND VDD 0.02533f
C10 GND VSUBS 0.50572f
C11 Y VSUBS 0.37296f
C12 VDD VSUBS 0.22445f
C13 w_0_397# VSUBS 0.49016f
.ends

.subckt colslice A B CSEL VDD GND
Xn A B n/Y VDD GND w_0_390# VSUBS nand2
Xd n/Y CSEL VDD d/GND w_0_390# VSUBS csdrv
C0 VDD GND 0.00396f
C1 A d/GND 0
C2 n/Y d/GND 0.00464f
C3 A GND 0
C4 w_0_390# B 0.00734f
C5 n/Y GND 0.00636f
C6 CSEL w_0_390# 0.00858f
C7 n/Y B 0
C8 d/GND B 0
C9 CSEL VDD -0
C10 w_0_390# VDD 0.00972f
C11 w_0_390# A 0.00949f
C12 CSEL n/Y 0.03376f
C13 w_0_390# n/Y 0.07232f
C14 CSEL d/GND -0
C15 A VDD 0
C16 w_0_390# d/GND 0.00533f
C17 n/Y VDD 0.1196f
C18 CSEL GND 0
C19 w_0_390# GND 0.00622f
C20 A n/Y 0.00278f
C21 VDD d/GND 0.00338f
C22 d/GND VSUBS 0.05342f
C23 CSEL VSUBS -0.00896f
C24 VDD VSUBS -0.23752f
C25 n/Y VSUBS 0.16964f
C26 w_0_390# VSUBS 0.1559f
C27 GND VSUBS 0.08468f
C28 B VSUBS -0.00734f
C29 A VSUBS -0.01321f
.ends
