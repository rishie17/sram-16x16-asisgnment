* NGSPICE file created from c1p.ext - technology: sky130A

.subckt c1p A B Y VDD GND Y_uq0
X0 VDD A Y w_0_229# sky130_fd_pr__pfet_01v8 ad=0.6468 pd=2.45 as=0.924 ps=4.46 w=1.68 l=0.15
X1 Y_uq0 B VDD w_0_229# sky130_fd_pr__pfet_01v8 ad=0.924 pd=4.46 as=0.6468 ps=2.45 w=1.68 l=0.15
C0 VDD Y 0.02984f
C1 Y_uq0 w_0_229# 0.00559f
C2 GND B 0.00534f
C3 A VDD 0.01497f
C4 Y_uq0 VDD 0.02984f
C5 GND w_0_229# 0.00971f
C6 B w_0_229# 0.04083f
C7 GND Y 0.00648f
C8 GND A 0.00534f
C9 GND VDD 0.02718f
C10 A B 0.01263f
C11 B VDD 0.01497f
C12 GND Y_uq0 0.00648f
C13 B Y_uq0 0.00245f
C14 w_0_229# Y 0.00559f
C15 A w_0_229# 0.04083f
C16 w_0_229# VDD 0.06194f
C17 A Y 0.00245f
C18 GND VSUBS 0.1883f
C19 Y_uq0 VSUBS 0.06481f
C20 VDD VSUBS 0.28285f
C21 Y VSUBS 0.06481f
C22 w_0_229# VSUBS 0.75325f
.ends
