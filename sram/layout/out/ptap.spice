* NGSPICE file created from ptap.ext - technology: sky130A

.subckt ptap VDD GND
.ends
