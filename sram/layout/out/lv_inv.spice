* NGSPICE file created from lv_inv.ext - technology: sky130A

.subckt inv A Y VDD GND w_0_397# VSUBS
X0 Y A VDD w_0_397# sky130_fd_pr__pfet_01v8 ad=0.3696 pd=2.56 as=0.3696 ps=2.56 w=0.84 l=0.15
X1 Y A GND VSUBS sky130_fd_pr__nfet_01v8 ad=0.1848 pd=1.72 as=0.1848 ps=1.72 w=0.42 l=0.15
.ends

.subckt lv_inv A Y VDD GND
Xu A Y VDD GND VDD GND inv
.ends
