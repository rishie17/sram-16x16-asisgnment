* NGSPICE file created from ob6.ext - technology: sky130A

.subckt ob6 A Y VDD GND
X0 Y A GND GND sky130_fd_pr__nfet_01v8 ad=2.75 pd=10.55 as=2.75 ps=10.55 w=10 l=0.15
X1 Y A VDD VDD sky130_fd_pr__pfet_01v8 ad=2.75 pd=10.55 as=2.75 ps=10.55 w=10 l=0.15
X2 Y A VDD VDD sky130_fd_pr__pfet_01v8 ad=2.75 pd=10.55 as=2.75 ps=10.55 w=10 l=0.15
X3 VDD A Y VDD sky130_fd_pr__pfet_01v8 ad=2.75 pd=10.55 as=2.75 ps=10.55 w=10 l=0.15
X4 Y A GND GND sky130_fd_pr__nfet_01v8 ad=2.75 pd=10.55 as=2.75 ps=10.55 w=10 l=0.15
X5 Y A VDD VDD sky130_fd_pr__pfet_01v8 ad=2.75 pd=10.55 as=2.75 ps=10.55 w=10 l=0.15
X6 Y A GND GND sky130_fd_pr__nfet_01v8 ad=2.75 pd=10.55 as=2.75 ps=10.55 w=10 l=0.15
X7 VDD A Y VDD sky130_fd_pr__pfet_01v8 ad=2.75 pd=10.55 as=2.75 ps=10.55 w=10 l=0.15
X8 Y A GND GND sky130_fd_pr__nfet_01v8 ad=2.75 pd=10.55 as=2.75 ps=10.55 w=10 l=0.15
X9 Y A VDD VDD sky130_fd_pr__pfet_01v8 ad=2.75 pd=10.55 as=2.75 ps=10.55 w=10 l=0.15
X10 VDD A Y VDD sky130_fd_pr__pfet_01v8 ad=2.75 pd=10.55 as=2.75 ps=10.55 w=10 l=0.15
X11 GND A Y GND sky130_fd_pr__nfet_01v8 ad=2.75 pd=10.55 as=2.75 ps=10.55 w=10 l=0.15
X12 VDD A Y VDD sky130_fd_pr__pfet_01v8 ad=2.75 pd=10.55 as=2.75 ps=10.55 w=10 l=0.15
X13 Y A GND GND sky130_fd_pr__nfet_01v8 ad=2.75 pd=10.55 as=2.75 ps=10.55 w=10 l=0.15
X14 VDD A Y VDD sky130_fd_pr__pfet_01v8 ad=2.75 pd=10.55 as=2.75 ps=10.55 w=10 l=0.15
X15 GND A Y GND sky130_fd_pr__nfet_01v8 ad=2.75 pd=10.55 as=2.75 ps=10.55 w=10 l=0.15
X16 VDD A Y VDD sky130_fd_pr__pfet_01v8 ad=2.75 pd=10.55 as=2.75 ps=10.55 w=10 l=0.15
X17 Y A GND GND sky130_fd_pr__nfet_01v8 ad=2.75 pd=10.55 as=2.75 ps=10.55 w=10 l=0.15
X18 VDD A Y VDD sky130_fd_pr__pfet_01v8 ad=2.75 pd=10.55 as=2.75 ps=10.55 w=10 l=0.15
X19 GND A Y GND sky130_fd_pr__nfet_01v8 ad=2.75 pd=10.55 as=2.75 ps=10.55 w=10 l=0.15
X20 VDD A Y VDD sky130_fd_pr__pfet_01v8 ad=2.75 pd=10.55 as=2.75 ps=10.55 w=10 l=0.15
X21 VDD A Y VDD sky130_fd_pr__pfet_01v8 ad=2.75 pd=10.55 as=2.75 ps=10.55 w=10 l=0.15
X22 VDD A Y VDD sky130_fd_pr__pfet_01v8 ad=2.75 pd=10.55 as=2.75 ps=10.55 w=10 l=0.15
X23 GND A Y GND sky130_fd_pr__nfet_01v8 ad=2.75 pd=10.55 as=2.75 ps=10.55 w=10 l=0.15
X24 Y A VDD VDD sky130_fd_pr__pfet_01v8 ad=2.75 pd=10.55 as=2.75 ps=10.55 w=10 l=0.15
X25 VDD A Y VDD sky130_fd_pr__pfet_01v8 ad=2.75 pd=10.55 as=2.75 ps=10.55 w=10 l=0.15
X26 Y A GND GND sky130_fd_pr__nfet_01v8 ad=2.75 pd=10.55 as=2.75 ps=10.55 w=10 l=0.15
X27 VDD A Y VDD sky130_fd_pr__pfet_01v8 ad=2.75 pd=10.55 as=2.75 ps=10.55 w=10 l=0.15
X28 VDD A Y VDD sky130_fd_pr__pfet_01v8 ad=2.75 pd=10.55 as=2.75 ps=10.55 w=10 l=0.15
X29 VDD A Y VDD sky130_fd_pr__pfet_01v8 ad=2.75 pd=10.55 as=2.75 ps=10.55 w=10 l=0.15
X30 VDD A Y VDD sky130_fd_pr__pfet_01v8 ad=2.75 pd=10.55 as=2.75 ps=10.55 w=10 l=0.15
X31 GND A Y GND sky130_fd_pr__nfet_01v8 ad=2.75 pd=10.55 as=2.75 ps=10.55 w=10 l=0.15
X32 Y A GND GND sky130_fd_pr__nfet_01v8 ad=2.75 pd=10.55 as=4.4 ps=20.88 w=10 l=0.15
X33 VDD A Y VDD sky130_fd_pr__pfet_01v8 ad=2.75 pd=10.55 as=2.75 ps=10.55 w=10 l=0.15
X34 VDD A Y VDD sky130_fd_pr__pfet_01v8 ad=2.75 pd=10.55 as=2.75 ps=10.55 w=10 l=0.15
X35 GND A Y GND sky130_fd_pr__nfet_01v8 ad=2.75 pd=10.55 as=2.75 ps=10.55 w=10 l=0.15
X36 VDD A Y VDD sky130_fd_pr__pfet_01v8 ad=2.75 pd=10.55 as=2.75 ps=10.55 w=10 l=0.15
X37 VDD A Y VDD sky130_fd_pr__pfet_01v8 ad=2.75 pd=10.55 as=2.75 ps=10.55 w=10 l=0.15
X38 GND A Y GND sky130_fd_pr__nfet_01v8 ad=2.75 pd=10.55 as=2.75 ps=10.55 w=10 l=0.15
X39 VDD A Y VDD sky130_fd_pr__pfet_01v8 ad=2.75 pd=10.55 as=2.75 ps=10.55 w=10 l=0.15
X40 VDD A Y VDD sky130_fd_pr__pfet_01v8 ad=2.75 pd=10.55 as=2.75 ps=10.55 w=10 l=0.15
X41 VDD A Y VDD sky130_fd_pr__pfet_01v8 ad=2.75 pd=10.55 as=2.75 ps=10.55 w=10 l=0.15
X42 Y A GND GND sky130_fd_pr__nfet_01v8 ad=2.75 pd=10.55 as=2.75 ps=10.55 w=10 l=0.15
X43 VDD A Y VDD sky130_fd_pr__pfet_01v8 ad=2.75 pd=10.55 as=2.75 ps=10.55 w=10 l=0.15
X44 GND A Y GND sky130_fd_pr__nfet_01v8 ad=2.75 pd=10.55 as=2.75 ps=10.55 w=10 l=0.15
X45 VDD A Y VDD sky130_fd_pr__pfet_01v8 ad=2.75 pd=10.55 as=2.75 ps=10.55 w=10 l=0.15
X46 VDD A Y VDD sky130_fd_pr__pfet_01v8 ad=2.75 pd=10.55 as=2.75 ps=10.55 w=10 l=0.15
X47 VDD A Y VDD sky130_fd_pr__pfet_01v8 ad=2.75 pd=10.55 as=2.75 ps=10.55 w=10 l=0.15
X48 Y A VDD VDD sky130_fd_pr__pfet_01v8 ad=2.75 pd=10.55 as=2.75 ps=10.55 w=10 l=0.15
X49 VDD A Y VDD sky130_fd_pr__pfet_01v8 ad=2.75 pd=10.55 as=2.75 ps=10.55 w=10 l=0.15
X50 VDD A Y VDD sky130_fd_pr__pfet_01v8 ad=2.75 pd=10.55 as=2.75 ps=10.55 w=10 l=0.15
X51 Y A GND GND sky130_fd_pr__nfet_01v8 ad=2.75 pd=10.55 as=2.75 ps=10.55 w=10 l=0.15
X52 VDD A Y VDD sky130_fd_pr__pfet_01v8 ad=2.75 pd=10.55 as=2.75 ps=10.55 w=10 l=0.15
X53 GND A Y GND sky130_fd_pr__nfet_01v8 ad=2.75 pd=10.55 as=2.75 ps=10.55 w=10 l=0.15
X54 Y A GND GND sky130_fd_pr__nfet_01v8 ad=2.75 pd=10.55 as=2.75 ps=10.55 w=10 l=0.15
X55 VDD A Y VDD sky130_fd_pr__pfet_01v8 ad=2.75 pd=10.55 as=2.75 ps=10.55 w=10 l=0.15
X56 VDD A Y VDD sky130_fd_pr__pfet_01v8 ad=2.75 pd=10.55 as=2.75 ps=10.55 w=10 l=0.15
X57 GND A Y GND sky130_fd_pr__nfet_01v8 ad=2.75 pd=10.55 as=2.75 ps=10.55 w=10 l=0.15
X58 Y A VDD VDD sky130_fd_pr__pfet_01v8 ad=2.75 pd=10.55 as=2.75 ps=10.55 w=10 l=0.15
X59 VDD A Y VDD sky130_fd_pr__pfet_01v8 ad=2.75 pd=10.55 as=2.75 ps=10.55 w=10 l=0.15
X60 VDD A Y VDD sky130_fd_pr__pfet_01v8 ad=2.75 pd=10.55 as=2.75 ps=10.55 w=10 l=0.15
X61 Y A GND GND sky130_fd_pr__nfet_01v8 ad=2.75 pd=10.55 as=2.75 ps=10.55 w=10 l=0.15
X62 VDD A Y VDD sky130_fd_pr__pfet_01v8 ad=2.75 pd=10.55 as=2.75 ps=10.55 w=10 l=0.15
X63 VDD A Y VDD sky130_fd_pr__pfet_01v8 ad=2.75 pd=10.55 as=2.75 ps=10.55 w=10 l=0.15
X64 VDD A Y VDD sky130_fd_pr__pfet_01v8 ad=2.75 pd=10.55 as=2.75 ps=10.55 w=10 l=0.15
X65 Y A VDD VDD sky130_fd_pr__pfet_01v8 ad=2.75 pd=10.55 as=2.75 ps=10.55 w=10 l=0.15
X66 VDD A Y VDD sky130_fd_pr__pfet_01v8 ad=2.75 pd=10.55 as=2.75 ps=10.55 w=10 l=0.15
X67 VDD A Y VDD sky130_fd_pr__pfet_01v8 ad=2.75 pd=10.55 as=2.75 ps=10.55 w=10 l=0.15
X68 Y A GND GND sky130_fd_pr__nfet_01v8 ad=2.75 pd=10.55 as=2.75 ps=10.55 w=10 l=0.15
X69 VDD A Y VDD sky130_fd_pr__pfet_01v8 ad=4.4 pd=20.88 as=2.75 ps=10.55 w=10 l=0.15
X70 GND A Y GND sky130_fd_pr__nfet_01v8 ad=2.75 pd=10.55 as=2.75 ps=10.55 w=10 l=0.15
X71 VDD A Y VDD sky130_fd_pr__pfet_01v8 ad=2.75 pd=10.55 as=2.75 ps=10.55 w=10 l=0.15
X72 Y A GND GND sky130_fd_pr__nfet_01v8 ad=2.75 pd=10.55 as=2.75 ps=10.55 w=10 l=0.15
X73 Y A VDD VDD sky130_fd_pr__pfet_01v8 ad=2.75 pd=10.55 as=2.75 ps=10.55 w=10 l=0.15
X74 VDD A Y VDD sky130_fd_pr__pfet_01v8 ad=2.75 pd=10.55 as=2.75 ps=10.55 w=10 l=0.15
X75 Y A VDD VDD sky130_fd_pr__pfet_01v8 ad=2.75 pd=10.55 as=2.75 ps=10.55 w=10 l=0.15
X76 Y A GND GND sky130_fd_pr__nfet_01v8 ad=2.75 pd=10.55 as=2.75 ps=10.55 w=10 l=0.15
X77 GND A Y GND sky130_fd_pr__nfet_01v8 ad=2.75 pd=10.55 as=2.75 ps=10.55 w=10 l=0.15
X78 Y A VDD VDD sky130_fd_pr__pfet_01v8 ad=2.75 pd=10.55 as=2.75 ps=10.55 w=10 l=0.15
X79 Y A VDD VDD sky130_fd_pr__pfet_01v8 ad=2.75 pd=10.55 as=2.75 ps=10.55 w=10 l=0.15
X80 Y A VDD VDD sky130_fd_pr__pfet_01v8 ad=2.75 pd=10.55 as=2.75 ps=10.55 w=10 l=0.15
X81 Y A VDD VDD sky130_fd_pr__pfet_01v8 ad=2.75 pd=10.55 as=2.75 ps=10.55 w=10 l=0.15
X82 GND A Y GND sky130_fd_pr__nfet_01v8 ad=2.75 pd=10.55 as=2.75 ps=10.55 w=10 l=0.15
X83 GND A Y GND sky130_fd_pr__nfet_01v8 ad=2.75 pd=10.55 as=2.75 ps=10.55 w=10 l=0.15
X84 Y A GND GND sky130_fd_pr__nfet_01v8 ad=2.75 pd=10.55 as=2.75 ps=10.55 w=10 l=0.15
X85 Y A VDD VDD sky130_fd_pr__pfet_01v8 ad=2.75 pd=10.55 as=2.75 ps=10.55 w=10 l=0.15
X86 Y A VDD VDD sky130_fd_pr__pfet_01v8 ad=2.75 pd=10.55 as=2.75 ps=10.55 w=10 l=0.15
X87 Y A VDD VDD sky130_fd_pr__pfet_01v8 ad=2.75 pd=10.55 as=2.75 ps=10.55 w=10 l=0.15
X88 Y A VDD VDD sky130_fd_pr__pfet_01v8 ad=2.75 pd=10.55 as=2.75 ps=10.55 w=10 l=0.15
X89 GND A Y GND sky130_fd_pr__nfet_01v8 ad=2.75 pd=10.55 as=2.75 ps=10.55 w=10 l=0.15
X90 Y A VDD VDD sky130_fd_pr__pfet_01v8 ad=2.75 pd=10.55 as=2.75 ps=10.55 w=10 l=0.15
X91 Y A GND GND sky130_fd_pr__nfet_01v8 ad=2.75 pd=10.55 as=2.75 ps=10.55 w=10 l=0.15
X92 GND A Y GND sky130_fd_pr__nfet_01v8 ad=2.75 pd=10.55 as=2.75 ps=10.55 w=10 l=0.15
X93 Y A VDD VDD sky130_fd_pr__pfet_01v8 ad=2.75 pd=10.55 as=2.75 ps=10.55 w=10 l=0.15
X94 Y A VDD VDD sky130_fd_pr__pfet_01v8 ad=2.75 pd=10.55 as=2.75 ps=10.55 w=10 l=0.15
X95 Y A VDD VDD sky130_fd_pr__pfet_01v8 ad=2.75 pd=10.55 as=2.75 ps=10.55 w=10 l=0.15
X96 Y A VDD VDD sky130_fd_pr__pfet_01v8 ad=2.75 pd=10.55 as=2.75 ps=10.55 w=10 l=0.15
X97 GND A Y GND sky130_fd_pr__nfet_01v8 ad=2.75 pd=10.55 as=2.75 ps=10.55 w=10 l=0.15
X98 Y A VDD VDD sky130_fd_pr__pfet_01v8 ad=2.75 pd=10.55 as=2.75 ps=10.55 w=10 l=0.15
X99 Y A VDD VDD sky130_fd_pr__pfet_01v8 ad=2.75 pd=10.55 as=2.75 ps=10.55 w=10 l=0.15
X100 Y A VDD VDD sky130_fd_pr__pfet_01v8 ad=2.75 pd=10.55 as=2.75 ps=10.55 w=10 l=0.15
X101 Y A VDD VDD sky130_fd_pr__pfet_01v8 ad=2.75 pd=10.55 as=2.75 ps=10.55 w=10 l=0.15
X102 GND A Y GND sky130_fd_pr__nfet_01v8 ad=2.75 pd=10.55 as=2.75 ps=10.55 w=10 l=0.15
X103 Y A VDD VDD sky130_fd_pr__pfet_01v8 ad=2.75 pd=10.55 as=2.75 ps=10.55 w=10 l=0.15
X104 Y A GND GND sky130_fd_pr__nfet_01v8 ad=2.75 pd=10.55 as=2.75 ps=10.55 w=10 l=0.15
X105 Y A VDD VDD sky130_fd_pr__pfet_01v8 ad=2.75 pd=10.55 as=2.75 ps=10.55 w=10 l=0.15
X106 Y A VDD VDD sky130_fd_pr__pfet_01v8 ad=2.75 pd=10.55 as=2.75 ps=10.55 w=10 l=0.15
X107 Y A VDD VDD sky130_fd_pr__pfet_01v8 ad=2.75 pd=10.55 as=2.75 ps=10.55 w=10 l=0.15
X108 GND A Y GND sky130_fd_pr__nfet_01v8 ad=2.75 pd=10.55 as=2.75 ps=10.55 w=10 l=0.15
X109 Y A GND GND sky130_fd_pr__nfet_01v8 ad=2.75 pd=10.55 as=2.75 ps=10.55 w=10 l=0.15
X110 Y A GND GND sky130_fd_pr__nfet_01v8 ad=2.75 pd=10.55 as=2.75 ps=10.55 w=10 l=0.15
X111 Y A VDD VDD sky130_fd_pr__pfet_01v8 ad=2.75 pd=10.55 as=2.75 ps=10.55 w=10 l=0.15
X112 Y A VDD VDD sky130_fd_pr__pfet_01v8 ad=2.75 pd=10.55 as=2.75 ps=10.55 w=10 l=0.15
X113 Y A VDD VDD sky130_fd_pr__pfet_01v8 ad=2.75 pd=10.55 as=2.75 ps=10.55 w=10 l=0.15
X114 Y A VDD VDD sky130_fd_pr__pfet_01v8 ad=2.75 pd=10.55 as=2.75 ps=10.55 w=10 l=0.15
X115 Y A VDD VDD sky130_fd_pr__pfet_01v8 ad=2.75 pd=10.55 as=2.75 ps=10.55 w=10 l=0.15
X116 GND A Y GND sky130_fd_pr__nfet_01v8 ad=2.75 pd=10.55 as=2.75 ps=10.55 w=10 l=0.15
X117 Y A VDD VDD sky130_fd_pr__pfet_01v8 ad=2.75 pd=10.55 as=2.75 ps=10.55 w=10 l=0.15
X118 Y A VDD VDD sky130_fd_pr__pfet_01v8 ad=2.75 pd=10.55 as=2.75 ps=10.55 w=10 l=0.15
X119 Y A VDD VDD sky130_fd_pr__pfet_01v8 ad=2.75 pd=10.55 as=2.75 ps=10.55 w=10 l=0.15
X120 Y A VDD VDD sky130_fd_pr__pfet_01v8 ad=2.75 pd=10.55 as=4.4 ps=20.88 w=10 l=0.15
X121 VDD A Y VDD sky130_fd_pr__pfet_01v8 ad=2.75 pd=10.55 as=2.75 ps=10.55 w=10 l=0.15
X122 Y A GND GND sky130_fd_pr__nfet_01v8 ad=4.4 pd=20.88 as=2.75 ps=10.55 w=10 l=0.15
X123 Y A VDD VDD sky130_fd_pr__pfet_01v8 ad=2.75 pd=10.55 as=2.75 ps=10.55 w=10 l=0.15
X124 Y A VDD VDD sky130_fd_pr__pfet_01v8 ad=2.75 pd=10.55 as=2.75 ps=10.55 w=10 l=0.15
X125 VDD A Y VDD sky130_fd_pr__pfet_01v8 ad=2.75 pd=10.55 as=2.75 ps=10.55 w=10 l=0.15
X126 Y A VDD VDD sky130_fd_pr__pfet_01v8 ad=2.75 pd=10.55 as=2.75 ps=10.55 w=10 l=0.15
X127 Y A GND GND sky130_fd_pr__nfet_01v8 ad=2.75 pd=10.55 as=2.75 ps=10.55 w=10 l=0.15
X128 GND A Y GND sky130_fd_pr__nfet_01v8 ad=2.75 pd=10.55 as=2.75 ps=10.55 w=10 l=0.15
C0 VDD A 14.6095f
C1 A Y 17.8363f
C2 VDD Y 65.6382f
C3 Y GND 40.2167f
C4 VDD GND 70.758f
.ends
