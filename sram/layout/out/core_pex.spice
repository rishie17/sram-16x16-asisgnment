* NGSPICE file created from core.ext - technology: sky130A

.subckt bitcell BL BLB WL VDD GND Q QB
X0 QB Q VDD VDD sky130_fd_pr__pfet_01v8 ad=0.1848 pd=1.72 as=0.1155 ps=0.97 w=0.42 l=0.15
X1 VDD QB Q VDD sky130_fd_pr__pfet_01v8 ad=0.1155 pd=0.97 as=0.1848 ps=1.72 w=0.42 l=0.15
X2 GND QB Q GND sky130_fd_pr__nfet_01v8 ad=0.17325 pd=1.18 as=0.14437 ps=1.18 w=0.63 l=0.15
X3 Q WL BL GND sky130_fd_pr__nfet_01v8 ad=0.14437 pd=1.18 as=0.1848 ps=1.72 w=0.42 l=0.15
X4 QB Q GND GND sky130_fd_pr__nfet_01v8 ad=0.14437 pd=1.18 as=0.17325 ps=1.18 w=0.63 l=0.15
X5 BLB WL QB GND sky130_fd_pr__nfet_01v8 ad=0.1848 pd=1.72 as=0.14437 ps=1.18 w=0.42 l=0.15
C0 VDD BL 0.06361f
C1 VDD WL 0.01593f
C2 BLB BL 0.03241f
C3 BLB WL 0.01664f
C4 QB BL 0.01314f
C5 QB WL 0.01626f
C6 WL BL 0.01664f
C7 VDD Q 0.08548f
C8 Q BLB 0.01314f
C9 VDD BLB 0.06361f
C10 QB Q 0.14815f
C11 VDD QB 0.1111f
C12 QB BLB 0.0343f
C13 Q BL 0.0343f
C14 Q WL 0.01804f
C15 BLB GND 0.26233f
C16 BL GND 0.54984f
C17 QB GND 0.246f
C18 VDD GND 1.10678f
.ends

.subckt nand2 A B Y VDD GND a_162_47# w_0_397# VSUBS
X0 GND B a_162_47# VSUBS sky130_fd_pr__nfet_01v8 ad=0.3696 pd=2.56 as=0.231 ps=1.39 w=0.84 l=0.15
X1 Y B VDD w_0_397# sky130_fd_pr__pfet_01v8 ad=0.3696 pd=2.56 as=0.231 ps=1.39 w=0.84 l=0.15
X2 VDD A Y w_0_397# sky130_fd_pr__pfet_01v8 ad=0.231 pd=1.39 as=0.3696 ps=2.56 w=0.84 l=0.15
X3 a_162_47# A Y VSUBS sky130_fd_pr__nfet_01v8 ad=0.231 pd=1.39 as=0.3696 ps=2.56 w=0.84 l=0.15
C0 GND VDD 0.00433f
C1 Y B 0.01673f
C2 Y A 0.0457f
C3 w_0_397# B 0.03444f
C4 w_0_397# A 0.03444f
C5 GND a_162_47# 0.01215f
C6 a_162_47# VDD 0
C7 GND Y 0.04167f
C8 VDD Y 0.14001f
C9 GND w_0_397# 0.00442f
C10 A B 0.0293f
C11 w_0_397# VDD 0.04634f
C12 a_162_47# Y 0.01292f
C13 GND B 0.01195f
C14 GND A 0.00866f
C15 w_0_397# Y 0.02334f
C16 VDD B 0.00869f
C17 VDD A 0.00869f
C18 a_162_47# B 0
C19 a_162_47# A 0
C20 GND VSUBS 0.28843f
C21 VDD VSUBS 0.22995f
C22 Y VSUBS 0.281f
C23 a_162_47# VSUBS 0.08257f
C24 w_0_397# VSUBS 0.40753f
.ends

.subckt csdrv A Y VDD GND w_0_397# VSUBS
X0 GND A Y VSUBS sky130_fd_pr__nfet_01v8 ad=0.231 pd=1.94 as=0.1617 ps=1.19 w=0.42 l=0.15
X1 Y A GND VSUBS sky130_fd_pr__nfet_01v8 ad=0.1617 pd=1.19 as=0.231 ps=1.94 w=0.42 l=0.15
X2 VDD A Y w_0_397# sky130_fd_pr__pfet_01v8 ad=0.462 pd=2.78 as=0.3234 ps=1.61 w=0.84 l=0.15
X3 Y A VDD w_0_397# sky130_fd_pr__pfet_01v8 ad=0.3234 pd=1.61 as=0.462 ps=2.78 w=0.84 l=0.15
C0 GND Y 0.04022f
C1 GND VDD 0.02533f
C2 w_0_397# Y 0.01664f
C3 w_0_397# VDD 0.06891f
C4 VDD Y 0.0613f
C5 A GND 0.02505f
C6 w_0_397# A 0.07896f
C7 w_0_397# GND 0.00551f
C8 A Y 0.066f
C9 A VDD 0.02613f
C10 GND VSUBS 0.50572f
C11 Y VSUBS 0.37296f
C12 VDD VSUBS 0.22445f
C13 w_0_397# VSUBS 0.49016f
.ends

.subckt colslice A B VDD GND n/a_162_47# w_0_390# CSEL d/GND n/Y VSUBS
Xn A B n/Y VDD GND n/a_162_47# w_0_390# VSUBS nand2
Xd n/Y CSEL VDD d/GND w_0_390# VSUBS csdrv
C0 GND CSEL 0
C1 VDD A 0
C2 n/Y B 0
C3 n/Y A 0.00278f
C4 VDD d/GND 0.00338f
C5 n/Y d/GND 0.00464f
C6 w_0_390# VDD 0.00972f
C7 w_0_390# n/Y 0.07232f
C8 B d/GND 0
C9 A d/GND 0
C10 VDD GND 0.00396f
C11 VDD CSEL -0
C12 n/Y GND 0.00636f
C13 n/Y CSEL 0.03376f
C14 w_0_390# B 0.00734f
C15 w_0_390# A 0.00949f
C16 GND A 0
C17 w_0_390# d/GND 0.00533f
C18 CSEL d/GND -0
C19 w_0_390# GND 0.00622f
C20 w_0_390# CSEL 0.00858f
C21 n/Y VDD 0.1196f
C22 d/GND VSUBS 0.05342f
C23 CSEL VSUBS -0.00896f
C24 VDD VSUBS -0.23752f
C25 n/Y VSUBS 0.16964f
C26 w_0_390# VSUBS 0.1559f
C27 GND VSUBS 0.08468f
C28 B VSUBS -0.00734f
C29 A VSUBS -0.01321f
.ends

.subckt colmux BL DL BLB DLB CSEL VSUBS
X0 DL CSEL BL VSUBS sky130_fd_pr__nfet_01v8 ad=0.3696 pd=2.56 as=0.3696 ps=2.56 w=0.84 l=0.15
X1 BLB CSEL DLB VSUBS sky130_fd_pr__nfet_01v8 ad=0.3696 pd=2.56 as=0.3696 ps=2.56 w=0.84 l=0.15
C0 BLB CSEL 0.01148f
C1 DL BL 0.03023f
C2 DLB BL 0.00206f
C3 BLB DL 0.00206f
C4 BLB DLB 0.03023f
C5 DL CSEL 0.00742f
C6 DLB CSEL 0.00742f
C7 DLB DL 0.00952f
C8 BLB BL 0.01491f
C9 CSEL BL 0.01148f
C10 BLB VSUBS 0.1624f
C11 DLB VSUBS 0.04371f
C12 DL VSUBS 0.2436f
C13 BL VSUBS 0.36229f
.ends

.subckt precharge PCB VDD BL BLB VSUBS
X0 BLB PCB BL VDD sky130_fd_pr__pfet_01v8 ad=0.6258 pd=3.82 as=0.6258 ps=3.82 w=0.42 l=0.15
X1 BLB PCB VDD VDD sky130_fd_pr__pfet_01v8 ad=0.6636 pd=3.26 as=0.525 ps=2.09 w=0.84 l=0.15
X2 VDD PCB BL VDD sky130_fd_pr__pfet_01v8 ad=0.525 pd=2.09 as=0.6636 ps=3.26 w=0.84 l=0.15
C0 BL PCB 0.01257f
C1 BLB PCB 0.01257f
C2 BL VDD 0.1558f
C3 BLB VDD 0.15509f
C4 BLB BL 0.05502f
C5 VDD PCB 0.33737f
C6 BLB VSUBS 0.23591f
C7 BL VSUBS 0.23591f
C8 VDD VSUBS 1.4606f
.ends

.subckt nand3 A B C Y VDD GND a_162_47# w_0_397# a_302_47# VSUBS
X0 a_302_47# B a_162_47# VSUBS sky130_fd_pr__nfet_01v8 ad=0.3465 pd=1.81 as=0.3465 ps=1.81 w=1.26 l=0.15
X1 VDD C Y w_0_397# sky130_fd_pr__pfet_01v8 ad=0.3696 pd=2.56 as=0.231 ps=1.39 w=0.84 l=0.15
X2 Y B VDD w_0_397# sky130_fd_pr__pfet_01v8 ad=0.231 pd=1.39 as=0.231 ps=1.39 w=0.84 l=0.15
X3 VDD A Y w_0_397# sky130_fd_pr__pfet_01v8 ad=0.231 pd=1.39 as=0.3696 ps=2.56 w=0.84 l=0.15
X4 GND C a_302_47# VSUBS sky130_fd_pr__nfet_01v8 ad=0.5544 pd=3.4 as=0.3465 ps=1.81 w=1.26 l=0.15
X5 a_162_47# A Y VSUBS sky130_fd_pr__nfet_01v8 ad=0.3465 pd=1.81 as=0.5544 ps=3.4 w=1.26 l=0.15
C0 B w_0_397# 0.03593f
C1 Y VDD 0.1587f
C2 VDD w_0_397# 0.06869f
C3 Y w_0_397# 0.02347f
C4 a_302_47# GND 0.0149f
C5 A GND 0.00781f
C6 A a_162_47# 0
C7 B a_302_47# 0
C8 B A 0.02319f
C9 C GND 0.01221f
C10 a_302_47# VDD 0
C11 Y a_302_47# 0.01336f
C12 A VDD 0.00885f
C13 Y A 0.04495f
C14 B C 0.02319f
C15 A w_0_397# 0.0369f
C16 C VDD 0.01435f
C17 Y C 0.00565f
C18 C w_0_397# 0.0369f
C19 GND a_162_47# 0.01252f
C20 B GND 0.00842f
C21 B a_162_47# 0
C22 a_302_47# C 0
C23 VDD GND 0.01702f
C24 Y GND 0.03698f
C25 VDD a_162_47# 0.00174f
C26 Y a_162_47# 0.02045f
C27 GND w_0_397# 0.00518f
C28 B VDD 0.00947f
C29 Y B 0.01759f
C30 GND VSUBS 0.23601f
C31 VDD VSUBS 0.31826f
C32 Y VSUBS 0.28163f
C33 a_302_47# VSUBS 0.04262f
C34 a_162_47# VSUBS 0.04262f
C35 w_0_397# VSUBS 0.53899f
.ends

.subckt wldrv A Y VDD GND w_0_397# VSUBS
X0 GND A Y VSUBS sky130_fd_pr__nfet_01v8 ad=0.1848 pd=1.72 as=0.1155 ps=0.97 w=0.42 l=0.15
X1 VDD A Y w_0_397# sky130_fd_pr__pfet_01v8 ad=0.3696 pd=2.56 as=0.231 ps=1.39 w=0.84 l=0.15
X2 Y A VDD w_0_397# sky130_fd_pr__pfet_01v8 ad=0.231 pd=1.39 as=0.3696 ps=2.56 w=0.84 l=0.15
X3 Y A GND VSUBS sky130_fd_pr__nfet_01v8 ad=0.1155 pd=0.97 as=0.1848 ps=1.72 w=0.42 l=0.15
C0 VDD w_0_397# 0.05909f
C1 VDD A 0.02761f
C2 GND w_0_397# 0.00487f
C3 GND A 0.02569f
C4 VDD Y 0.05869f
C5 GND Y 0.0384f
C6 A w_0_397# 0.06983f
C7 w_0_397# Y 0.01491f
C8 A Y 0.0755f
C9 GND VDD 0.02086f
C10 GND VSUBS 0.45666f
C11 Y VSUBS 0.35858f
C12 VDD VSUBS 0.20319f
C13 w_0_397# VSUBS 0.40753f
.ends

.subckt rowslice A B C WL VDD wd/A n3/a_162_47# n3/a_302_47# GND
Xn3 A B C wd/A VDD GND n3/a_162_47# VDD n3/a_302_47# GND nand3
Xwd wd/A WL VDD GND VDD GND wldrv
C0 n3/a_302_47# VDD -0
C1 VDD B -0
C2 VDD WL 0.00661f
C3 n3/a_302_47# WL 0.00166f
C4 WL B 0
C5 VDD C 0.00228f
C6 wd/A A 0.00356f
C7 WL C 0.00383f
C8 VDD wd/A 0.07387f
C9 n3/a_302_47# wd/A 0.00778f
C10 B wd/A 0.01097f
C11 WL wd/A 0.01639f
C12 C wd/A 0.03002f
C13 WL n3/a_162_47# 0
C14 n3/a_162_47# wd/A 0.00239f
C15 VDD A 0.00264f
C16 WL A 0
C17 WL GND -0.03926f
C18 VDD GND -0.24458f
C19 wd/A GND 0.07188f
C20 C GND -0.02255f
C21 B GND 0
C22 A GND -0.00172f
C23 n3/a_302_47# GND -0
.ends

.subckt rowcell A B C WL VDD s/n3/a_162_47# s/wd/A s/n3/a_302_47# GND
Xs A B C WL VDD s/wd/A s/n3/a_162_47# s/n3/a_302_47# GND rowslice
C0 WL VDD 0.10856f
C1 WL C 0
C2 WL A 0
C3 VDD s/wd/A -0.00139f
C4 WL s/wd/A 0.02538f
C5 WL s/n3/a_162_47# 0
C6 B WL 0
C7 WL s/n3/a_302_47# 0.00115f
C8 WL GND 0.24854f
C9 VDD GND -0.10247f
C10 s/wd/A GND -0.29371f
C11 C GND -0.04429f
C12 B GND -0.0182f
C13 A GND -0.02565f
.ends

.subckt core clkb rl0 rl1 rl2 rl3 rh0 rh1 rh2 rh3 bl0 blb0 bl1 blb1 bl2 blb2 bl3 blb3
+ bl4 blb4 bl5 blb5 bl6 blb6 bl7 blb7 bl8 blb8 bl9 blb9 bl10 blb10 bl11 blb11 bl12
+ blb12 bl13 blb13 bl14 blb14 bl15 blb15 csel0 csel1 csel2 csel3 csel4 csel5 csel6
+ csel7 csel8 csel9 csel10 csel11 csel12 csel13 csel14 csel15 pcb dl dlb ch0 ch1 ch2
+ ch3 cl0 cl1 cl2 cl3 VDD GND
Xc_11_1 bl1 blb1 rc11/WL VDD GND c_11_1/Q c_11_1/QB bitcell
Xc_3_14 bl14 blb14 rc3/WL VDD GND c_3_14/Q c_3_14/QB bitcell
Xcs10 ch2 cl2 VDD GND cs10/n/a_162_47# VDD csel10 GND cs10/n/Y GND colslice
Xmux12 bl12 dl blb12 dlb csel12 GND colmux
Xc_0_15 bl15 blb15 rc0/WL VDD GND c_0_15/Q c_0_15/QB bitcell
Xc_15_8 bl8 blb8 rc15/WL VDD GND c_15_8/Q c_15_8/QB bitcell
Xc_9_13 bl13 blb13 rc9/WL VDD GND c_9_13/Q c_9_13/QB bitcell
Xc_3_7 bl7 blb7 rc3/WL VDD GND c_3_7/Q c_3_7/QB bitcell
Xc_13_5 bl5 blb5 rc13/WL VDD GND c_13_5/Q c_13_5/QB bitcell
Xc_11_2 bl2 blb2 rc11/WL VDD GND c_11_2/Q c_11_2/QB bitcell
Xc_6_14 bl14 blb14 rc6/WL VDD GND c_6_14/Q c_6_14/QB bitcell
Xc_1_4 bl4 blb4 rc1/WL VDD GND c_1_4/Q c_1_4/QB bitcell
Xc_3_15 bl15 blb15 rc3/WL VDD GND c_3_15/Q c_3_15/QB bitcell
Xcs11 ch2 cl3 VDD GND cs11/n/a_162_47# VDD csel11 GND cs11/n/Y GND colslice
Xmux13 bl13 dl blb13 dlb csel13 GND colmux
Xc_11_10 bl10 blb10 rc11/WL VDD GND c_11_10/Q c_11_10/QB bitcell
Xc_9_14 bl14 blb14 rc9/WL VDD GND c_9_14/Q c_9_14/QB bitcell
Xc_15_9 bl9 blb9 rc15/WL VDD GND c_15_9/Q c_15_9/QB bitcell
Xc_13_6 bl6 blb6 rc13/WL VDD GND c_13_6/Q c_13_6/QB bitcell
Xc_6_15 bl15 blb15 rc6/WL VDD GND c_6_15/Q c_6_15/QB bitcell
Xc_1_5 bl5 blb5 rc1/WL VDD GND c_1_5/Q c_1_5/QB bitcell
Xc_3_8 bl8 blb8 rc3/WL VDD GND c_3_8/Q c_3_8/QB bitcell
Xc_14_10 bl10 blb10 rc14/WL VDD GND c_14_10/Q c_14_10/QB bitcell
Xc_11_3 bl3 blb3 rc11/WL VDD GND c_11_3/Q c_11_3/QB bitcell
Xcs12 ch3 cl0 VDD GND cs12/n/a_162_47# VDD csel12 GND cs12/n/Y GND colslice
Xc_11_11 bl11 blb11 rc11/WL VDD GND c_11_11/Q c_11_11/QB bitcell
Xmux14 bl14 dl blb14 dlb csel14 GND colmux
Xc_9_15 bl15 blb15 rc9/WL VDD GND c_9_15/Q c_9_15/QB bitcell
Xc_3_9 bl9 blb9 rc3/WL VDD GND c_3_9/Q c_3_9/QB bitcell
Xc_13_7 bl7 blb7 rc13/WL VDD GND c_13_7/Q c_13_7/QB bitcell
Xc_1_6 bl6 blb6 rc1/WL VDD GND c_1_6/Q c_1_6/QB bitcell
Xc_14_11 bl11 blb11 rc14/WL VDD GND c_14_11/Q c_14_11/QB bitcell
Xc_11_4 bl4 blb4 rc11/WL VDD GND c_11_4/Q c_11_4/QB bitcell
Xcs13 ch3 cl1 VDD GND cs13/n/a_162_47# VDD csel13 GND cs13/n/Y GND colslice
Xmux15 bl15 dl blb15 dlb csel15 GND colmux
Xc_11_12 bl12 blb12 rc11/WL VDD GND c_11_12/Q c_11_12/QB bitcell
Xc_13_8 bl8 blb8 rc13/WL VDD GND c_13_8/Q c_13_8/QB bitcell
Xc_8_0 bl0 blb0 rc8/WL VDD GND c_8_0/Q c_8_0/QB bitcell
Xc_1_7 bl7 blb7 rc1/WL VDD GND c_1_7/Q c_1_7/QB bitcell
Xc_14_12 bl12 blb12 rc14/WL VDD GND c_14_12/Q c_14_12/QB bitcell
Xc_11_5 bl5 blb5 rc11/WL VDD GND c_11_5/Q c_11_5/QB bitcell
Xc_11_13 bl13 blb13 rc11/WL VDD GND c_11_13/Q c_11_13/QB bitcell
Xcs14 ch3 cl2 VDD GND cs14/n/a_162_47# VDD csel14 GND cs14/n/Y GND colslice
Xc_8_1 bl1 blb1 rc8/WL VDD GND c_8_1/Q c_8_1/QB bitcell
Xc_13_9 bl9 blb9 rc13/WL VDD GND c_13_9/Q c_13_9/QB bitcell
Xc_1_8 bl8 blb8 rc1/WL VDD GND c_1_8/Q c_1_8/QB bitcell
Xc_14_13 bl13 blb13 rc14/WL VDD GND c_14_13/Q c_14_13/QB bitcell
Xc_11_6 bl6 blb6 rc11/WL VDD GND c_11_6/Q c_11_6/QB bitcell
Xcs15 ch3 cl3 VDD GND cs15/n/a_162_47# VDD csel15 GND cs15/n/Y GND colslice
Xc_11_14 bl14 blb14 rc11/WL VDD GND c_11_14/Q c_11_14/QB bitcell
Xc_8_2 bl2 blb2 rc8/WL VDD GND c_8_2/Q c_8_2/QB bitcell
Xc_1_9 bl9 blb9 rc1/WL VDD GND c_1_9/Q c_1_9/QB bitcell
Xc_14_14 bl14 blb14 rc14/WL VDD GND c_14_14/Q c_14_14/QB bitcell
Xc_11_7 bl7 blb7 rc11/WL VDD GND c_11_7/Q c_11_7/QB bitcell
Xc_11_15 bl15 blb15 rc11/WL VDD GND c_11_15/Q c_11_15/QB bitcell
Xc_8_3 bl3 blb3 rc8/WL VDD GND c_8_3/Q c_8_3/QB bitcell
Xc_6_0 bl0 blb0 rc6/WL VDD GND c_6_0/Q c_6_0/QB bitcell
Xc_14_15 bl15 blb15 rc14/WL VDD GND c_14_15/Q c_14_15/QB bitcell
Xc_11_8 bl8 blb8 rc11/WL VDD GND c_11_8/Q c_11_8/QB bitcell
Xc_8_4 bl4 blb4 rc8/WL VDD GND c_8_4/Q c_8_4/QB bitcell
Xc_1_10 bl10 blb10 rc1/WL VDD GND c_1_10/Q c_1_10/QB bitcell
Xc_11_9 bl9 blb9 rc11/WL VDD GND c_11_9/Q c_11_9/QB bitcell
Xc_6_1 bl1 blb1 rc6/WL VDD GND c_6_1/Q c_6_1/QB bitcell
Xc_4_10 bl10 blb10 rc4/WL VDD GND c_4_10/Q c_4_10/QB bitcell
Xc_8_5 bl5 blb5 rc8/WL VDD GND c_8_5/Q c_8_5/QB bitcell
Xc_6_2 bl2 blb2 rc6/WL VDD GND c_6_2/Q c_6_2/QB bitcell
Xc_1_11 bl11 blb11 rc1/WL VDD GND c_1_11/Q c_1_11/QB bitcell
Xc_7_10 bl10 blb10 rc7/WL VDD GND c_7_10/Q c_7_10/QB bitcell
Xc_4_11 bl11 blb11 rc4/WL VDD GND c_4_11/Q c_4_11/QB bitcell
Xc_8_6 bl6 blb6 rc8/WL VDD GND c_8_6/Q c_8_6/QB bitcell
Xcs0 ch0 cl0 VDD GND cs0/n/a_162_47# VDD csel0 GND cs0/n/Y GND colslice
Xc_1_12 bl12 blb12 rc1/WL VDD GND c_1_12/Q c_1_12/QB bitcell
Xc_6_3 bl3 blb3 rc6/WL VDD GND c_6_3/Q c_6_3/QB bitcell
Xc_7_11 bl11 blb11 rc7/WL VDD GND c_7_11/Q c_7_11/QB bitcell
Xc_4_0 bl0 blb0 rc4/WL VDD GND c_4_0/Q c_4_0/QB bitcell
Xc_4_12 bl12 blb12 rc4/WL VDD GND c_4_12/Q c_4_12/QB bitcell
Xc_8_7 bl7 blb7 rc8/WL VDD GND c_8_7/Q c_8_7/QB bitcell
Xc_6_4 bl4 blb4 rc6/WL VDD GND c_6_4/Q c_6_4/QB bitcell
Xcs1 ch0 cl1 VDD GND cs1/n/a_162_47# VDD csel1 GND cs1/n/Y GND colslice
Xc_1_13 bl13 blb13 rc1/WL VDD GND c_1_13/Q c_1_13/QB bitcell
Xc_7_12 bl12 blb12 rc7/WL VDD GND c_7_12/Q c_7_12/QB bitcell
Xc_4_1 bl1 blb1 rc4/WL VDD GND c_4_1/Q c_4_1/QB bitcell
Xc_4_13 bl13 blb13 rc4/WL VDD GND c_4_13/Q c_4_13/QB bitcell
Xc_8_8 bl8 blb8 rc8/WL VDD GND c_8_8/Q c_8_8/QB bitcell
Xc_1_14 bl14 blb14 rc1/WL VDD GND c_1_14/Q c_1_14/QB bitcell
Xcs2 ch0 cl2 VDD GND cs2/n/a_162_47# VDD csel2 GND cs2/n/Y GND colslice
Xc_6_5 bl5 blb5 rc6/WL VDD GND c_6_5/Q c_6_5/QB bitcell
Xc_14_0 bl0 blb0 rc14/WL VDD GND c_14_0/Q c_14_0/QB bitcell
Xc_7_13 bl13 blb13 rc7/WL VDD GND c_7_13/Q c_7_13/QB bitcell
Xc_4_2 bl2 blb2 rc4/WL VDD GND c_4_2/Q c_4_2/QB bitcell
Xc_4_14 bl14 blb14 rc4/WL VDD GND c_4_14/Q c_4_14/QB bitcell
Xmux0 bl0 dl blb0 dlb csel0 GND colmux
Xpre10 pcb VDD bl10 blb10 GND precharge
Xc_8_9 bl9 blb9 rc8/WL VDD GND c_8_9/Q c_8_9/QB bitcell
Xc_1_15 bl15 blb15 rc1/WL VDD GND c_1_15/Q c_1_15/QB bitcell
Xcs3 ch0 cl3 VDD GND cs3/n/a_162_47# VDD csel3 GND cs3/n/Y GND colslice
Xc_7_14 bl14 blb14 rc7/WL VDD GND c_7_14/Q c_7_14/QB bitcell
Xc_6_6 bl6 blb6 rc6/WL VDD GND c_6_6/Q c_6_6/QB bitcell
Xc_4_3 bl3 blb3 rc4/WL VDD GND c_4_3/Q c_4_3/QB bitcell
Xc_14_1 bl1 blb1 rc14/WL VDD GND c_14_1/Q c_14_1/QB bitcell
Xc_4_15 bl15 blb15 rc4/WL VDD GND c_4_15/Q c_4_15/QB bitcell
Xc_2_0 bl0 blb0 rc2/WL VDD GND c_2_0/Q c_2_0/QB bitcell
Xpre11 pcb VDD bl11 blb11 GND precharge
Xc_12_10 bl10 blb10 rc12/WL VDD GND c_12_10/Q c_12_10/QB bitcell
Xcs4 ch1 cl0 VDD GND cs4/n/a_162_47# VDD csel4 GND cs4/n/Y GND colslice
Xmux1 bl1 dl blb1 dlb csel1 GND colmux
Xc_6_7 bl7 blb7 rc6/WL VDD GND c_6_7/Q c_6_7/QB bitcell
Xc_14_2 bl2 blb2 rc14/WL VDD GND c_14_2/Q c_14_2/QB bitcell
Xc_7_15 bl15 blb15 rc7/WL VDD GND c_7_15/Q c_7_15/QB bitcell
Xc_4_4 bl4 blb4 rc4/WL VDD GND c_4_4/Q c_4_4/QB bitcell
Xc_2_1 bl1 blb1 rc2/WL VDD GND c_2_1/Q c_2_1/QB bitcell
Xc_15_10 bl10 blb10 rc15/WL VDD GND c_15_10/Q c_15_10/QB bitcell
Xmux2 bl2 dl blb2 dlb csel2 GND colmux
Xpre12 pcb VDD bl12 blb12 GND precharge
Xc_12_11 bl11 blb11 rc12/WL VDD GND c_12_11/Q c_12_11/QB bitcell
Xcs5 ch1 cl1 VDD GND cs5/n/a_162_47# VDD csel5 GND cs5/n/Y GND colslice
Xc_6_8 bl8 blb8 rc6/WL VDD GND c_6_8/Q c_6_8/QB bitcell
Xc_4_5 bl5 blb5 rc4/WL VDD GND c_4_5/Q c_4_5/QB bitcell
Xc_15_11 bl11 blb11 rc15/WL VDD GND c_15_11/Q c_15_11/QB bitcell
Xc_14_3 bl3 blb3 rc14/WL VDD GND c_14_3/Q c_14_3/QB bitcell
Xc_2_2 bl2 blb2 rc2/WL VDD GND c_2_2/Q c_2_2/QB bitcell
Xpre13 pcb VDD bl13 blb13 GND precharge
Xc_12_12 bl12 blb12 rc12/WL VDD GND c_12_12/Q c_12_12/QB bitcell
Xc_12_0 bl0 blb0 rc12/WL VDD GND c_12_0/Q c_12_0/QB bitcell
Xcs6 ch1 cl2 VDD GND cs6/n/a_162_47# VDD csel6 GND cs6/n/Y GND colslice
Xmux3 bl3 dl blb3 dlb csel3 GND colmux
Xc_6_9 bl9 blb9 rc6/WL VDD GND c_6_9/Q c_6_9/QB bitcell
Xc_4_6 bl6 blb6 rc4/WL VDD GND c_4_6/Q c_4_6/QB bitcell
Xc_15_12 bl12 blb12 rc15/WL VDD GND c_15_12/Q c_15_12/QB bitcell
Xc_14_4 bl4 blb4 rc14/WL VDD GND c_14_4/Q c_14_4/QB bitcell
Xc_12_1 bl1 blb1 rc12/WL VDD GND c_12_1/Q c_12_1/QB bitcell
Xc_0_0 bl0 blb0 rc0/WL VDD GND c_0_0/Q c_0_0/QB bitcell
Xmux4 bl4 dl blb4 dlb csel4 GND colmux
Xc_2_3 bl3 blb3 rc2/WL VDD GND c_2_3/Q c_2_3/QB bitcell
Xpre14 pcb VDD bl14 blb14 GND precharge
Xc_12_13 bl13 blb13 rc12/WL VDD GND c_12_13/Q c_12_13/QB bitcell
Xcs7 ch1 cl3 VDD GND cs7/n/a_162_47# VDD csel7 GND cs7/n/Y GND colslice
Xc_4_7 bl7 blb7 rc4/WL VDD GND c_4_7/Q c_4_7/QB bitcell
Xc_15_13 bl13 blb13 rc15/WL VDD GND c_15_13/Q c_15_13/QB bitcell
Xc_14_5 bl5 blb5 rc14/WL VDD GND c_14_5/Q c_14_5/QB bitcell
Xc_2_4 bl4 blb4 rc2/WL VDD GND c_2_4/Q c_2_4/QB bitcell
Xpre15 pcb VDD bl15 blb15 GND precharge
Xc_12_14 bl14 blb14 rc12/WL VDD GND c_12_14/Q c_12_14/QB bitcell
Xc_12_2 bl2 blb2 rc12/WL VDD GND c_12_2/Q c_12_2/QB bitcell
Xc_0_1 bl1 blb1 rc0/WL VDD GND c_0_1/Q c_0_1/QB bitcell
Xmux5 bl5 dl blb5 dlb csel5 GND colmux
Xcs8 ch2 cl0 VDD GND cs8/n/a_162_47# VDD csel8 GND cs8/n/Y GND colslice
Xc_4_8 bl8 blb8 rc4/WL VDD GND c_4_8/Q c_4_8/QB bitcell
Xc_15_14 bl14 blb14 rc15/WL VDD GND c_15_14/Q c_15_14/QB bitcell
Xc_14_6 bl6 blb6 rc14/WL VDD GND c_14_6/Q c_14_6/QB bitcell
Xc_12_3 bl3 blb3 rc12/WL VDD GND c_12_3/Q c_12_3/QB bitcell
Xc_0_2 bl2 blb2 rc0/WL VDD GND c_0_2/Q c_0_2/QB bitcell
Xmux6 bl6 dl blb6 dlb csel6 GND colmux
Xc_2_5 bl5 blb5 rc2/WL VDD GND c_2_5/Q c_2_5/QB bitcell
Xc_12_15 bl15 blb15 rc12/WL VDD GND c_12_15/Q c_12_15/QB bitcell
Xc_10_0 bl0 blb0 rc10/WL VDD GND c_10_0/Q c_10_0/QB bitcell
Xcs9 ch2 cl1 VDD GND cs9/n/a_162_47# VDD csel9 GND cs9/n/Y GND colslice
Xpre0 pcb VDD bl0 blb0 GND precharge
Xc_15_15 bl15 blb15 rc15/WL VDD GND c_15_15/Q c_15_15/QB bitcell
Xc_14_7 bl7 blb7 rc14/WL VDD GND c_14_7/Q c_14_7/QB bitcell
Xc_4_9 bl9 blb9 rc4/WL VDD GND c_4_9/Q c_4_9/QB bitcell
Xc_2_6 bl6 blb6 rc2/WL VDD GND c_2_6/Q c_2_6/QB bitcell
Xc_12_4 bl4 blb4 rc12/WL VDD GND c_12_4/Q c_12_4/QB bitcell
Xc_0_3 bl3 blb3 rc0/WL VDD GND c_0_3/Q c_0_3/QB bitcell
Xmux7 bl7 dl blb7 dlb csel7 GND colmux
Xpre1 pcb VDD bl1 blb1 GND precharge
Xc_10_1 bl1 blb1 rc10/WL VDD GND c_10_1/Q c_10_1/QB bitcell
Xrc0 rh0 rl0 clkb rc0/WL VDD rc0/s/n3/a_162_47# rc0/s/wd/A rc0/s/n3/a_302_47# GND
+ rowcell
Xc_9_0 bl0 blb0 rc9/WL VDD GND c_9_0/Q c_9_0/QB bitcell
Xc_2_10 bl10 blb10 rc2/WL VDD GND c_2_10/Q c_2_10/QB bitcell
Xc_14_8 bl8 blb8 rc14/WL VDD GND c_14_8/Q c_14_8/QB bitcell
Xc_12_5 bl5 blb5 rc12/WL VDD GND c_12_5/Q c_12_5/QB bitcell
Xc_0_4 bl4 blb4 rc0/WL VDD GND c_0_4/Q c_0_4/QB bitcell
Xmux8 bl8 dl blb8 dlb csel8 GND colmux
Xc_2_7 bl7 blb7 rc2/WL VDD GND c_2_7/Q c_2_7/QB bitcell
Xc_10_2 bl2 blb2 rc10/WL VDD GND c_10_2/Q c_10_2/QB bitcell
Xc_5_10 bl10 blb10 rc5/WL VDD GND c_5_10/Q c_5_10/QB bitcell
Xpre2 pcb VDD bl2 blb2 GND precharge
Xrc1 rh0 rl1 clkb rc1/WL VDD rc1/s/n3/a_162_47# rc1/s/wd/A rc1/s/n3/a_302_47# GND
+ rowcell
Xc_2_11 bl11 blb11 rc2/WL VDD GND c_2_11/Q c_2_11/QB bitcell
Xc_14_9 bl9 blb9 rc14/WL VDD GND c_14_9/Q c_14_9/QB bitcell
Xc_8_10 bl10 blb10 rc8/WL VDD GND c_8_10/Q c_8_10/QB bitcell
Xc_9_1 bl1 blb1 rc9/WL VDD GND c_9_1/Q c_9_1/QB bitcell
Xc_2_8 bl8 blb8 rc2/WL VDD GND c_2_8/Q c_2_8/QB bitcell
Xc_12_6 bl6 blb6 rc12/WL VDD GND c_12_6/Q c_12_6/QB bitcell
Xc_0_5 bl5 blb5 rc0/WL VDD GND c_0_5/Q c_0_5/QB bitcell
Xmux9 bl9 dl blb9 dlb csel9 GND colmux
Xpre3 pcb VDD bl3 blb3 GND precharge
Xc_10_3 bl3 blb3 rc10/WL VDD GND c_10_3/Q c_10_3/QB bitcell
Xc_5_11 bl11 blb11 rc5/WL VDD GND c_5_11/Q c_5_11/QB bitcell
Xrc2 rh0 rl2 clkb rc2/WL VDD rc2/s/n3/a_162_47# rc2/s/wd/A rc2/s/n3/a_302_47# GND
+ rowcell
Xc_9_2 bl2 blb2 rc9/WL VDD GND c_9_2/Q c_9_2/QB bitcell
Xc_2_12 bl12 blb12 rc2/WL VDD GND c_2_12/Q c_2_12/QB bitcell
Xc_8_11 bl11 blb11 rc8/WL VDD GND c_8_11/Q c_8_11/QB bitcell
Xc_0_6 bl6 blb6 rc0/WL VDD GND c_0_6/Q c_0_6/QB bitcell
Xc_2_9 bl9 blb9 rc2/WL VDD GND c_2_9/Q c_2_9/QB bitcell
Xc_12_7 bl7 blb7 rc12/WL VDD GND c_12_7/Q c_12_7/QB bitcell
Xc_10_4 bl4 blb4 rc10/WL VDD GND c_10_4/Q c_10_4/QB bitcell
Xc_5_12 bl12 blb12 rc5/WL VDD GND c_5_12/Q c_5_12/QB bitcell
Xpre4 pcb VDD bl4 blb4 GND precharge
Xrc3 rh0 rl3 clkb rc3/WL VDD rc3/s/n3/a_162_47# rc3/s/wd/A rc3/s/n3/a_302_47# GND
+ rowcell
Xc_2_13 bl13 blb13 rc2/WL VDD GND c_2_13/Q c_2_13/QB bitcell
Xc_9_3 bl3 blb3 rc9/WL VDD GND c_9_3/Q c_9_3/QB bitcell
Xc_12_8 bl8 blb8 rc12/WL VDD GND c_12_8/Q c_12_8/QB bitcell
Xc_8_12 bl12 blb12 rc8/WL VDD GND c_8_12/Q c_8_12/QB bitcell
Xc_7_0 bl0 blb0 rc7/WL VDD GND c_7_0/Q c_7_0/QB bitcell
Xc_0_7 bl7 blb7 rc0/WL VDD GND c_0_7/Q c_0_7/QB bitcell
Xpre5 pcb VDD bl5 blb5 GND precharge
Xc_10_5 bl5 blb5 rc10/WL VDD GND c_10_5/Q c_10_5/QB bitcell
Xc_5_13 bl13 blb13 rc5/WL VDD GND c_5_13/Q c_5_13/QB bitcell
Xrc4 rh1 rl0 clkb rc4/WL VDD rc4/s/n3/a_162_47# rc4/s/wd/A rc4/s/n3/a_302_47# GND
+ rowcell
Xc_9_4 bl4 blb4 rc9/WL VDD GND c_9_4/Q c_9_4/QB bitcell
Xc_2_14 bl14 blb14 rc2/WL VDD GND c_2_14/Q c_2_14/QB bitcell
Xc_8_13 bl13 blb13 rc8/WL VDD GND c_8_13/Q c_8_13/QB bitcell
Xc_7_1 bl1 blb1 rc7/WL VDD GND c_7_1/Q c_7_1/QB bitcell
Xc_12_9 bl9 blb9 rc12/WL VDD GND c_12_9/Q c_12_9/QB bitcell
Xc_10_6 bl6 blb6 rc10/WL VDD GND c_10_6/Q c_10_6/QB bitcell
Xc_5_14 bl14 blb14 rc5/WL VDD GND c_5_14/Q c_5_14/QB bitcell
Xc_0_8 bl8 blb8 rc0/WL VDD GND c_0_8/Q c_0_8/QB bitcell
Xpre6 pcb VDD bl6 blb6 GND precharge
Xrc5 rh1 rl1 clkb rc5/WL VDD rc5/s/n3/a_162_47# rc5/s/wd/A rc5/s/n3/a_302_47# GND
+ rowcell
Xc_2_15 bl15 blb15 rc2/WL VDD GND c_2_15/Q c_2_15/QB bitcell
Xc_10_10 bl10 blb10 rc10/WL VDD GND c_10_10/Q c_10_10/QB bitcell
Xc_9_5 bl5 blb5 rc9/WL VDD GND c_9_5/Q c_9_5/QB bitcell
Xc_8_14 bl14 blb14 rc8/WL VDD GND c_8_14/Q c_8_14/QB bitcell
Xc_7_2 bl2 blb2 rc7/WL VDD GND c_7_2/Q c_7_2/QB bitcell
Xc_0_9 bl9 blb9 rc0/WL VDD GND c_0_9/Q c_0_9/QB bitcell
Xc_10_7 bl7 blb7 rc10/WL VDD GND c_10_7/Q c_10_7/QB bitcell
Xrc6 rh1 rl2 clkb rc6/WL VDD rc6/s/n3/a_162_47# rc6/s/wd/A rc6/s/n3/a_302_47# GND
+ rowcell
Xc_5_15 bl15 blb15 rc5/WL VDD GND c_5_15/Q c_5_15/QB bitcell
Xpre7 pcb VDD bl7 blb7 GND precharge
Xc_13_10 bl10 blb10 rc13/WL VDD GND c_13_10/Q c_13_10/QB bitcell
Xc_8_15 bl15 blb15 rc8/WL VDD GND c_8_15/Q c_8_15/QB bitcell
Xc_10_11 bl11 blb11 rc10/WL VDD GND c_10_11/Q c_10_11/QB bitcell
Xc_9_6 bl6 blb6 rc9/WL VDD GND c_9_6/Q c_9_6/QB bitcell
Xc_7_3 bl3 blb3 rc7/WL VDD GND c_7_3/Q c_7_3/QB bitcell
Xc_10_8 bl8 blb8 rc10/WL VDD GND c_10_8/Q c_10_8/QB bitcell
Xc_5_0 bl0 blb0 rc5/WL VDD GND c_5_0/Q c_5_0/QB bitcell
Xpre8 pcb VDD bl8 blb8 GND precharge
Xc_13_11 bl11 blb11 rc13/WL VDD GND c_13_11/Q c_13_11/QB bitcell
Xrc7 rh1 rl3 clkb rc7/WL VDD rc7/s/n3/a_162_47# rc7/s/wd/A rc7/s/n3/a_302_47# GND
+ rowcell
Xc_10_12 bl12 blb12 rc10/WL VDD GND c_10_12/Q c_10_12/QB bitcell
Xc_9_7 bl7 blb7 rc9/WL VDD GND c_9_7/Q c_9_7/QB bitcell
Xc_7_4 bl4 blb4 rc7/WL VDD GND c_7_4/Q c_7_4/QB bitcell
Xc_5_1 bl1 blb1 rc5/WL VDD GND c_5_1/Q c_5_1/QB bitcell
Xc_10_9 bl9 blb9 rc10/WL VDD GND c_10_9/Q c_10_9/QB bitcell
Xrc8 rh2 rl0 clkb rc8/WL VDD rc8/s/n3/a_162_47# rc8/s/wd/A rc8/s/n3/a_302_47# GND
+ rowcell
Xpre9 pcb VDD bl9 blb9 GND precharge
Xc_13_12 bl12 blb12 rc13/WL VDD GND c_13_12/Q c_13_12/QB bitcell
Xc_10_13 bl13 blb13 rc10/WL VDD GND c_10_13/Q c_10_13/QB bitcell
Xc_9_8 bl8 blb8 rc9/WL VDD GND c_9_8/Q c_9_8/QB bitcell
Xc_7_5 bl5 blb5 rc7/WL VDD GND c_7_5/Q c_7_5/QB bitcell
Xc_5_2 bl2 blb2 rc5/WL VDD GND c_5_2/Q c_5_2/QB bitcell
Xc_15_0 bl0 blb0 rc15/WL VDD GND c_15_0/Q c_15_0/QB bitcell
Xc_13_13 bl13 blb13 rc13/WL VDD GND c_13_13/Q c_13_13/QB bitcell
Xrc9 rh2 rl1 clkb rc9/WL VDD rc9/s/n3/a_162_47# rc9/s/wd/A rc9/s/n3/a_302_47# GND
+ rowcell
Xc_9_9 bl9 blb9 rc9/WL VDD GND c_9_9/Q c_9_9/QB bitcell
Xrc10 rh2 rl2 clkb rc10/WL VDD rc10/s/n3/a_162_47# rc10/s/wd/A rc10/s/n3/a_302_47#
+ GND rowcell
Xc_10_14 bl14 blb14 rc10/WL VDD GND c_10_14/Q c_10_14/QB bitcell
Xc_7_6 bl6 blb6 rc7/WL VDD GND c_7_6/Q c_7_6/QB bitcell
Xc_15_1 bl1 blb1 rc15/WL VDD GND c_15_1/Q c_15_1/QB bitcell
Xc_5_3 bl3 blb3 rc5/WL VDD GND c_5_3/Q c_5_3/QB bitcell
Xc_3_0 bl0 blb0 rc3/WL VDD GND c_3_0/Q c_3_0/QB bitcell
Xc_13_14 bl14 blb14 rc13/WL VDD GND c_13_14/Q c_13_14/QB bitcell
Xrc11 rh2 rl3 clkb rc11/WL VDD rc11/s/n3/a_162_47# rc11/s/wd/A rc11/s/n3/a_302_47#
+ GND rowcell
Xc_10_15 bl15 blb15 rc10/WL VDD GND c_10_15/Q c_10_15/QB bitcell
Xc_7_7 bl7 blb7 rc7/WL VDD GND c_7_7/Q c_7_7/QB bitcell
Xc_5_4 bl4 blb4 rc5/WL VDD GND c_5_4/Q c_5_4/QB bitcell
Xc_15_2 bl2 blb2 rc15/WL VDD GND c_15_2/Q c_15_2/QB bitcell
Xc_13_15 bl15 blb15 rc13/WL VDD GND c_13_15/Q c_13_15/QB bitcell
Xc_3_1 bl1 blb1 rc3/WL VDD GND c_3_1/Q c_3_1/QB bitcell
Xrc12 rh3 rl0 clkb rc12/WL VDD rc12/s/n3/a_162_47# rc12/s/wd/A rc12/s/n3/a_302_47#
+ GND rowcell
Xc_7_8 bl8 blb8 rc7/WL VDD GND c_7_8/Q c_7_8/QB bitcell
Xc_15_3 bl3 blb3 rc15/WL VDD GND c_15_3/Q c_15_3/QB bitcell
Xc_5_5 bl5 blb5 rc5/WL VDD GND c_5_5/Q c_5_5/QB bitcell
Xc_0_10 bl10 blb10 rc0/WL VDD GND c_0_10/Q c_0_10/QB bitcell
Xc_3_2 bl2 blb2 rc3/WL VDD GND c_3_2/Q c_3_2/QB bitcell
Xc_13_0 bl0 blb0 rc13/WL VDD GND c_13_0/Q c_13_0/QB bitcell
Xrc13 rh3 rl1 clkb rc13/WL VDD rc13/s/n3/a_162_47# rc13/s/wd/A rc13/s/n3/a_302_47#
+ GND rowcell
Xc_3_10 bl10 blb10 rc3/WL VDD GND c_3_10/Q c_3_10/QB bitcell
Xc_7_9 bl9 blb9 rc7/WL VDD GND c_7_9/Q c_7_9/QB bitcell
Xc_5_6 bl6 blb6 rc5/WL VDD GND c_5_6/Q c_5_6/QB bitcell
Xc_0_11 bl11 blb11 rc0/WL VDD GND c_0_11/Q c_0_11/QB bitcell
Xc_15_4 bl4 blb4 rc15/WL VDD GND c_15_4/Q c_15_4/QB bitcell
Xc_3_3 bl3 blb3 rc3/WL VDD GND c_3_3/Q c_3_3/QB bitcell
Xc_13_1 bl1 blb1 rc13/WL VDD GND c_13_1/Q c_13_1/QB bitcell
Xrc14 rh3 rl2 clkb rc14/WL VDD rc14/s/n3/a_162_47# rc14/s/wd/A rc14/s/n3/a_302_47#
+ GND rowcell
Xc_6_10 bl10 blb10 rc6/WL VDD GND c_6_10/Q c_6_10/QB bitcell
Xc_1_0 bl0 blb0 rc1/WL VDD GND c_1_0/Q c_1_0/QB bitcell
Xc_3_11 bl11 blb11 rc3/WL VDD GND c_3_11/Q c_3_11/QB bitcell
Xc_15_5 bl5 blb5 rc15/WL VDD GND c_15_5/Q c_15_5/QB bitcell
Xc_9_10 bl10 blb10 rc9/WL VDD GND c_9_10/Q c_9_10/QB bitcell
Xc_5_7 bl7 blb7 rc5/WL VDD GND c_5_7/Q c_5_7/QB bitcell
Xc_0_12 bl12 blb12 rc0/WL VDD GND c_0_12/Q c_0_12/QB bitcell
Xc_3_4 bl4 blb4 rc3/WL VDD GND c_3_4/Q c_3_4/QB bitcell
Xc_13_2 bl2 blb2 rc13/WL VDD GND c_13_2/Q c_13_2/QB bitcell
Xc_6_11 bl11 blb11 rc6/WL VDD GND c_6_11/Q c_6_11/QB bitcell
Xc_1_1 bl1 blb1 rc1/WL VDD GND c_1_1/Q c_1_1/QB bitcell
Xrc15 rh3 rl3 clkb rc15/WL VDD rc15/s/n3/a_162_47# rc15/s/wd/A rc15/s/n3/a_302_47#
+ GND rowcell
Xmux10 bl10 dl blb10 dlb csel10 GND colmux
Xc_3_12 bl12 blb12 rc3/WL VDD GND c_3_12/Q c_3_12/QB bitcell
Xc_9_11 bl11 blb11 rc9/WL VDD GND c_9_11/Q c_9_11/QB bitcell
Xc_5_8 bl8 blb8 rc5/WL VDD GND c_5_8/Q c_5_8/QB bitcell
Xc_0_13 bl13 blb13 rc0/WL VDD GND c_0_13/Q c_0_13/QB bitcell
Xc_15_6 bl6 blb6 rc15/WL VDD GND c_15_6/Q c_15_6/QB bitcell
Xc_3_5 bl5 blb5 rc3/WL VDD GND c_3_5/Q c_3_5/QB bitcell
Xc_13_3 bl3 blb3 rc13/WL VDD GND c_13_3/Q c_13_3/QB bitcell
Xc_11_0 bl0 blb0 rc11/WL VDD GND c_11_0/Q c_11_0/QB bitcell
Xc_6_12 bl12 blb12 rc6/WL VDD GND c_6_12/Q c_6_12/QB bitcell
Xc_1_2 bl2 blb2 rc1/WL VDD GND c_1_2/Q c_1_2/QB bitcell
Xmux11 bl11 dl blb11 dlb csel11 GND colmux
Xc_3_13 bl13 blb13 rc3/WL VDD GND c_3_13/Q c_3_13/QB bitcell
Xc_9_12 bl12 blb12 rc9/WL VDD GND c_9_12/Q c_9_12/QB bitcell
Xc_5_9 bl9 blb9 rc5/WL VDD GND c_5_9/Q c_5_9/QB bitcell
Xc_0_14 bl14 blb14 rc0/WL VDD GND c_0_14/Q c_0_14/QB bitcell
Xc_15_7 bl7 blb7 rc15/WL VDD GND c_15_7/Q c_15_7/QB bitcell
Xc_13_4 bl4 blb4 rc13/WL VDD GND c_13_4/Q c_13_4/QB bitcell
Xc_6_13 bl13 blb13 rc6/WL VDD GND c_6_13/Q c_6_13/QB bitcell
Xc_1_3 bl3 blb3 rc1/WL VDD GND c_1_3/Q c_1_3/QB bitcell
Xc_3_6 bl6 blb6 rc3/WL VDD GND c_3_6/Q c_3_6/QB bitcell
C0 rh0 rc3/s/n3/a_302_47# 0.0045f
C1 rh3 c_13_0/Q 0
C2 VDD c_1_4/QB 0.00969f
C3 rc0/WL c_0_8/QB 0
C4 c_10_11/Q c_11_11/QB 0
C5 c_10_11/QB c_11_11/Q 0
C6 rl3 rc1/s/wd/A 0.00121f
C7 VDD c_11_9/QB 0.00969f
C8 csel14 blb14 0.00807f
C9 bl0 rc1/WL 0.06726f
C10 blb3 rc15/WL 0.00298f
C11 c_1_10/Q c_1_9/Q 0
C12 c_5_6/Q c_5_5/Q 0
C13 rc5/WL bl10 0.00159f
C14 bl0 rc10/WL 0.06726f
C15 clkb c_1_1/Q 0
C16 VDD c_11_10/Q 0.00756f
C17 c_1_2/Q rc2/WL 0
C18 c_3_5/QB c_3_6/QB 0
C19 blb9 bl10 2.86379f
C20 rh0 dlb 0.02813f
C21 rl0 dl 0.04809f
C22 c_0_5/Q blb4 0.00303f
C23 c_7_6/QB rc7/WL 0
C24 rl1 rc10/s/n3/a_302_47# 0.00105f
C25 clkb c_10_0/QB 0
C26 ch2 bl6 0
C27 c_11_3/Q rc10/WL 0
C28 bl15 c_9_14/QB 0.00303f
C29 blb9 rc8/WL 0.00159f
C30 bl0 rc10/s/n3/a_162_47# 0
C31 c_13_14/Q rc13/WL 0
C32 rc12/WL rc11/WL 0.88789f
C33 c_2_5/QB c_2_6/Q 0.01135f
C34 c_5_9/QB rc6/WL 0
C35 c_0_14/QB rc1/WL 0
C36 c_7_4/QB c_7_5/Q 0.01135f
C37 blb13 rc14/WL 0.00159f
C38 cl3 blb13 0
C39 bl8 c_13_7/QB 0.00303f
C40 blb14 c_13_15/QB 0
C41 c_10_5/QB c_10_4/QB 0
C42 c_10_15/Q rc10/WL 0
C43 bl8 cl0 0
C44 c_13_8/Q c_13_9/Q 0
C45 c_0_1/Q rc0/s/wd/A 0
C46 c_5_12/Q rc5/WL 0
C47 c_11_0/QB rc11/WL 0.00535f
C48 c_3_2/Q c_3_1/Q 0
C49 rc11/s/wd/A rl1 0.00205f
C50 rc5/WL c_4_7/QB 0
C51 bl0 rc6/WL 0.06726f
C52 c_0_9/QB ch3 0
C53 c_1_11/QB c_0_11/Q 0
C54 c_1_11/Q c_0_11/QB 0
C55 blb10 c_4_11/Q 0.00303f
C56 bl6 c_11_5/Q 0
C57 c_4_3/QB c_4_2/Q 0.00377f
C58 c_4_3/Q c_4_2/QB 0.01135f
C59 bl0 rh2 0.01321f
C60 c_10_8/Q c_10_9/Q 0
C61 c_6_4/QB c_7_4/Q 0
C62 rc12/WL c_13_11/Q 0
C63 rc11/s/n3/a_302_47# rh2 0.0045f
C64 c_3_13/QB c_3_14/Q 0.01135f
C65 VDD rc2/s/n3/a_302_47# -0
C66 rc9/WL c_10_13/Q 0
C67 blb1 c_11_2/QB 0
C68 cs4/n/Y cl3 0.05978f
C69 bl8 c_7_7/QB 0.00303f
C70 cs0/n/Y cl0 0.04796f
C71 ch2 csel12 0.06373f
C72 c_4_4/Q c_4_5/QB 0.00377f
C73 c_7_15/QB c_6_15/QB 0.01281f
C74 c_2_5/QB blb4 0
C75 blb7 rc1/WL 0.00159f
C76 c_4_9/QB rc5/WL 0
C77 c_10_0/Q c_10_1/Q 0
C78 c_13_0/QB VDD 0.01264f
C79 rh3 rc10/s/wd/A 0
C80 c_5_1/Q c_5_2/Q 0
C81 c_9_8/Q c_8_8/Q 0.00654f
C82 c_10_4/QB bl5 0.00303f
C83 c_5_1/Q c_6_1/Q 0.00634f
C84 blb5 c_7_6/QB 0
C85 pcb blb8 0.07118f
C86 clkb c_12_0/Q 0
C87 rh0 rc3/WL 0.00372f
C88 c_9_8/Q c_9_9/QB 0.00377f
C89 blb7 rc10/WL 0.00159f
C90 c_10_5/QB c_10_6/QB 0
C91 c_9_2/Q c_10_2/Q 0.00634f
C92 c_15_10/Q c_15_9/Q 0
C93 c_12_6/QB c_12_6/Q 0
C94 c_0_15/Q dlb 0
C95 c_10_14/Q rc10/WL 0
C96 rc13/WL c_13_11/Q 0
C97 rc2/WL c_2_8/QB 0
C98 bl1 rl2 0
C99 rc0/s/wd/A rl2 0.00155f
C100 c_6_11/Q c_7_11/Q 0.00654f
C101 c_0_2/Q c_0_1/Q 0
C102 c_4_10/Q c_3_10/Q 0.00634f
C103 c_6_5/QB bl6 0.00303f
C104 c_0_9/Q c_0_10/QB 0.00377f
C105 c_0_9/QB c_0_10/Q 0.01135f
C106 c_7_1/Q rc7/WL 0.00103f
C107 c_6_7/Q c_6_6/Q 0
C108 c_0_13/QB dl 0.0049f
C109 rc4/WL c_5_1/QB 0
C110 c_7_3/QB c_7_4/Q 0.01135f
C111 ch1 csel6 0.3165f
C112 bl15 c_10_14/QB 0.00303f
C113 rl3 rc11/s/wd/A 0.05286f
C114 ch0 c_0_12/QB 0
C115 cl2 cs6/n/a_162_47# 0.00134f
C116 ch1 c_0_1/QB 0
C117 c_4_2/QB rc3/WL 0
C118 bl5 rc7/WL 0.00159f
C119 c_7_13/Q bl14 0
C120 VDD c_9_9/Q 0.00756f
C121 rc6/WL blb7 0.00159f
C122 csel3 ch2 0.02936f
C123 rc2/WL c_1_5/QB 0
C124 c_2_14/Q c_2_13/Q 0
C125 c_6_11/Q c_5_11/QB 0
C126 c_6_11/QB c_5_11/Q 0
C127 rl3 rc7/s/n3/a_302_47# 0.00707f
C128 rc2/WL c_3_13/Q 0
C129 c_11_14/QB c_10_14/QB 0.01281f
C130 rc11/WL c_11_12/QB 0
C131 bl13 rc9/WL 0.00159f
C132 c_1_12/QB c_1_13/QB 0
C133 c_2_10/QB c_2_11/QB 0
C134 c_2_14/QB VDD 0.00969f
C135 c_6_9/QB c_6_10/Q 0.01135f
C136 c_0_12/Q c_0_11/Q 0
C137 c_9_2/Q rc9/WL 0
C138 rc0/WL blb12 0.00289f
C139 c_6_7/Q rc6/WL 0
C140 bl1 csel0 0.00103f
C141 c_4_3/QB rc5/WL 0
C142 VDD c_6_10/Q 0.00756f
C143 ch3 cs5/n/Y 0
C144 c_10_3/Q c_10_2/QB 0.01135f
C145 rc5/s/wd/A blb0 0
C146 c_14_5/Q rc14/WL 0
C147 c_1_5/QB c_0_5/QB 0.01281f
C148 c_12_13/QB c_13_13/QB 0.01281f
C149 cs3/n/Y cl2 0.04756f
C150 ch0 c_0_8/QB 0
C151 blb11 c_4_12/QB 0
C152 blb9 dl 0.02104f
C153 rc0/WL ch0 0.00516f
C154 clkb rl0 4.45591f
C155 c_4_0/Q c_4_1/Q 0
C156 bl10 rc7/WL 0.00159f
C157 c_3_10/QB c_3_9/Q 0.00377f
C158 c_6_4/Q bl5 0
C159 rc8/WL rc7/WL 0.88789f
C160 c_4_8/QB c_3_8/QB 0.0025f
C161 rc11/WL c_11_5/QB 0
C162 c_8_13/Q rc7/WL 0
C163 rh0 cl0 0.02792f
C164 c_2_4/Q rc1/WL 0
C165 pcb c_15_1/QB 0.00493f
C166 VDD c_10_12/QB 0.00969f
C167 cs8/n/Y ch3 0
C168 rc12/WL c_13_9/Q 0
C169 c_10_3/Q c_10_4/Q 0
C170 VDD c_3_2/Q 0.00756f
C171 blb5 c_4_6/QB 0
C172 blb5 bl5 -0.00665f
C173 blb2 c_13_3/Q 0.00303f
C174 c_9_4/Q c_9_3/Q 0
C175 c_8_2/QB c_8_3/Q 0.01135f
C176 c_0_7/Q dlb 0
C177 c_0_6/Q rc1/WL 0
C178 blb6 rc1/WL 0.00159f
C179 c_5_6/QB bl7 0.00303f
C180 c_7_11/QB rc8/WL 0
C181 cs10/n/Y dl 0
C182 c_13_9/QB c_14_9/Q 0
C183 c_13_3/QB bl4 0.00303f
C184 rc5/WL blb15 0
C185 c_14_14/QB c_15_14/QB 0.01281f
C186 cl3 cs9/n/a_162_47# 0
C187 rc8/s/n3/a_162_47# rh1 0
C188 ch1 blb0 0
C189 blb6 rc10/WL 0.00159f
C190 ch0 c_0_15/QB 0
C191 rc6/s/n3/a_302_47# bl0 0.00159f
C192 c_8_12/Q c_7_12/QB 0
C193 cs14/n/Y ch0 0
C194 rc0/WL rl1 0
C195 bl1 rc7/s/wd/A 0
C196 pcb c_15_8/QB 0.00493f
C197 c_3_4/QB rc4/WL 0
C198 c_4_15/QB VDD 0.00479f
C199 bl3 c_15_2/QB 0.00303f
C200 blb11 rc4/WL 0.00159f
C201 c_3_13/Q c_4_13/Q 0.00634f
C202 c_10_3/QB rc10/WL 0
C203 bl13 dlb 0
C204 rc13/WL c_13_9/Q 0
C205 c_8_11/QB c_9_11/Q 0
C206 c_10_5/QB c_11_5/Q 0
C207 c_10_5/Q c_11_5/QB 0
C208 blb2 rc5/WL 0.00159f
C209 c_14_15/Q rc13/WL 0
C210 rl0 cl2 0.02784f
C211 c_0_7/Q csel7 0.00119f
C212 rc11/WL c_12_4/QB 0
C213 blb5 rc8/WL 0.00159f
C214 c_8_9/QB c_8_8/Q 0.00377f
C215 c_8_9/Q c_8_8/QB 0.01135f
C216 rc11/WL blb8 0.00159f
C217 bl2 c_14_1/Q 0
C218 rc9/s/n3/a_162_47# rh2 0.01115f
C219 c_2_13/QB rc1/WL 0
C220 blb2 c_12_3/QB 0
C221 rc14/WL c_15_4/QB 0
C222 rc13/s/wd/A c_13_1/Q 0
C223 c_8_9/QB c_9_9/QB 0.01281f
C224 ch2 bl5 0
C225 blb6 rc6/WL 0.00159f
C226 c_6_6/Q c_6_7/QB 0.00377f
C227 cl0 c_0_15/Q 0
C228 c_11_4/QB rc11/WL 0
C229 rc12/s/wd/A c_12_1/Q 0
C230 c_3_13/QB rc2/WL 0
C231 VDD c_6_13/QB 0.00969f
C232 clkb rc8/s/wd/A 0.09749f
C233 rc9/s/wd/A rl1 0.05346f
C234 c_9_4/Q c_9_5/Q 0
C235 rc11/s/n3/a_162_47# VDD 0
C236 c_4_8/QB c_4_7/Q 0.00377f
C237 csel10 dlb 0.10216f
C238 rc4/WL c_3_2/QB 0
C239 c_8_10/Q c_9_10/Q 0.00654f
C240 c_0_13/Q dlb 0
C241 rc8/WL c_9_8/Q 0
C242 VDD c_8_10/QB 0.00969f
C243 c_9_12/QB c_8_12/QB 0.01281f
C244 rc0/s/wd/A rh1 0
C245 c_2_8/Q rc1/WL 0
C246 ch2 c_0_12/Q 0
C247 c_7_8/Q c_7_7/Q 0
C248 c_2_14/Q c_1_14/Q 0.00634f
C249 rc5/WL c_5_11/Q 0
C250 bl1 c_9_0/Q 0
C251 clkb rc13/s/n3/a_162_47# 0.00107f
C252 c_12_13/Q VDD 0.00756f
C253 c_12_7/QB c_11_7/QB 0.0025f
C254 rc2/WL c_1_13/QB 0
C255 rc6/WL c_6_7/QB 0
C256 c_12_8/Q c_12_7/Q 0
C257 rc14/WL c_15_5/QB 0
C258 c_4_14/QB rc3/WL 0
C259 c_4_9/Q c_4_8/QB 0.01135f
C260 rc15/WL c_15_10/Q 0
C261 blb6 c_1_7/Q 0.00303f
C262 bl3 c_7_2/Q 0
C263 rc15/WL c_15_3/QB 0
C264 ch1 csel8 0.06924f
C265 ch2 bl10 0
C266 bl13 rc3/WL 0.00159f
C267 cs2/n/Y cl1 0.04734f
C268 c_1_10/QB VDD 0.00969f
C269 c_4_5/Q c_4_4/QB 0.01135f
C270 c_14_2/Q c_14_3/Q 0
C271 cs2/n/Y VDD 0.01448f
C272 c_6_2/Q c_6_3/QB 0.00377f
C273 rc12/s/wd/A rl2 0.00155f
C274 rc2/WL c_1_7/QB 0
C275 rc2/WL blb14 0.00159f
C276 bl3 c_5_2/Q 0
C277 clkb rc5/WL 0.00509f
C278 blb1 c_15_2/QB 0
C279 VDD rc15/s/wd/A -0.00273f
C280 c_0_0/QB c_1_0/Q 0
C281 c_1_10/Q c_1_11/Q 0
C282 c_14_11/Q VDD 0.00756f
C283 c_8_4/Q c_8_3/QB 0.01135f
C284 c_8_4/QB c_8_3/Q 0.00377f
C285 blb9 c_9_10/Q 0.00303f
C286 csel1 cl1 0.03035f
C287 ch2 c_0_8/Q 0
C288 csel1 VDD 0.02187f
C289 rc15/WL c_14_3/QB 0
C290 cl3 cl1 0.19243f
C291 bl10 csel9 0.00103f
C292 c_2_13/QB c_1_13/Q 0
C293 c_4_4/Q bl5 0
C294 rl0 rc14/s/wd/A 0.00281f
C295 cl3 VDD 0.78064f
C296 c_0_11/Q dl 0.00931f
C297 ch0 blb12 0.00109f
C298 c_0_11/QB dlb 0.004f
C299 rc5/s/wd/A bl0 0.00934f
C300 VDD rc14/WL 0.05907f
C301 bl1 c_5_0/QB 0.00303f
C302 c_0_2/QB c_1_2/QB 0.01281f
C303 c_2_1/Q c_1_1/QB 0
C304 blb12 c_15_13/Q 0.00303f
C305 c_5_2/QB c_5_3/Q 0.01135f
C306 c_5_2/Q c_5_3/QB 0.00377f
C307 rc4/WL c_5_4/Q 0
C308 c_9_8/QB rc9/WL 0
C309 ch0 cs7/n/Y 0
C310 c_4_1/QB c_5_1/QB 0.01281f
C311 rc2/WL c_3_9/Q 0
C312 c_2_14/QB c_2_15/Q 0.01135f
C313 c_1_12/Q c_2_12/QB 0
C314 rl3 rc9/s/wd/A 0.00121f
C315 c_0_14/QB bl15 0.00303f
C316 c_13_8/QB c_13_7/Q 0.00377f
C317 c_13_8/Q c_13_7/QB 0.01135f
C318 rc14/WL c_14_7/QB 0
C319 c_9_7/Q blb6 0.00303f
C320 rc0/WL c_1_6/Q 0
C321 c_3_13/QB c_4_13/Q 0
C322 c_6_1/QB rc6/s/wd/A 0
C323 c_12_4/Q bl5 0
C324 c_15_4/Q rc14/WL 0
C325 c_10_8/Q rc10/WL 0
C326 cs13/n/Y cs12/n/Y 0.02812f
C327 rc0/WL c_1_9/QB 0
C328 blb11 c_14_12/Q 0.00303f
C329 c_8_5/Q c_7_5/Q 0.00634f
C330 rl0 pcb 0
C331 c_2_9/QB bl10 0.00303f
C332 c_4_0/Q c_5_0/Q 0.00654f
C333 bl2 c_6_1/Q 0
C334 cl3 cs5/n/a_162_47# 0
C335 c_2_5/Q rc2/WL 0
C336 c_4_5/QB c_3_5/Q 0
C337 c_13_3/Q c_13_2/Q 0
C338 rc12/WL c_12_5/Q 0
C339 rc11/WL c_10_0/QB 0
C340 rc0/s/n3/a_162_47# bl0 0
C341 c_0_7/Q cl0 0
C342 c_5_6/Q c_6_6/QB 0
C343 c_8_0/QB c_8_1/QB 0
C344 c_15_3/Q c_14_3/Q 0.00654f
C345 c_11_4/Q bl5 0
C346 rc0/WL bl7 0.00289f
C347 csel14 c_1_14/Q 0
C348 rc4/s/wd/A rh2 0
C349 blb15 rc7/WL 0
C350 VDD c_8_3/Q 0.00756f
C351 c_12_13/QB bl14 0.00303f
C352 c_14_2/QB rc14/WL 0
C353 c_3_3/Q c_3_4/Q 0
C354 bl6 c_3_5/Q 0
C355 ch1 bl0 0
C356 blb14 c_1_15/QB 0
C357 blb1 c_7_2/Q 0.00303f
C358 c_13_5/QB blb4 0
C359 csel4 csel5 0.02364f
C360 c_0_1/Q c_1_1/QB 0
C361 blb5 dl 0.02104f
C362 cl1 bl8 0
C363 blb1 c_5_2/Q 0.00303f
C364 ch0 rl1 0.02782f
C365 c_0_2/Q bl3 0
C366 blb9 cl2 0
C367 c_7_6/Q rc7/WL 0
C368 bl8 VDD -0.00929f
C369 blb13 c_11_14/Q 0.00303f
C370 bl13 cl0 0
C371 c_15_11/QB c_15_10/Q 0.00377f
C372 c_11_8/Q blb7 0.00303f
C373 c_9_13/Q rc10/WL 0
C374 c_9_4/QB rc10/WL 0
C375 blb5 c_3_6/QB 0
C376 c_2_12/Q c_3_12/Q 0.00654f
C377 rc5/WL c_6_0/Q 0
C378 c_10_14/Q bl15 0
C379 rh0 rc2/s/wd/A 0.03742f
C380 blb2 rc7/WL 0.00159f
C381 bl1 blb1 -0.00665f
C382 rc0/s/wd/A blb1 0
C383 c_2_15/QB c_1_15/Q 0
C384 c_13_9/Q blb8 0.00303f
C385 c_9_15/Q c_9_14/Q 0
C386 rc13/WL c_12_5/Q 0
C387 c_8_7/QB rc7/WL 0
C388 bl8 c_14_7/QB 0.00303f
C389 c_6_4/QB c_6_3/Q 0.00377f
C390 ch1 c_0_14/QB 0
C391 ch3 cs13/n/a_162_47# 0.00134f
C392 cl1 cs0/n/Y 0
C393 rl1 rc3/s/wd/A 0.00205f
C394 c_15_15/QB c_15_14/Q 0.00377f
C395 c_12_11/Q c_12_12/QB 0.00377f
C396 c_12_11/QB c_12_12/Q 0.01135f
C397 c_10_14/Q c_11_14/QB 0
C398 rc12/WL c_13_1/Q 0
C399 bl8 c_9_7/QB 0.00303f
C400 VDD cs0/n/Y 0.02056f
C401 rc6/WL c_7_0/QB 0
C402 c_6_8/QB c_5_8/QB 0.0025f
C403 rc11/WL c_11_11/Q 0
C404 VDD c_12_10/Q 0.00756f
C405 blb7 c_13_8/QB 0
C406 rc12/WL bl4 0.00159f
C407 csel10 cl0 0.02918f
C408 c_14_9/Q c_14_10/QB 0.00377f
C409 c_10_10/QB c_9_10/QB 0.0025f
C410 rc11/WL c_12_0/Q 0
C411 bl12 c_9_11/QB 0.00303f
C412 cl2 cs10/n/Y 0.04836f
C413 c_6_4/QB c_7_4/QB 0.01281f
C414 bl10 c_8_9/QB 0.00303f
C415 c_0_13/Q cl0 0
C416 c_12_6/Q c_11_6/Q 0.00634f
C417 rc8/WL c_8_9/QB 0
C418 ch3 blb4 0
C419 bl14 rc1/WL 0.00159f
C420 VDD c_11_11/QB 0.00969f
C421 ch3 c_0_10/QB 0
C422 c_4_8/QB rc3/WL 0
C423 c_4_14/QB blb13 0
C424 c_2_9/Q c_2_10/Q 0
C425 c_7_7/Q rc6/WL 0
C426 VDD c_6_12/Q 0.00756f
C427 pcb rc8/s/wd/A 0
C428 ch2 dl 0.03702f
C429 csel2 dlb 0.10216f
C430 c_5_10/Q c_6_10/Q 0.00634f
C431 c_7_1/Q c_8_1/Q 0.00634f
C432 bl14 rc10/WL 0.00159f
C433 blb13 bl13 -0.00665f
C434 blb5 c_7_6/Q 0.00303f
C435 VDD c_11_10/QB 0.00969f
C436 c_10_2/QB c_10_1/Q 0.00377f
C437 ch1 blb7 0
C438 c_5_7/Q c_5_8/QB 0.00377f
C439 VDD rc5/s/n3/a_162_47# 0
C440 rl3 ch0 0.02782f
C441 rc9/WL blb8 0.00159f
C442 rc13/WL c_13_1/Q 0.00103f
C443 c_4_9/Q blb8 0.00303f
C444 c_0_2/Q blb1 0.00303f
C445 csel9 dl 0.08427f
C446 clkb rc7/WL 0.00509f
C447 c_6_2/Q rc6/WL 0
C448 rc13/WL bl4 0.00159f
C449 rc12/s/wd/A rh1 0
C450 c_7_3/QB c_6_3/Q 0
C451 c_7_14/Q rc8/WL 0
C452 c_1_6/QB dl 0.0021f
C453 c_3_10/Q c_3_9/Q 0
C454 c_3_12/QB rc2/WL 0
C455 c_5_7/QB c_4_7/QB 0.01281f
C456 c_2_1/Q rc1/WL 0
C457 rc8/WL c_9_2/QB 0
C458 VDD c_7_5/Q 0.00756f
C459 cl0 c_0_11/QB 0
C460 rc3/s/n3/a_162_47# rh1 0
C461 rc6/WL bl14 0.00159f
C462 rc12/WL c_13_7/QB 0
C463 rl3 rc3/s/wd/A 0.05286f
C464 c_7_3/QB c_7_4/QB 0
C465 c_0_14/Q c_1_14/Q 0.00654f
C466 c_9_0/QB c_8_0/Q 0
C467 c_10_8/QB c_10_7/QB 0
C468 clkb c_11_0/Q 0
C469 rc0/WL bl6 0.00289f
C470 ch2 blb15 0
C471 c_9_0/QB VDD 0.01264f
C472 blb9 pcb 0.07118f
C473 c_0_6/QB dlb 0.004f
C474 rc2/WL csel5 0
C475 c_0_12/QB csel12 0
C476 c_12_8/QB c_12_9/QB 0
C477 VDD c_14_10/Q 0.00756f
C478 VDD c_10_7/QB 0.00969f
C479 rc12/WL c_11_3/QB 0
C480 cs11/n/Y cs12/n/Y 0.02812f
C481 c_14_11/QB c_14_12/Q 0.01135f
C482 c_14_11/Q c_14_12/QB 0.00377f
C483 rl0 rc8/s/n3/a_302_47# 0.00707f
C484 c_8_1/Q rc8/WL 0.00103f
C485 rc15/WL blb14 0.00298f
C486 bl11 c_13_10/QB 0.00303f
C487 c_12_5/QB c_11_5/Q 0
C488 c_12_5/Q c_11_5/QB 0
C489 c_0_1/QB csel1 0
C490 cl3 csel6 0.03848f
C491 c_1_13/Q bl14 0
C492 bl1 rc2/WL 0.00215f
C493 rl0 rc11/WL 0
C494 c_8_13/QB rc9/WL 0
C495 rl3 rl1 0.17174f
C496 bl0 rc2/s/n3/a_302_47# 0.00159f
C497 c_4_4/QB c_4_3/Q 0.00377f
C498 c_4_4/Q c_4_3/QB 0.01135f
C499 c_7_9/Q blb8 0.00303f
C500 c_5_0/QB c_5_1/QB 0
C501 c_7_15/QB c_8_15/QB 0.0025f
C502 rc14/WL c_14_12/QB 0
C503 c_9_14/Q rc10/WL 0
C504 rc5/s/wd/A rc5/s/n3/a_302_47# -0
C505 rl0 c_8_0/QB 0
C506 cs3/n/a_162_47# ch0 0.00134f
C507 rh0 cl1 0.02787f
C508 blb2 ch2 0
C509 c_7_3/QB bl4 0.00303f
C510 c_13_2/Q c_12_2/QB 0
C511 rh0 VDD 0.53339f
C512 c_0_5/Q c_0_4/Q 0
C513 c_5_14/QB rc4/WL 0
C514 c_0_5/QB csel5 0
C515 rc13/WL c_13_7/QB 0
C516 c_9_7/QB c_10_7/QB 0.0025f
C517 ch0 bl7 0.00109f
C518 c_0_1/Q rc1/WL 0
C519 rc2/WL c_2_13/Q 0
C520 rc8/WL c_9_13/QB 0
C521 c_9_13/QB c_8_13/Q 0
C522 bl1 c_15_0/Q 0
C523 bl9 rc2/WL 0.00159f
C524 bl9 c_15_9/Q 0
C525 cs10/n/Y cs9/n/Y 0.02812f
C526 dlb blb8 0.0282f
C527 rc0/WL csel12 0.02369f
C528 c_3_3/QB rc2/WL 0
C529 cs13/n/Y ch3 0.09885f
C530 rc12/WL blb13 0.00159f
C531 bl2 c_5_1/QB 0.00303f
C532 csel15 dlb 0.10216f
C533 c_6_0/Q rc7/WL 0
C534 c_1_2/QB c_1_2/Q -0
C535 c_5_6/QB c_4_6/QB 0.01281f
C536 rc15/WL c_15_15/Q 0
C537 csel0 c_1_0/QB 0
C538 VDD c_4_2/QB 0.00969f
C539 c_9_13/QB c_10_13/QB 0.0025f
C540 c_8_1/QB rc9/WL 0
C541 c_0_7/QB c_0_6/Q 0.00377f
C542 c_4_15/Q rc3/WL 0
C543 c_9_12/Q c_9_13/Q 0
C544 c_0_7/QB blb6 0
C545 c_12_5/QB c_12_4/Q 0.00377f
C546 c_12_5/Q c_12_4/QB 0.01135f
C547 bl7 c_10_6/Q 0
C548 rc8/WL c_8_8/QB 0
C549 rh3 ch3 0.02852f
C550 c_9_2/Q c_8_2/QB 0
C551 c_15_6/Q bl7 0
C552 c_15_14/Q blb14 0
C553 c_14_4/Q c_13_4/QB 0
C554 c_10_0/QB rc9/WL 0
C555 ch1 c_0_6/Q 0
C556 ch1 blb6 0
C557 c_4_4/QB rc3/WL 0
C558 c_4_5/Q c_3_5/QB 0
C559 rc14/s/n3/a_302_47# rl2 0.00707f
C560 cs6/n/Y ch3 0
C561 rc15/s/wd/A blb0 0
C562 rc12/s/wd/A blb1 0
C563 clkb ch2 0.03883f
C564 c_4_8/Q c_5_8/QB 0
C565 rc8/WL c_8_2/Q 0
C566 c_15_13/QB c_14_13/QB 0.01281f
C567 rc13/WL blb13 0.00159f
C568 c_14_1/Q rc15/WL 0
C569 csel1 blb0 0.00103f
C570 rc8/s/wd/A rc8/s/n3/a_302_47# -0
C571 cl3 blb0 0
C572 csel3 rc0/WL 0.02369f
C573 rh0 c_3_0/Q 0
C574 c_14_2/Q c_15_2/Q 0.00654f
C575 rc14/WL blb0 0.00236f
C576 blb5 cl2 0
C577 c_2_14/Q rc1/WL 0
C578 csel2 cl0 0.02918f
C579 VDD c_0_15/Q 0.00565f
C580 c_15_13/QB bl14 0.00303f
C581 c_8_10/Q c_8_11/Q 0
C582 c_14_8/QB bl9 0.00303f
C583 blb8 rc3/WL 0.00159f
C584 rc10/WL rl2 0.00286f
C585 c_4_15/Q c_5_15/Q 0.00654f
C586 c_8_0/QB rc8/s/wd/A 0.00246f
C587 c_2_4/Q c_1_4/QB 0
C588 c_2_4/QB c_1_4/Q 0
C589 c_3_12/QB c_4_12/Q 0
C590 c_13_4/Q rc14/WL 0
C591 rc15/WL c_15_2/QB 0
C592 c_13_3/QB VDD 0.00969f
C593 csel14 cs15/n/Y 0.00301f
C594 rc1/s/wd/A dl 0.00199f
C595 c_1_2/Q c_2_2/Q 0.00634f
C596 rc10/s/n3/a_162_47# rl2 0.01123f
C597 c_15_14/Q c_15_15/Q 0
C598 rc5/WL c_6_8/QB 0
C599 rc0/s/n3/a_302_47# rh0 0.0045f
C600 c_4_15/Q c_3_15/Q 0.00634f
C601 rc5/s/wd/A rc4/s/wd/A 0.02158f
C602 c_14_4/QB c_14_3/Q 0.00377f
C603 c_5_1/Q rc6/WL 0
C604 c_2_11/Q c_2_12/QB 0.00377f
C605 c_1_5/QB blb4 0
C606 c_15_15/QB c_15_14/QB 0
C607 c_2_12/Q c_2_13/QB 0.00377f
C608 c_12_8/Q rc11/WL 0
C609 csel0 rc1/WL 0
C610 c_11_8/Q c_10_8/Q 0.00654f
C611 rc0/WL c_1_11/QB 0
C612 rc6/WL rl2 0.00286f
C613 c_14_6/QB c_15_6/Q 0
C614 c_11_1/Q c_12_1/Q 0.00634f
C615 c_13_11/Q c_13_12/QB 0.00377f
C616 c_1_2/Q c_1_3/Q 0
C617 bl3 c_3_2/QB 0.00303f
C618 c_2_11/Q c_3_11/Q 0.00654f
C619 blb11 bl12 2.86379f
C620 rh2 rl2 0.44613f
C621 blb9 rc11/WL 0.00159f
C622 cs11/n/Y csel11 0.07585f
C623 c_6_12/QB c_7_12/QB 0.01281f
C624 c_12_3/QB rc11/WL 0
C625 VDD c_10_13/Q 0.00756f
C626 c_0_6/QB cl0 0
C627 ch2 c_0_3/QB 0
C628 ch0 bl6 0.00109f
C629 blb11 bl11 -0.00665f
C630 c_3_2/QB c_2_2/QB 0.01281f
C631 bl1 c_7_0/Q 0
C632 pcb c_15_6/QB 0.00493f
C633 ch2 cl2 0.34604f
C634 rc13/s/wd/A VDD -0.00408f
C635 rc5/WL c_5_7/Q 0
C636 c_15_3/Q c_15_2/Q 0
C637 blb11 c_1_12/QB 0
C638 c_13_6/Q blb5 0.00303f
C639 rc2/WL c_1_14/Q 0
C640 VDD c_11_14/Q 0.00756f
C641 c_2_0/Q c_1_0/Q 0.00634f
C642 c_7_12/Q rc7/WL 0
C643 c_15_7/QB rc14/WL 0
C644 blb11 c_8_12/QB 0
C645 blb10 rc4/WL 0.00159f
C646 csel9 c_1_9/Q 0
C647 cl3 csel8 0.06159f
C648 c_5_4/Q c_5_5/Q 0
C649 cl2 csel9 0.02844f
C650 VDD c_13_8/Q 0.00756f
C651 c_13_0/QB c_14_0/Q 0
C652 c_8_5/QB rc7/WL 0
C653 blb12 csel12 0.00807f
C654 csel14 rc1/WL 0
C655 c_15_6/Q bl6 0
C656 c_8_14/Q bl15 0
C657 bl2 c_1_1/QB 0.00303f
C658 c_7_1/QB rc8/WL 0
C659 cs1/n/Y cs0/n/a_162_47# 0
C660 c_3_15/QB c_2_15/QB 0.01281f
C661 ch3 cs11/n/Y 0.00118f
C662 cl0 blb8 0.00156f
C663 rc15/WL c_14_14/Q 0
C664 c_14_9/QB bl9 0
C665 rc12/WL c_12_15/Q 0
C666 c_7_11/QB c_7_12/Q 0.01135f
C667 rc11/s/n3/a_162_47# bl0 0
C668 c_0_7/Q VDD 0.00756f
C669 ch0 csel12 0.03716f
C670 cl0 csel15 0.02918f
C671 c_14_14/Q c_14_13/Q 0
C672 bl1 rc15/WL 0.00353f
C673 c_1_6/Q bl7 0
C674 c_12_9/QB c_12_9/Q 0
C675 pcb blb5 0.07118f
C676 c_14_5/Q rc13/WL 0
C677 c_2_9/Q c_1_9/QB 0
C678 c_2_9/QB c_1_9/Q 0
C679 c_6_3/QB c_5_3/QB 0.0025f
C680 ch0 cs2/n/a_162_47# 0.00134f
C681 rc0/WL bl5 0.00289f
C682 csel13 bl14 0.00103f
C683 c_3_14/QB c_3_15/QB 0
C684 rl0 rc9/WL 0
C685 c_2_10/QB c_1_10/QB 0.0025f
C686 bl15 rc4/WL 0.00159f
C687 c_4_14/QB VDD 0.00969f
C688 c_9_3/Q rc10/WL 0
C689 cs5/n/Y csel5 0.07585f
C690 cs3/n/Y dlb 0
C691 bl10 c_12_9/QB 0.00303f
C692 c_11_4/QB c_11_3/QB 0
C693 cl1 bl13 0
C694 c_4_5/Q rc5/WL 0
C695 blb1 c_3_2/QB 0
C696 VDD bl13 -0.00929f
C697 blb9 c_10_10/Q 0.00303f
C698 c_11_1/QB c_11_2/QB 0
C699 rc12/s/n3/a_162_47# rc12/s/wd/A -0.00121f
C700 rc5/s/wd/A rc4/WL 0
C701 c_5_4/Q c_5_3/QB 0.01135f
C702 bl8 c_15_7/QB 0.00303f
C703 bl9 rc15/WL 0.00298f
C704 c_9_3/Q c_8_3/QB 0
C705 c_9_2/Q VDD 0.00756f
C706 ch3 c_0_5/Q 0
C707 rc0/WL c_0_12/Q 0
C708 c_1_15/Q c_1_14/QB 0.01135f
C709 c_1_15/QB c_1_14/Q 0.00377f
C710 rc13/WL c_12_15/Q 0
C711 bl8 csel8 0.00807f
C712 rc15/s/wd/A bl0 0.00934f
C713 clkb rc12/s/n3/a_302_47# 0.00768f
C714 c_3_3/Q rc4/WL 0
C715 rc5/WL c_4_6/Q 0
C716 rc14/WL c_13_7/Q 0
C717 rc6/WL rc7/s/wd/A 0
C718 cl3 bl0 0
C719 bl0 rc14/WL 0.06726f
C720 c_0_0/QB ch3 0
C721 c_7_13/QB c_7_12/QB 0
C722 rh2 rc7/s/wd/A 0
C723 rc11/WL c_12_2/QB 0
C724 c_10_4/QB rc11/WL 0
C725 csel3 ch0 0.34945f
C726 csel10 cl1 0.06555f
C727 rc0/WL bl10 0.00289f
C728 clkb rc1/s/wd/A 0.09749f
C729 csel10 VDD 0.02187f
C730 c_14_14/Q c_15_14/Q 0.00654f
C731 bl1 c_4_0/QB 0.00303f
C732 pcb c_15_12/Q 0.00484f
C733 pcb ch2 0.02782f
C734 c_0_13/Q VDD 0.00756f
C735 c_12_13/QB c_11_13/QB 0.0025f
C736 rl0 rc3/s/n3/a_302_47# 0.00105f
C737 c_6_15/QB blb14 0
C738 rc11/WL c_11_2/Q 0
C739 ch2 cs9/n/Y 0.09866f
C740 VDD c_1_4/Q 0.00756f
C741 c_12_11/QB c_12_10/QB 0
C742 c_13_6/QB bl7 0.00303f
C743 rc0/WL c_0_8/Q 0
C744 c_9_0/Q rc10/WL 0
C745 c_10_11/Q c_11_11/Q 0.00654f
C746 VDD c_11_9/Q 0.00756f
C747 c_6_8/QB rc7/WL 0
C748 c_6_10/QB c_6_11/QB 0
C749 c_15_10/QB c_14_10/QB 0.01281f
C750 rc10/WL c_9_5/Q 0
C751 clkb c_8_1/Q 0
C752 c_12_7/QB c_12_8/QB 0
C753 c_8_7/QB c_8_8/QB 0
C754 c_7_4/Q rc7/WL 0
C755 blb14 c_15_14/QB 0
C756 csel9 cs9/n/Y 0.07585f
C757 rc5/WL c_4_8/Q 0
C758 rc2/WL c_3_4/QB 0
C759 c_3_5/Q c_3_6/QB 0.00377f
C760 c_3_5/QB c_3_6/Q 0.01135f
C761 c_8_11/Q rc7/WL 0
C762 rl0 dlb 0.02808f
C763 rh0 blb0 0
C764 bl3 rc1/WL 0.00159f
C765 blb11 rc2/WL 0.00159f
C766 clkb c_10_0/Q 0
C767 c_14_11/QB bl12 0.00303f
C768 bl15 c_9_14/Q 0
C769 ch1 bl14 0
C770 rc6/WL rh1 0.00372f
C771 c_14_6/QB bl7 0.00303f
C772 blb3 c_0_4/Q 0.00303f
C773 rc6/s/n3/a_302_47# rl2 0.00707f
C774 rc8/WL rc9/s/wd/A 0
C775 rc8/s/wd/A rc9/WL 0
C776 rh2 rh1 3.7726f
C777 c_2_2/QB rc1/WL 0
C778 c_2_5/Q c_2_6/Q 0
C779 c_0_14/Q rc1/WL 0
C780 c_5_9/Q rc6/WL 0
C781 c_8_0/QB rc7/WL 0
C782 bl3 rc10/WL 0.00159f
C783 c_14_11/QB bl11 0
C784 rc11/WL c_10_6/QB 0
C785 blb14 c_13_15/Q 0.00303f
C786 bl8 c_13_7/Q 0
C787 c_8_10/Q rc9/WL 0
C788 rc6/WL c_5_5/Q 0
C789 c_9_1/QB rc10/WL 0
C790 c_10_5/QB c_10_4/Q 0.00377f
C791 c_10_5/Q c_10_4/QB 0.01135f
C792 VDD c_0_11/QB 0.00969f
C793 c_9_0/Q rh2 0
C794 c_13_4/QB bl5 0.00303f
C795 c_11_0/Q rc11/WL 0.01507f
C796 c_2_14/QB c_2_13/QB 0
C797 c_7_14/QB blb13 0
C798 rc12/WL VDD 0.05907f
C799 c_7_11/QB c_8_11/Q 0
C800 c_1_11/Q c_0_11/Q 0.00654f
C801 rc5/WL c_4_7/Q 0
C802 cl3 blb7 0
C803 c_0_9/Q ch3 0
C804 c_4_3/Q c_4_2/Q 0
C805 rc14/WL blb7 0.00159f
C806 c_1_3/QB rc1/WL 0
C807 rc2/WL c_3_2/QB 0
C808 bl12 rc1/WL 0.00159f
C809 c_6_4/Q c_7_4/Q 0.00654f
C810 rc2/WL c_1_1/QB 0
C811 c_11_0/QB VDD 0.01264f
C812 c_11_13/QB rc10/WL 0
C813 bl2 rc1/WL 0.00175f
C814 c_13_11/QB c_13_12/Q 0.01135f
C815 bl11 rc1/WL 0.00159f
C816 c_15_15/Q c_15_14/QB 0.01135f
C817 bl3 rc6/WL 0.00159f
C818 bl12 rc10/WL 0.00159f
C819 c_1_12/QB rc1/WL 0
C820 c_7_15/QB c_6_15/Q 0
C821 c_13_6/QB c_14_6/QB 0.0025f
C822 bl2 rc10/WL 0.00175f
C823 c_2_5/Q blb4 0.00303f
C824 c_3_5/QB rc3/WL 0
C825 rc6/WL c_5_0/QB 0
C826 c_4_9/Q rc5/WL 0
C827 clkb rc10/s/n3/a_302_47# 0.00768f
C828 c_9_10/QB c_9_9/QB 0
C829 bl11 rc10/WL 0.00159f
C830 c_11_6/QB rc10/WL 0
C831 blb9 rc9/WL 0.00159f
C832 rc11/WL blb5 0.00159f
C833 c_10_4/Q bl5 0
C834 c_0_12/QB dl 0.0049f
C835 c_6_4/QB VDD 0.00969f
C836 rl0 rc3/WL 0
C837 VDD rc13/WL 0.05907f
C838 c_10_5/QB c_10_6/Q 0.01135f
C839 c_10_5/Q c_10_6/QB 0.00377f
C840 csel4 rc1/WL 0
C841 VDD c_4_8/QB 0.00969f
C842 rc6/WL c_5_3/QB 0
C843 cs3/n/Y cl0 0
C844 blb1 rc1/WL 0.00178f
C845 ch0 bl5 0.00109f
C846 clkb rc11/s/wd/A 0.09749f
C847 bl12 rc6/WL 0.00159f
C848 blb10 c_15_10/QB 0
C849 rc13/WL c_14_7/QB 0
C850 bl0 rc5/s/n3/a_162_47# 0
C851 rc5/WL c_4_11/QB 0
C852 c_6_5/Q bl6 0
C853 blb1 rc10/WL 0.00178f
C854 c_0_9/Q c_0_10/Q 0
C855 bl2 rc6/WL 0.00175f
C856 bl11 rc6/WL 0.00159f
C857 c_0_13/QB dlb 0.004f
C858 bl8 blb7 2.86379f
C859 rc5/s/wd/A c_5_1/Q 0
C860 c_14_1/Q c_15_1/Q 0.00654f
C861 c_2_14/Q bl15 0
C862 bl11 c_13_10/Q 0
C863 c_10_8/QB c_9_8/QB 0.0025f
C864 ch1 c_0_1/Q 0
C865 ch0 c_0_12/Q 0
C866 clkb rc7/s/n3/a_302_47# 0.00768f
C867 dl c_0_8/QB 0.0049f
C868 c_4_2/Q rc3/WL 0
C869 rc2/WL c_1_0/QB 0
C870 c_13_3/QB c_13_4/Q 0.01135f
C871 c_10_14/QB c_10_13/Q 0.00377f
C872 cs12/n/Y csel11 0.00301f
C873 rc0/WL dl 0.08904f
C874 rc2/WL c_1_5/Q 0
C875 rc5/s/wd/A rl2 0.00155f
C876 VDD c_9_8/QB 0.00969f
C877 c_2_0/QB bl1 0.00303f
C878 c_6_11/Q c_5_11/Q 0.00634f
C879 rc8/WL blb12 0.00159f
C880 bl13 c_14_12/QB 0.00303f
C881 bl11 c_12_10/QB 0.00303f
C882 c_8_13/Q blb12 0.00303f
C883 bl8 c_6_7/Q 0
C884 c_14_2/QB rc13/WL 0
C885 c_1_12/QB c_1_13/Q 0.01135f
C886 c_1_12/Q c_1_13/QB 0.00377f
C887 c_15_2/QB c_15_1/Q 0.00377f
C888 c_14_0/Q rc14/WL 0.01507f
C889 c_11_14/Q c_10_14/QB 0
C890 c_11_2/Q c_10_2/Q 0.00654f
C891 c_5_13/QB VDD 0.00969f
C892 c_7_3/QB VDD 0.00969f
C893 c_6_10/QB rc5/WL 0
C894 bl10 ch0 0.00109f
C895 blb1 rc6/WL 0.00178f
C896 ch3 c_0_4/Q 0
C897 c_4_3/Q rc5/WL 0
C898 c_6_10/QB blb9 0
C899 bl2 c_11_1/Q 0
C900 rc13/s/wd/A blb0 0
C901 c_1_5/Q c_0_5/QB 0
C902 c_1_5/QB c_0_5/Q 0
C903 c_12_13/QB c_13_13/Q 0
C904 c_12_13/Q c_13_13/QB 0
C905 c_9_7/QB c_9_8/QB 0
C906 cl1 csel2 0.06555f
C907 ch0 c_0_8/Q 0
C908 VDD c_15_12/QB 0.01187f
C909 blb12 c_10_13/QB 0
C910 VDD c_11_12/QB 0.00969f
C911 VDD csel2 0.02187f
C912 blb9 dlb 0.0282f
C913 pcb rc1/s/wd/A 0
C914 blb11 c_4_12/Q 0.00303f
C915 c_5_10/QB rc5/WL 0
C916 rc11/WL c_11_5/Q 0
C917 ch3 cs12/n/Y 0.09775f
C918 c_4_8/QB c_3_8/Q 0
C919 rl0 cl0 0.02791f
C920 rc0/WL blb15 0.00219f
C921 c_5_10/QB blb9 0
C922 blb6 rc14/WL 0.00159f
C923 cl3 blb6 0
C924 c_0_15/QB dl 0.0049f
C925 rh0 bl0 0.01321f
C926 bl6 c_4_5/QB 0.00303f
C927 c_12_11/QB blb10 0
C928 cs14/n/Y dl 0
C929 ch1 rl2 0.02782f
C930 blb5 c_4_6/Q 0.00303f
C931 rc14/WL c_15_9/QB 0
C932 rc6/s/n3/a_302_47# rh1 0.0045f
C933 VDD c_11_5/QB 0.00969f
C934 c_10_4/QB rc9/WL 0
C935 cs4/n/Y cs3/n/Y 0.02812f
C936 csel14 csel13 0.03263f
C937 rc5/WL c_6_3/Q 0
C938 c_7_6/QB bl7 0.00303f
C939 c_8_1/QB c_8_2/QB 0
C940 c_3_11/QB c_4_11/QB 0.0025f
C941 rc14/WL c_13_13/QB 0
C942 rc8/WL rl1 0
C943 c_7_11/Q rc8/WL 0
C944 c_15_0/QB rc15/s/wd/A 0.00246f
C945 cs10/n/Y dlb 0
C946 blb2 rc0/WL 0.00289f
C947 c_13_3/Q bl4 0
C948 c_14_14/Q c_15_14/QB 0
C949 rc2/WL rc1/WL 0.88789f
C950 csel14 bl15 0.00103f
C951 VDD c_0_6/QB 0.00969f
C952 c_2_5/QB c_1_5/QB 0.0025f
C953 c_2_11/QB bl12 0.00303f
C954 c_3_13/Q c_3_14/QB 0.00377f
C955 c_4_15/Q VDD 0.00565f
C956 pcb c_15_8/Q 0.00484f
C957 c_15_0/QB rc14/WL 0
C958 csel5 blb4 0.00103f
C959 bl8 c_3_7/QB 0.00303f
C960 blb11 rc15/WL 0.00298f
C961 bl11 c_14_10/QB 0.00303f
C962 bl3 c_15_2/Q 0
C963 VDD rc4/s/n3/a_302_47# -0
C964 c_12_2/Q c_11_2/QB 0
C965 c_4_4/QB VDD 0.00969f
C966 bl1 c_15_1/Q 0
C967 c_8_11/QB c_9_11/QB 0.01281f
C968 blb9 rc3/WL 0.00159f
C969 c_10_5/Q c_11_5/Q 0.00654f
C970 c_9_15/QB c_8_15/QB 0.01281f
C971 ch1 csel0 0.03082f
C972 c_0_2/QB ch3 0
C973 rc11/WL c_12_4/Q 0
C974 c_0_5/QB rc1/WL 0
C975 c_8_9/Q c_8_8/Q 0
C976 c_10_6/QB rc9/WL 0
C977 blb2 c_10_3/Q 0.00303f
C978 c_14_9/Q rc14/WL 0
C979 blb2 c_12_3/Q 0.00303f
C980 c_8_9/Q c_9_9/QB 0
C981 blb3 ch3 0
C982 VDD rc1/s/n3/a_162_47# 0
C983 rc5/WL bl4 0.00159f
C984 blb8 c_6_9/QB 0
C985 VDD c_12_4/QB 0.00969f
C986 c_5_14/Q c_5_13/Q 0
C987 VDD c_6_13/Q 0.00756f
C988 rc12/WL c_12_1/QB 0
C989 c_11_4/Q rc11/WL 0
C990 cl1 blb8 0
C991 c_9_10/QB rc8/WL 0
C992 VDD blb8 -0.00917f
C993 c_12_3/QB bl4 0.00303f
C994 rc9/s/n3/a_302_47# VDD -0
C995 rc4/WL c_3_2/Q 0
C996 c_5_12/Q c_5_11/QB 0.01135f
C997 cl1 csel15 0.02913f
C998 VDD csel15 0.0182f
C999 bl2 c_15_2/Q 0
C1000 c_9_12/Q c_8_12/QB 0
C1001 c_9_12/QB c_8_12/Q 0
C1002 rc5/WL c_5_15/Q 0
C1003 c_11_4/QB VDD 0.00969f
C1004 clkb rc0/WL 0.00509f
C1005 c_0_13/QB cl0 0
C1006 bl8 c_6_7/QB 0.00303f
C1007 blb12 dl 0.02104f
C1008 c_12_7/QB c_11_7/Q 0
C1009 c_12_7/Q c_11_7/QB 0
C1010 rc2/WL c_1_13/Q 0
C1011 c_5_4/QB bl5 0.00303f
C1012 rc13/WL c_14_12/QB 0
C1013 ch1 csel14 0.03695f
C1014 c_7_9/Q rc7/WL 0
C1015 rc14/WL c_15_5/Q 0
C1016 c_4_14/Q rc3/WL 0
C1017 pcb rc11/s/wd/A 0
C1018 c_0_14/QB c_0_15/Q 0.01135f
C1019 cs8/n/a_162_47# cs9/n/Y 0
C1020 cs7/n/Y dl 0
C1021 ch0 dl 0.05543f
C1022 rc5/s/wd/A rh1 0.03734f
C1023 c_1_10/Q VDD 0.00756f
C1024 c_4_5/Q c_4_4/Q 0
C1025 blb5 rc9/WL 0.00159f
C1026 rc13/WL c_12_1/QB 0
C1027 rc2/WL c_1_7/Q 0
C1028 c_4_6/QB bl7 0.00303f
C1029 c_9_6/QB c_10_6/QB 0.0025f
C1030 rc12/s/n3/a_162_47# rh2 0
C1031 c_6_10/QB rc7/WL 0
C1032 blb1 c_15_2/Q 0.00303f
C1033 c_0_0/Q c_1_0/Q 0.00654f
C1034 c_8_13/QB VDD 0.00969f
C1035 c_8_4/Q c_8_3/Q 0
C1036 c_13_9/QB c_14_9/QB 0.0025f
C1037 c_3_11/QB rc3/WL 0
C1038 rc15/WL c_14_3/Q 0
C1039 c_15_11/QB blb11 0
C1040 clkb rc9/s/wd/A 0.09749f
C1041 c_0_11/Q dlb 0
C1042 rc2/s/n3/a_302_47# rl2 0.00707f
C1043 bl1 c_5_0/Q 0
C1044 rc13/s/wd/A bl0 0.00934f
C1045 bl15 c_3_14/Q 0
C1046 c_0_2/QB c_1_2/Q 0
C1047 c_0_2/Q c_1_2/QB 0
C1048 blb9 cl0 0
C1049 blb10 bl11 2.86379f
C1050 bl10 c_1_9/QB 0.00303f
C1051 c_5_2/Q c_5_3/Q 0
C1052 rc12/WL blb0 0.00236f
C1053 ch3 csel11 0.02926f
C1054 c_9_8/Q rc9/WL 0
C1055 c_4_1/Q c_5_1/QB 0
C1056 VDD c_5_12/QB 0.00969f
C1057 c_0_9/QB rc1/WL 0
C1058 c_7_14/QB VDD 0.00969f
C1059 c_0_14/Q bl15 0
C1060 c_3_13/QB c_3_14/QB 0
C1061 rh0 rc4/s/n3/a_162_47# 0
C1062 rc14/WL c_14_7/Q 0
C1063 c_13_8/Q c_13_7/Q 0
C1064 c_6_1/Q rc6/s/wd/A 0
C1065 c_12_3/QB c_11_3/QB 0.0025f
C1066 rc0/WL c_0_3/QB 0
C1067 rc12/WL c_13_4/Q 0
C1068 rc0/WL c_1_9/Q 0
C1069 ch0 blb15 0.00109f
C1070 rc5/s/wd/A c_5_0/QB 0.00246f
C1071 c_7_8/QB rc7/WL 0
C1072 c_10_10/QB c_10_11/QB 0
C1073 dl rl1 0.03898f
C1074 bl14 c_6_13/QB 0.00303f
C1075 rc0/WL cl2 0.00174f
C1076 bl1 rc6/s/wd/A 0
C1077 ch1 rh1 0.02782f
C1078 c_2_9/Q bl10 0
C1079 rc8/WL bl7 0.00159f
C1080 VDD c_15_1/QB 0.01187f
C1081 blb14 c_2_15/QB 0
C1082 c_6_3/Q rc7/WL 0
C1083 c_15_12/QB c_14_12/QB 0.01281f
C1084 c_9_6/QB blb5 0
C1085 blb6 c_10_7/QB 0
C1086 c_8_13/QB c_8_14/QB 0
C1087 c_8_0/QB c_8_1/Q 0.01135f
C1088 c_8_0/Q c_8_1/QB 0.00377f
C1089 rc11/WL c_10_0/Q 0
C1090 rh3 rc0/s/wd/A 0
C1091 cl0 cs10/n/Y 0
C1092 c_8_1/QB VDD 0.00969f
C1093 c_11_12/Q c_10_12/Q 0.00654f
C1094 cs6/n/Y csel5 0.00301f
C1095 c_2_11/QB rc2/WL 0
C1096 c_14_2/Q rc14/WL 0
C1097 c_12_13/Q bl14 0
C1098 rc13/WL blb0 0.00236f
C1099 VDD c_1_1/Q 0.00756f
C1100 blb2 ch0 0.00109f
C1101 bl1 c_13_0/Q 0
C1102 blb14 c_1_15/Q 0.00303f
C1103 rc5/WL blb13 0.00159f
C1104 c_13_5/Q blb4 0.00303f
C1105 rc7/WL c_7_4/QB 0
C1106 c_14_11/QB rc15/WL 0
C1107 c_11_13/QB c_11_14/QB 0
C1108 c_10_0/QB VDD 0.01264f
C1109 c_7_14/QB c_8_14/QB 0.0025f
C1110 c_10_5/QB bl6 0.00303f
C1111 blb5 dlb 0.0282f
C1112 bl13 c_3_12/Q 0
C1113 rc13/WL c_13_4/Q 0
C1114 blb5 c_3_6/Q 0.00303f
C1115 rc6/WL c_6_6/QB 0
C1116 c_15_11/Q c_15_10/Q 0
C1117 rl0 rc2/s/wd/A 0.00281f
C1118 VDD c_15_8/QB 0.01187f
C1119 rc14/WL c_14_13/QB 0
C1120 ch1 bl3 0
C1121 clkb c_12_0/QB 0
C1122 c_10_14/Q c_10_13/Q 0
C1123 c_8_7/Q rc7/WL 0
C1124 cs14/n/Y cl2 0.04836f
C1125 c_7_14/QB c_7_15/Q 0.01135f
C1126 bl8 c_14_7/Q 0
C1127 csel6 c_0_6/QB 0
C1128 c_6_4/Q c_6_3/Q 0
C1129 c_14_4/Q bl5 0
C1130 ch1 c_0_14/Q 0
C1131 cl3 bl14 0
C1132 c_4_6/QB c_4_5/QB 0
C1133 rc14/WL bl14 0.00159f
C1134 csel4 c_0_4/QB 0
C1135 rc7/WL bl4 0.00159f
C1136 blb3 c_15_3/QB 0
C1137 c_12_11/Q c_12_12/Q 0
C1138 c_10_14/Q c_11_14/Q 0.00654f
C1139 rc6/WL c_7_0/Q 0
C1140 c_6_8/QB c_5_8/Q 0
C1141 c_6_8/Q c_5_8/QB 0
C1142 c_7_15/QB blb14 0
C1143 rl3 dl 0.03898f
C1144 blb7 c_13_8/Q 0.00303f
C1145 rc5/s/wd/A blb1 0
C1146 c_14_9/Q c_14_10/Q 0
C1147 c_10_10/QB c_9_10/Q 0
C1148 bl10 c_8_9/Q 0
C1149 c_6_4/Q c_7_4/QB 0
C1150 c_1_8/QB c_0_8/QB 0.01281f
C1151 c_6_9/Q c_7_9/QB 0
C1152 c_8_15/QB blb14 0
C1153 rc8/WL c_8_9/Q 0
C1154 c_7_7/Q bl8 0
C1155 rc0/WL c_1_8/QB 0
C1156 ch1 bl12 0
C1157 c_15_3/Q rc14/WL 0
C1158 VDD c_11_11/Q 0.00756f
C1159 ch3 c_0_10/Q 0
C1160 bl2 ch1 0
C1161 c_4_14/Q blb13 0.00303f
C1162 clkb ch0 0.03889f
C1163 ch1 bl11 0
C1164 c_14_8/Q pcb 0.00166f
C1165 ch2 dlb 0.04721f
C1166 VDD c_12_0/Q 0.01304f
C1167 cs3/n/Y cl1 0
C1168 rc11/s/wd/A rc11/WL -0.00118f
C1169 cs3/n/Y VDD 0.01448f
C1170 blb5 rc3/WL 0.00159f
C1171 VDD c_5_8/QB 0.00969f
C1172 ch1 cs7/n/a_162_47# 0.00134f
C1173 c_5_7/Q c_5_8/Q 0
C1174 bl1 rc10/s/wd/A 0
C1175 bl8 rc4/WL 0.00159f
C1176 c_0_13/Q c_0_14/QB 0.00377f
C1177 rc7/s/n3/a_162_47# rh2 0
C1178 rl3 rc15/s/n3/a_302_47# 0.00707f
C1179 csel9 dlb 0.10216f
C1180 c_11_3/QB c_11_2/Q 0.00377f
C1181 csel4 ch1 0.29458f
C1182 c_2_12/Q c_1_12/QB 0
C1183 c_1_6/Q dl 0.00273f
C1184 c_1_6/QB dlb 0
C1185 blb10 rc2/WL 0.00159f
C1186 clkb rc3/s/wd/A 0.09749f
C1187 dl c_1_9/QB 0.0021f
C1188 c_5_7/QB c_4_7/Q 0
C1189 c_5_7/Q c_5_6/QB 0.01135f
C1190 c_9_2/QB c_10_2/Q 0
C1191 c_15_11/QB c_14_11/QB 0.01281f
C1192 ch1 blb1 0
C1193 cl0 c_0_11/Q 0
C1194 rc8/WL bl6 0.00159f
C1195 ch2 csel7 0.02936f
C1196 rc12/WL c_13_7/Q 0
C1197 rc12/WL bl0 0.06726f
C1198 c_10_8/Q c_10_7/QB 0.01135f
C1199 c_8_9/QB rc9/WL 0
C1200 rh0 rc4/s/wd/A 0.00132f
C1201 clkb rl1 1.05001f
C1202 c_1_3/QB c_1_4/QB 0
C1203 bl7 dl 0.04919f
C1204 bl1 c_1_0/Q 0
C1205 c_12_8/QB c_12_9/Q 0.01135f
C1206 c_0_12/Q csel12 0.00119f
C1207 rc2/WL csel13 0
C1208 cl2 blb12 0
C1209 pcb rc9/s/wd/A 0
C1210 c_14_11/Q c_14_12/Q 0
C1211 rc12/WL c_11_3/Q 0
C1212 c_10_7/Q rc10/WL 0
C1213 bl7 c_3_6/QB 0.00303f
C1214 c_12_5/Q c_11_5/Q 0.00634f
C1215 c_0_1/Q csel1 0.00119f
C1216 c_7_7/QB rc7/WL 0
C1217 c_14_6/Q rc14/WL 0
C1218 c_2_1/QB c_1_1/Q 0
C1219 ch0 c_0_3/QB 0
C1220 c_4_4/Q c_4_3/Q 0
C1221 cl2 cs7/n/Y 0.04756f
C1222 c_5_0/Q c_5_1/QB 0.00377f
C1223 rc14/WL c_14_12/Q 0
C1224 c_7_15/QB c_8_15/Q 0
C1225 VDD c_3_5/QB 0.00969f
C1226 ch0 cl2 0.34504f
C1227 rc2/WL bl15 0.00159f
C1228 rl0 c_8_0/Q 0
C1229 c_12_7/QB c_12_7/Q 0
C1230 rl0 cl1 0.02787f
C1231 c_6_11/QB VDD 0.00969f
C1232 rl0 VDD 0.53106f
C1233 bl11 c_11_10/Q 0
C1234 c_0_5/Q csel5 0.00119f
C1235 rc13/WL c_13_7/Q 0
C1236 csel4 c_1_4/QB 0
C1237 c_14_9/QB c_14_10/QB 0
C1238 rc13/WL bl0 0.06726f
C1239 blb13 rc7/WL 0.00159f
C1240 c_9_2/QB rc9/WL 0
C1241 ch2 bl4 0
C1242 c_7_9/Q c_8_9/QB 0
C1243 blb5 cl0 0
C1244 c_2_0/QB c_1_0/QB 0.0025f
C1245 c_3_3/Q rc2/WL 0
C1246 blb13 c_6_14/QB 0
C1247 c_13_4/Q c_12_4/QB 0
C1248 bl1 c_0_0/QB 0.00303f
C1249 rh3 rc12/s/wd/A 0.03687f
C1250 rc0/s/wd/A c_0_0/QB 0.00246f
C1251 c_5_6/QB c_4_6/Q 0
C1252 rc15/s/wd/A rl2 0.00262f
C1253 c_0_4/QB c_0_5/QB 0
C1254 VDD c_4_2/Q 0.00756f
C1255 c_7_6/Q bl7 0
C1256 c_0_1/QB c_1_1/Q 0
C1257 c_8_1/Q rc9/WL 0
C1258 cl2 rl1 0.02782f
C1259 c_0_7/Q c_0_6/Q 0
C1260 c_2_9/QB rc3/WL 0
C1261 clkb rl3 1.01912f
C1262 c_12_5/Q c_12_4/Q 0
C1263 rc12/WL blb7 0.00159f
C1264 rc8/WL c_8_8/Q 0
C1265 c_0_7/Q blb6 0.00303f
C1266 rc15/WL c_14_10/QB 0
C1267 bl10 c_9_9/QB 0.00303f
C1268 rc8/WL c_9_9/QB 0
C1269 rc14/WL rl2 0.00286f
C1270 cl3 rl2 0.04111f
C1271 c_10_0/Q rc9/WL 0
C1272 rc11/WL c_12_9/QB 0
C1273 c_4_4/Q rc3/WL 0
C1274 c_4_5/Q c_3_5/Q 0.00634f
C1275 c_6_9/Q rc6/WL 0
C1276 rc15/WL c_15_13/QB 0
C1277 c_2_7/QB rc3/WL 0
C1278 c_15_13/QB c_14_13/Q 0
C1279 c_13_2/QB c_13_1/QB 0
C1280 c_10_1/QB c_10_0/QB 0
C1281 c_4_8/Q c_5_8/Q 0.00654f
C1282 c_1_2/QB c_1_1/QB 0
C1283 c_9_13/QB rc9/WL 0
C1284 blb2 c_2_3/QB 0
C1285 cs10/n/Y cs9/n/a_162_47# 0
C1286 rc8/WL c_7_6/QB 0
C1287 ch2 cl0 0.39912f
C1288 c_2_14/QB c_3_14/Q 0
C1289 clkb c_10_1/Q 0
C1290 c_2_12/Q rc2/WL 0
C1291 blb7 c_4_8/QB 0
C1292 pcb blb12 0.07118f
C1293 rc13/WL blb7 0.00159f
C1294 c_8_0/Q rc8/s/wd/A 0
C1295 c_15_10/QB rc14/WL 0
C1296 c_2_4/Q c_1_4/Q 0.00634f
C1297 ch1 c_0_5/QB 0
C1298 csel1 csel0 0.01915f
C1299 rc8/s/wd/A VDD -0.00408f
C1300 rc15/WL c_15_2/Q 0
C1301 c_13_3/Q VDD 0.00756f
C1302 cl3 csel0 0.04045f
C1303 bl6 dl 0.04919f
C1304 csel9 cl0 0.07259f
C1305 c_0_13/QB VDD 0.00969f
C1306 c_14_8/QB c_13_8/QB 0.0025f
C1307 pcb ch0 0.02782f
C1308 csel8 blb8 0.00807f
C1309 c_8_10/Q VDD 0.00756f
C1310 c_8_8/QB rc9/WL 0
C1311 c_2_0/QB rc1/WL 0
C1312 rc5/WL c_6_8/Q 0
C1313 cs1/n/Y ch3 0
C1314 pcb c_15_13/Q 0.00484f
C1315 c_9_7/Q c_10_7/Q 0.00634f
C1316 ch0 cs9/n/Y 0
C1317 rc0/s/n3/a_302_47# rl0 0.00707f
C1318 blb0 c_15_1/QB 0
C1319 VDD c_13_12/QB 0.00969f
C1320 rc4/WL c_4_2/QB 0
C1321 clkb c_6_0/QB 0
C1322 rc13/s/n3/a_162_47# VDD 0
C1323 rc11/WL c_11_7/QB 0
C1324 rl3 cl2 0.02782f
C1325 c_1_5/Q blb4 0.00303f
C1326 rc0/WL c_1_11/Q 0
C1327 rl1 rc14/s/wd/A 0.00205f
C1328 rc2/WL c_1_4/QB 0
C1329 c_8_1/QB blb0 0
C1330 c_8_2/Q rc9/WL 0
C1331 blb14 c_11_15/QB 0
C1332 bl3 c_3_2/Q 0
C1333 c_8_2/QB rc7/WL 0
C1334 c_15_14/Q c_15_13/QB 0.01135f
C1335 bl6 c_12_5/QB 0.00303f
C1336 c_10_3/Q rc11/WL 0
C1337 blb7 c_9_8/QB 0
C1338 c_1_1/Q blb0 0.00303f
C1339 pcb rc3/s/wd/A 0
C1340 c_12_0/Q c_12_1/QB 0.00377f
C1341 rc5/WL c_6_9/QB 0
C1342 c_12_3/Q rc11/WL 0
C1343 ch2 c_0_3/Q 0
C1344 bl11 c_6_10/Q 0
C1345 pcb c_15_6/Q 0.00484f
C1346 c_12_8/Q VDD 0.00756f
C1347 ch2 blb13 0
C1348 c_3_2/Q c_2_2/QB 0
C1349 c_3_2/QB c_2_2/Q 0
C1350 rc5/WL VDD 0.05907f
C1351 blb11 c_1_12/Q 0.00303f
C1352 blb9 cl1 0.0013f
C1353 csel12 dl 0.08427f
C1354 cl3 csel14 0.03848f
C1355 rc5/WL c_5_5/QB 0
C1356 blb9 VDD -0.00917f
C1357 c_2_6/Q rc1/WL 0
C1358 bl0 rc4/s/n3/a_302_47# 0.00159f
C1359 rc15/WL blb10 0.00298f
C1360 c_12_3/QB VDD 0.00969f
C1361 c_3_12/QB c_2_12/QB 0.01281f
C1362 c_15_7/Q rc14/WL 0
C1363 pcb rl1 0.00106f
C1364 c_4_14/QB c_4_13/QB 0
C1365 blb11 c_8_12/Q 0.00303f
C1366 c_3_15/QB blb14 0
C1367 c_1_13/QB c_1_14/QB 0
C1368 c_5_9/QB blb8 0
C1369 c_3_1/QB rc3/s/wd/A 0
C1370 bl0 rc1/s/n3/a_162_47# 0
C1371 c_3_12/QB c_3_11/Q 0.00377f
C1372 c_9_13/Q c_10_13/Q 0.00634f
C1373 c_1_9/QB c_1_9/Q -0
C1374 rc12/WL blb6 0.00159f
C1375 c_8_5/Q rc7/WL 0
C1376 rh3 rc15/s/n3/a_162_47# 0.01096f
C1377 blb5 c_2_6/QB 0
C1378 cs4/n/Y ch2 0
C1379 c_7_1/Q rc8/WL 0
C1380 c_14_0/Q rc13/WL 0
C1381 c_7_11/Q c_7_12/Q 0
C1382 rc9/s/n3/a_302_47# bl0 0.00159f
C1383 rc8/WL bl5 0.00159f
C1384 rc14/WL c_13_15/QB 0
C1385 c_14_4/QB rc14/WL 0
C1386 cl1 cs10/n/Y 0.04734f
C1387 rc5/s/n3/a_162_47# rl2 0.0024f
C1388 c_9_12/QB c_9_11/Q 0.00377f
C1389 VDD cs10/n/Y 0.01448f
C1390 ch1 c_0_9/QB 0
C1391 rc12/WL c_13_13/QB 0
C1392 cl2 bl7 0
C1393 c_2_9/Q c_1_9/Q 0.00634f
C1394 c_4_4/QB c_3_4/Q 0
C1395 rc15/WL bl15 0.00298f
C1396 rl3 rc14/s/wd/A 0.00228f
C1397 cs0/n/Y csel0 0.07585f
C1398 rc1/WL blb4 0.00159f
C1399 c_6_3/QB c_5_3/Q 0
C1400 c_0_10/QB rc1/WL 0
C1401 c_15_3/QB c_14_3/QB 0.01281f
C1402 rc15/s/wd/A rh1 0
C1403 c_2_10/QB c_1_10/Q 0
C1404 c_4_14/Q VDD 0.00756f
C1405 csel3 dl 0.08427f
C1406 bl10 c_12_9/Q 0
C1407 c_11_4/QB c_11_3/Q 0.00377f
C1408 c_11_4/Q c_11_3/QB 0.01135f
C1409 rc10/WL blb4 0.00159f
C1410 blb1 c_3_2/Q 0.00303f
C1411 c_7_10/QB c_7_9/QB 0
C1412 rc5/WL c_6_2/QB 0
C1413 c_12_9/QB c_13_9/Q 0
C1414 blb6 rc13/WL 0.00159f
C1415 c_10_2/QB rc11/WL 0
C1416 cl3 rh1 0.04111f
C1417 c_2_13/Q c_2_12/QB 0.01135f
C1418 c_7_8/QB c_8_8/QB 0.0025f
C1419 c_5_4/Q c_5_3/Q 0
C1420 c_9_3/Q c_8_3/Q 0.00654f
C1421 bl8 c_15_7/Q 0
C1422 rc11/WL c_12_0/QB 0
C1423 c_4_6/QB c_4_7/QB 0
C1424 c_9_4/Q c_9_3/QB 0.01135f
C1425 c_1_15/Q c_1_14/Q 0
C1426 bl14 c_10_13/Q 0
C1427 c_1_2/QB rc1/WL 0
C1428 c_4_12/QB bl13 0.00303f
C1429 ch3 blb14 0
C1430 c_15_7/QB c_15_8/QB 0
C1431 rl3 pcb 0.00943f
C1432 c_3_11/QB VDD 0.00969f
C1433 bl10 rc8/WL 0.00159f
C1434 rc13/WL c_13_13/QB 0
C1435 rc8/WL c_8_13/Q 0
C1436 c_0_0/Q ch3 0
C1437 c_7_13/Q c_7_12/QB 0.01135f
C1438 c_10_4/Q rc11/WL 0
C1439 c_8_4/QB rc7/WL 0
C1440 rc14/s/n3/a_162_47# rl1 0.0024f
C1441 rc11/WL blb12 0.00159f
C1442 c_10_10/QB rc11/WL 0
C1443 rc6/WL blb4 0.00159f
C1444 c_15_11/QB blb10 0
C1445 bl1 c_4_0/Q 0
C1446 c_1_11/QB dl 0.0021f
C1447 c_12_13/QB c_11_13/Q 0
C1448 c_12_13/Q c_11_13/QB 0
C1449 c_1_8/QB c_1_9/QB 0
C1450 rh0 rl2 0.46096f
C1451 c_6_15/Q blb14 0.00303f
C1452 bl11 c_8_10/QB 0.00303f
C1453 c_11_1/QB rc10/WL 0
C1454 cl3 bl3 0
C1455 rc6/WL c_5_13/Q 0
C1456 c_12_11/QB c_12_10/Q 0.00377f
C1457 c_12_11/Q c_12_10/QB 0.01135f
C1458 c_13_6/Q bl7 0
C1459 bl3 rc14/WL 0.00159f
C1460 VDD c_12_2/QB 0.00969f
C1461 c_10_4/QB VDD 0.00969f
C1462 c_1_6/QB c_2_6/QB 0.0025f
C1463 c_6_8/Q rc7/WL 0
C1464 bl15 c_15_14/Q 0
C1465 c_6_10/QB c_6_11/Q 0.01135f
C1466 c_15_10/QB c_14_10/Q 0
C1467 c_12_7/Q c_12_8/QB 0.00377f
C1468 rc11/WL c_11_12/Q 0
C1469 c_8_7/Q c_8_8/QB 0.00377f
C1470 c_8_7/QB c_8_8/Q 0.01135f
C1471 blb3 c_9_4/Q 0.00303f
C1472 VDD c_11_2/Q 0.00756f
C1473 c_2_14/QB rc2/WL 0
C1474 c_12_11/QB c_11_11/QB 0.0025f
C1475 c_4_14/QB rc4/WL 0
C1476 c_14_9/Q rc13/WL 0
C1477 c_3_5/Q c_3_6/Q 0
C1478 c_15_6/QB c_15_5/QB 0
C1479 c_10_3/Q c_10_2/Q 0
C1480 csel3 blb2 0.00103f
C1481 c_1_10/QB bl11 0.00303f
C1482 rl0 blb0 0
C1483 bl13 rc4/WL 0.00159f
C1484 c_14_11/Q bl12 0
C1485 bl13 c_14_13/QB 0
C1486 ch1 cs5/n/Y 0.09848f
C1487 c_4_9/QB bl10 0.00303f
C1488 rc7/WL c_6_9/QB 0
C1489 rc11/WL c_10_6/Q 0
C1490 c_2_2/Q rc1/WL 0
C1491 c_8_0/Q rc7/WL 0
C1492 cl3 bl12 0
C1493 bl12 rc14/WL 0.00159f
C1494 bl2 csel1 0.00103f
C1495 c_10_5/Q c_10_4/Q 0
C1496 VDD c_0_11/Q 0.00756f
C1497 VDD rc7/WL 0.05907f
C1498 c_9_1/Q rc10/WL 0
C1499 pcb bl7 0.07118f
C1500 bl2 cl3 0
C1501 bl2 rc14/WL 0.00175f
C1502 cl3 bl11 0
C1503 c_14_12/QB c_13_12/QB 0.0025f
C1504 bl11 rc14/WL 0.00159f
C1505 c_7_14/Q blb13 0.00303f
C1506 VDD c_6_14/QB 0.00969f
C1507 c_1_1/QB c_1_0/Q 0.00377f
C1508 c_2_6/QB c_2_7/QB 0
C1509 c_5_14/QB c_5_13/Q 0.00377f
C1510 VDD c_10_6/QB 0.00969f
C1511 rc11/WL rl1 0
C1512 c_7_11/Q c_8_11/Q 0.00634f
C1513 c_15_6/QB VDD 0.01187f
C1514 ch1 cs8/n/Y 0.00137f
C1515 ch2 cs9/n/a_162_47# 0.00134f
C1516 cl3 cs7/n/a_162_47# 0.0022f
C1517 cl2 bl6 0
C1518 rc14/s/n3/a_302_47# rh3 0.0045f
C1519 rc2/WL c_3_2/Q 0
C1520 c_1_3/Q rc1/WL 0
C1521 dl bl5 0.04919f
C1522 blb1 rc15/s/wd/A 0
C1523 c_11_0/Q VDD 0.01304f
C1524 c_11_13/Q rc10/WL 0
C1525 c_4_1/QB c_4_2/QB 0
C1526 c_13_11/Q c_13_12/Q 0
C1527 csel4 cl3 0.06159f
C1528 blb4 c_7_5/QB 0
C1529 c_7_11/QB VDD 0.00969f
C1530 blb5 c_15_5/QB 0
C1531 csel1 blb1 0.00807f
C1532 c_1_12/Q rc1/WL 0
C1533 c_4_6/QB c_3_6/QB 0.0025f
C1534 c_13_6/Q c_14_6/QB 0
C1535 rc6/WL c_5_0/Q 0
C1536 blb1 rc14/WL 0.00178f
C1537 c_9_10/Q c_9_9/QB 0.01135f
C1538 cl3 blb1 0
C1539 c_0_13/Q bl14 0
C1540 c_3_5/Q rc3/WL 0
C1541 c_10_3/Q rc9/WL 0
C1542 c_11_6/Q rc10/WL 0
C1543 c_8_14/QB rc7/WL 0
C1544 c_0_12/QB dlb 0.004f
C1545 c_0_12/Q dl 0.00931f
C1546 rh1 rc5/s/n3/a_162_47# 0.01115f
C1547 c_6_4/Q VDD 0.00756f
C1548 rc9/s/wd/A rc9/WL -0.00118f
C1549 c_12_7/QB rc11/WL 0
C1550 c_10_5/Q c_10_6/Q 0
C1551 c_5_9/QB c_5_8/QB 0
C1552 c_15_13/QB c_15_14/QB 0
C1553 rc6/WL c_5_3/Q 0
C1554 blb11 c_7_12/QB 0
C1555 c_7_10/QB rc6/WL 0
C1556 cl1 blb5 0.0013f
C1557 c_5_13/QB c_4_13/QB 0.01281f
C1558 cs11/n/Y cs10/n/a_162_47# 0
C1559 blb5 VDD -0.00917f
C1560 cl2 csel12 0.0291f
C1561 rh0 rc7/s/wd/A 0
C1562 rc6/WL rc6/s/wd/A -0.00118f
C1563 c_6_2/QB rc7/WL 0
C1564 c_7_15/Q rc7/WL 0
C1565 rh2 rc6/s/wd/A 0
C1566 rc13/WL c_14_7/Q 0
C1567 bl10 dl 0.04919f
C1568 rc5/WL c_4_11/Q 0
C1569 rc8/s/wd/A blb0 0
C1570 cs8/n/a_162_47# cl0 0.00134f
C1571 cl2 cs2/n/a_162_47# 0.00134f
C1572 c_1_0/QB c_1_0/Q -0
C1573 c_14_6/QB pcb 0.00169f
C1574 rl3 rc8/s/n3/a_302_47# 0.00105f
C1575 c_10_8/Q c_9_8/QB 0
C1576 c_10_8/QB c_9_8/Q 0
C1577 rl3 rc11/WL 0.00286f
C1578 c_3_0/QB rc3/s/wd/A 0.00246f
C1579 rh3 rh2 3.78679f
C1580 blb10 c_8_11/QB 0
C1581 dl c_0_8/Q 0.00931f
C1582 dlb c_0_8/QB 0.004f
C1583 c_15_8/QB blb7 0
C1584 c_14_1/QB rc14/WL 0
C1585 c_13_3/Q c_13_4/Q 0
C1586 rc0/WL dlb 0.01644f
C1587 c_15_9/QB blb8 0
C1588 c_14_5/QB c_14_6/QB 0
C1589 rc13/s/wd/A rl2 0.00155f
C1590 VDD c_9_8/Q 0.00756f
C1591 c_2_0/Q bl1 0
C1592 c_5_2/QB c_5_1/QB 0
C1593 rc12/WL bl14 0.00159f
C1594 c_6_1/QB c_5_1/QB 0.0025f
C1595 bl13 c_14_12/Q 0
C1596 bl11 c_12_10/Q 0
C1597 c_9_15/QB blb14 0
C1598 pcb c_14_4/Q 0.00166f
C1599 c_15_2/Q c_15_1/Q 0
C1600 c_14_2/Q rc13/WL 0
C1601 c_1_12/Q c_1_13/Q 0
C1602 bl12 c_11_11/QB 0.00303f
C1603 rh0 rh1 3.75415f
C1604 c_14_5/QB c_14_4/Q 0.00377f
C1605 csel3 c_0_3/QB 0
C1606 ch3 csel5 0.02926f
C1607 rc5/WL blb0 0.00236f
C1608 c_12_13/Q c_13_13/Q 0.00654f
C1609 ch2 cl1 0.37145f
C1610 csel3 cl2 0.05854f
C1611 c_1_5/Q c_0_5/Q 0.00654f
C1612 rc8/WL blb15 0
C1613 rc11/WL c_10_1/Q 0
C1614 c_9_7/QB c_9_8/Q 0.01135f
C1615 ch2 VDD 0.34207f
C1616 rc0/WL csel7 0.02369f
C1617 VDD c_15_12/Q 0.015f
C1618 c_10_2/QB rc9/WL 0
C1619 bl1 ch3 0
C1620 c_1_10/QB rc2/WL 0
C1621 pcb bl6 0.07118f
C1622 rc13/WL c_14_13/QB 0
C1623 rc0/s/wd/A ch3 0
C1624 rc4/WL c_4_8/QB 0
C1625 c_9_2/QB c_8_2/QB 0.01281f
C1626 c_5_10/Q rc5/WL 0
C1627 rh0 rc1/s/n3/a_302_47# 0.0045f
C1628 bl11 c_11_10/QB 0.00303f
C1629 c_0_0/QB c_1_0/QB 0.01281f
C1630 c_15_15/QB blb14 0
C1631 rc10/s/wd/A rc10/WL -0.00118f
C1632 c_5_10/Q blb9 0.00303f
C1633 rc8/WL c_7_6/Q 0
C1634 c_9_1/QB c_9_0/QB 0
C1635 c_14_5/QB bl6 0.00303f
C1636 cl1 csel9 0.03035f
C1637 c_0_15/QB dlb 0.004f
C1638 rc13/WL bl14 0.00159f
C1639 c_12_11/Q blb10 0.00303f
C1640 rl0 bl0 0.01662f
C1641 cs14/n/Y dlb 0
C1642 csel9 VDD 0.02187f
C1643 csel1 rc2/WL 0
C1644 c_14_9/Q blb8 0.00303f
C1645 rl0 rc11/s/n3/a_302_47# 0.00105f
C1646 blb7 c_5_8/QB 0
C1647 c_10_10/Q c_9_10/QB 0
C1648 rc14/WL c_15_9/Q 0
C1649 rc10/s/n3/a_162_47# rc10/s/wd/A -0.00121f
C1650 c_1_6/QB VDD 0.00969f
C1651 blb2 rc8/WL 0.00159f
C1652 c_10_4/Q rc9/WL 0
C1653 c_10_10/QB rc9/WL 0
C1654 VDD c_11_5/Q 0.00756f
C1655 c_8_1/Q c_8_2/QB 0.00377f
C1656 blb12 rc9/WL 0.00159f
C1657 bl9 ch3 0
C1658 rc14/WL c_13_13/Q 0
C1659 rc11/WL bl7 0.00159f
C1660 rc8/WL c_8_7/QB 0
C1661 rc4/s/wd/A rc4/s/n3/a_302_47# -0
C1662 c_3_11/QB c_4_11/Q 0
C1663 rc1/WL c_1_0/Q 0.01507f
C1664 clkb c_7_1/Q 0
C1665 c_10_13/QB c_10_12/Q 0.00377f
C1666 c_15_0/Q rc15/s/wd/A 0
C1667 c_12_1/QB c_12_2/QB 0
C1668 rc2/s/wd/A rc1/s/wd/A 0.02007f
C1669 rc6/s/n3/a_162_47# rl1 0.0024f
C1670 bl6 c_8_5/QB 0.00303f
C1671 rl3 c_3_0/QB 0
C1672 c_3_4/Q c_3_5/QB 0.00377f
C1673 c_2_5/Q c_1_5/QB 0
C1674 c_2_5/QB c_1_5/Q 0
C1675 bl8 c_3_7/Q 0
C1676 c_2_9/QB VDD 0.00969f
C1677 c_15_0/Q rc14/WL 0
C1678 rh2 rc10/s/wd/A 0.03724f
C1679 bl11 c_14_10/Q 0
C1680 rc0/WL bl4 0.00289f
C1681 c_5_13/QB rc4/WL 0
C1682 blb11 c_2_12/QB 0
C1683 bl15 c_15_14/QB 0.00303f
C1684 c_4_4/Q VDD 0.00756f
C1685 c_0_2/Q ch3 0
C1686 c_9_15/QB c_8_15/Q 0
C1687 c_9_15/Q c_8_15/QB 0
C1688 bl3 c_4_2/QB 0.00303f
C1689 c_5_13/QB bl14 0.00303f
C1690 VDD c_2_7/QB 0.00969f
C1691 c_0_5/Q rc1/WL 0
C1692 c_15_3/QB c_15_2/QB 0
C1693 c_0_12/QB cl0 0
C1694 c_10_6/Q rc9/WL 0
C1695 rc2/WL bl8 0.00159f
C1696 c_6_5/QB VDD 0.00969f
C1697 c_15_0/QB c_15_1/QB 0
C1698 c_14_8/QB rc14/WL 0
C1699 VDD c_12_4/Q 0.00756f
C1700 rc12/WL c_12_1/Q 0.00103f
C1701 c_0_0/QB rc1/WL 0
C1702 c_6_5/QB c_5_5/QB 0.0025f
C1703 c_9_10/Q rc8/WL 0
C1704 clkb rc8/WL 0.00509f
C1705 rc9/WL rl1 0.00292f
C1706 c_10_3/Q bl4 0
C1707 c_15_8/QB c_15_9/QB 0
C1708 c_12_3/Q bl4 0
C1709 c_5_12/Q c_5_11/Q 0
C1710 c_2_15/QB rc1/WL 0
C1711 c_2_10/Q rc3/WL 0
C1712 c_9_12/Q c_8_12/Q 0.00654f
C1713 rc6/s/n3/a_302_47# rc6/s/wd/A -0
C1714 rc8/s/wd/A bl0 0.00934f
C1715 c_11_4/Q VDD 0.00756f
C1716 c_14_6/Q rc13/WL 0
C1717 blb12 dlb 0.0282f
C1718 c_12_7/Q c_11_7/Q 0.00634f
C1719 cl2 bl5 0
C1720 rc13/WL c_14_12/Q 0
C1721 cl0 c_0_8/QB 0
C1722 c_1_15/Q rc1/WL 0
C1723 c_1_14/QB c_1_14/Q -0
C1724 rc0/WL cl0 0.0027f
C1725 csel6 blb5 0.00103f
C1726 cs7/n/Y dlb 0
C1727 c_0_14/Q c_0_15/Q 0
C1728 VDD c_8_9/QB 0.00969f
C1729 c_4_15/Q rc4/WL 0
C1730 rc13/s/n3/a_162_47# bl0 0
C1731 ch0 dlb 4.28364f
C1732 rc13/s/wd/A rh1 0
C1733 rc3/s/n3/a_302_47# rc3/s/wd/A -0
C1734 c_2_5/QB rc1/WL 0
C1735 c_5_7/QB VDD 0.00969f
C1736 c_5_9/QB rc5/WL 0
C1737 rc13/WL c_12_1/Q 0
C1738 c_4_6/Q bl7 0
C1739 c_9_6/QB c_10_6/Q 0
C1740 c_9_6/Q c_10_6/QB 0
C1741 blb15 dl 0.02104f
C1742 ch1 blb4 0
C1743 c_4_4/QB rc4/WL 0
C1744 ch1 c_0_10/QB 0
C1745 c_0_13/QB c_0_14/QB 0
C1746 c_2_10/QB blb9 0
C1747 c_10_1/Q c_10_2/Q 0
C1748 blb0 rc7/WL 0.00236f
C1749 blb1 c_4_2/QB 0
C1750 rc5/WL bl0 0.06726f
C1751 c_15_11/Q blb11 0
C1752 c_9_10/QB rc9/WL 0
C1753 rc12/s/n3/a_302_47# VDD -0
C1754 rc11/WL bl6 0.00159f
C1755 c_0_2/Q c_1_2/Q 0.00654f
C1756 c_9_2/Q c_9_3/Q 0
C1757 cs7/n/Y csel7 0.07585f
C1758 bl10 c_1_9/Q 0
C1759 csel13 cs13/n/Y 0.07585f
C1760 ch0 csel7 0.03716f
C1761 bl10 cl2 0
C1762 c_6_12/QB blb11 0
C1763 blb2 c_4_3/QB 0
C1764 c_5_11/QB c_4_11/QB 0.01281f
C1765 c_7_14/Q VDD 0.00756f
C1766 c_0_9/Q rc1/WL 0
C1767 blb2 dl 0.02104f
C1768 blb3 c_3_4/QB 0
C1769 cl0 c_0_15/QB 0
C1770 rl0 rc4/s/n3/a_162_47# 0.01123f
C1771 rc4/WL blb8 0.00159f
C1772 rc6/WL c_7_12/QB 0
C1773 c_10_3/Q c_11_3/QB 0
C1774 cs14/n/Y cl0 0
C1775 c_6_9/Q c_6_10/Q 0
C1776 VDD c_9_2/QB 0.00969f
C1777 c_12_3/QB c_11_3/Q 0
C1778 c_12_3/Q c_11_3/QB 0
C1779 VDD rc1/s/wd/A -0.00408f
C1780 c_4_12/QB c_5_12/QB 0.01281f
C1781 rc0/WL c_0_3/Q 0
C1782 c_3_12/QB c_3_13/Q 0.01135f
C1783 c_8_13/QB c_9_13/Q 0
C1784 dlb rl1 0.02782f
C1785 rc5/s/wd/A c_5_0/Q 0
C1786 c_10_10/QB c_10_11/Q 0.01135f
C1787 rc0/WL blb13 0.00289f
C1788 blb12 rc3/WL 0.00159f
C1789 bl14 c_6_13/Q 0
C1790 csel6 ch2 0.02936f
C1791 c_14_9/QB rc14/WL 0
C1792 c_0_1/QB ch2 0
C1793 c_15_12/QB c_14_12/Q 0
C1794 c_15_12/Q c_14_12/QB 0
C1795 c_12_12/QB c_12_12/Q 0
C1796 c_8_13/QB c_8_14/Q 0.01135f
C1797 c_9_6/Q blb5 0.00303f
C1798 c_1_5/QB csel5 0
C1799 c_8_0/Q c_8_1/Q 0
C1800 c_11_13/QB c_10_13/Q 0
C1801 rc11/WL c_12_8/QB 0
C1802 c_8_1/Q VDD 0.00756f
C1803 bl9 c_2_8/QB 0.00303f
C1804 c_2_11/Q rc1/WL 0
C1805 rc5/s/wd/A rc6/s/wd/A 0.02007f
C1806 c_7_15/QB rc6/WL 0
C1807 rc15/WL rc15/s/wd/A -0.00118f
C1808 c_10_1/Q rc9/WL 0
C1809 csel6 c_1_6/QB 0
C1810 c_14_11/Q rc15/WL 0
C1811 c_10_0/Q VDD 0.01304f
C1812 cs1/n/Y cs1/n/a_162_47# -0
C1813 c_11_13/Q c_11_14/QB 0.00377f
C1814 c_11_13/QB c_11_14/Q 0.01135f
C1815 c_7_14/Q c_8_14/QB 0
C1816 c_7_14/QB c_8_14/Q 0
C1817 c_10_5/Q bl6 0
C1818 c_10_11/QB c_10_12/Q 0.01135f
C1819 rc5/s/wd/A rh3 0
C1820 cs11/n/Y cs11/n/a_162_47# -0
C1821 ch0 bl4 0.00109f
C1822 rc15/WL rc14/WL 0.07019f
C1823 rc3/s/n3/a_302_47# rl3 0.00707f
C1824 blb14 c_15_15/Q 0.00303f
C1825 rh0 rc2/WL 0.00372f
C1826 rc3/s/wd/A rc3/WL -0.00118f
C1827 c_5_10/QB c_5_11/QB 0
C1828 pcb bl5 0.07118f
C1829 c_12_8/Q blb7 0.00303f
C1830 VDD c_15_8/Q 0.015f
C1831 rc14/WL c_14_13/Q 0
C1832 rc5/WL blb7 0.00159f
C1833 c_4_14/QB c_3_14/Q 0
C1834 VDD c_9_13/QB 0.00969f
C1835 c_8_13/QB bl14 0.00303f
C1836 c_3_11/QB c_3_12/Q 0.01135f
C1837 c_7_14/Q c_7_15/Q 0
C1838 clkb dl 0.05974f
C1839 c_15_6/QB c_15_7/QB 0
C1840 c_3_13/Q c_2_13/Q 0.00654f
C1841 c_4_5/Q bl6 0
C1842 rc4/WL c_5_12/QB 0
C1843 c_4_6/Q c_4_5/QB 0.01135f
C1844 c_12_11/QB rc12/WL 0
C1845 bl7 rc9/WL 0.00159f
C1846 rl1 rc3/WL 0
C1847 cl3 cs5/n/Y 0.01311f
C1848 c_2_12/QB rc1/WL 0
C1849 c_9_2/Q bl3 0
C1850 ch1 cs13/n/Y 0
C1851 c_6_8/Q c_5_8/Q 0.00634f
C1852 rl3 dlb 0.02782f
C1853 blb11 csel11 0.00807f
C1854 rc5/WL c_6_7/Q 0
C1855 rc13/s/wd/A blb1 0
C1856 c_9_1/QB c_9_2/Q 0.01135f
C1857 c_1_8/QB c_0_8/Q 0
C1858 c_1_8/Q c_0_8/QB 0
C1859 c_8_15/Q blb14 0.00303f
C1860 VDD c_8_8/QB 0.00969f
C1861 rc0/WL c_1_8/Q 0
C1862 rc12/WL c_13_15/QB 0
C1863 VDD rc10/s/n3/a_302_47# -0
C1864 c_0_4/Q rc1/WL 0
C1865 blb3 c_5_4/Q 0.00303f
C1866 cl3 cs8/n/Y 0.05978f
C1867 cl0 blb12 0.00156f
C1868 pcb bl10 0.07118f
C1869 ch1 rh3 0.02852f
C1870 ch2 blb0 0
C1871 clkb rc15/s/n3/a_302_47# 0.00463f
C1872 cs7/n/Y cl0 0
C1873 ch0 cl0 0.39416f
C1874 VDD c_5_8/Q 0.00756f
C1875 pcb c_14_15/QB 0.00169f
C1876 rc15/WL bl8 0.00298f
C1877 c_12_11/QB rc13/WL 0
C1878 VDD c_8_2/Q 0.00756f
C1879 blb11 c_12_12/QB 0
C1880 rc14/WL c_15_14/Q 0
C1881 c_3_13/QB c_3_12/QB 0
C1882 ch1 cs6/n/Y 0.09848f
C1883 c_0_13/Q c_0_14/Q 0
C1884 c_1_12/QB bl13 0.00303f
C1885 rc11/s/wd/A VDD -0.00408f
C1886 blb11 ch3 0
C1887 c_11_3/Q c_11_2/Q 0
C1888 rc8/WL c_7_12/Q 0
C1889 c_2_12/Q c_1_12/Q 0.00634f
C1890 c_5_6/QB VDD 0.00969f
C1891 c_9_6/QB bl7 0.00303f
C1892 c_0_3/QB dl 0.0049f
C1893 bl13 c_8_12/QB 0.00303f
C1894 dl c_1_9/Q 0.00273f
C1895 dlb c_1_9/QB 0
C1896 cl2 dl 0.03079f
C1897 c_15_11/Q c_14_11/QB 0
C1898 c_15_11/QB c_14_11/Q 0
C1899 c_14_4/QB rc13/WL 0
C1900 c_5_6/QB c_5_5/QB 0
C1901 bl0 rc7/WL 0.06726f
C1902 c_7_2/QB rc6/WL 0
C1903 rc7/s/n3/a_302_47# VDD -0
C1904 rl3 rc3/WL 0.00286f
C1905 c_5_2/QB rc6/WL 0
C1906 c_15_11/QB rc14/WL 0
C1907 c_8_9/Q rc9/WL 0
C1908 rc8/WL c_8_5/QB 0
C1909 c_9_3/QB rc10/WL 0
C1910 bl11 csel10 0.00103f
C1911 c_6_1/QB rc6/WL 0
C1912 c_1_3/Q c_1_4/QB 0.00377f
C1913 c_1_3/QB c_1_4/Q 0.01135f
C1914 rl0 rc4/s/wd/A 0.05406f
C1915 bl7 dlb 0
C1916 c_9_2/Q blb1 0.00303f
C1917 rc1/s/n3/a_162_47# rl2 0.0024f
C1918 c_9_3/QB c_8_3/QB 0.01281f
C1919 bl7 c_3_6/Q 0
C1920 c_10_5/QB rc11/WL 0
C1921 cl0 rl1 0.02782f
C1922 c_1_11/QB c_1_11/Q -0
C1923 c_2_1/Q c_1_1/Q 0.00634f
C1924 bl3 rc12/WL 0.00159f
C1925 ch0 c_0_3/Q 0
C1926 ch0 blb13 0.00109f
C1927 VDD c_3_5/Q 0.00756f
C1928 c_13_13/QB c_13_12/QB 0
C1929 rc9/s/n3/a_302_47# rl2 0.00105f
C1930 c_0_2/QB rc1/WL 0
C1931 blb13 c_15_13/Q 0
C1932 c_6_11/Q VDD 0.00756f
C1933 c_3_13/QB c_2_13/Q 0
C1934 rc5/WL blb6 0.00159f
C1935 ch2 csel8 0.27242f
C1936 cl2 blb15 0
C1937 csel4 c_1_4/Q 0
C1938 rc4/WL c_5_8/QB 0
C1939 csel7 bl7 0.00807f
C1940 blb3 rc1/WL 0.00159f
C1941 c_14_9/QB c_14_10/Q 0.01135f
C1942 bl8 c_10_7/Q 0
C1943 c_9_11/Q rc10/WL 0
C1944 bl6 rc9/WL 0.00159f
C1945 bl12 c_0_11/QB 0.00303f
C1946 rc12/WL c_11_13/QB 0
C1947 c_7_9/Q c_8_9/Q 0.00634f
C1948 c_2_0/Q c_1_0/QB 0
C1949 c_7_4/Q bl5 0
C1950 blb3 rc10/WL 0.00159f
C1951 blb9 c_15_9/QB 0
C1952 c_12_7/QB c_13_7/QB 0.01281f
C1953 csel9 csel8 0.02813f
C1954 c_0_15/Q c_1_15/QB 0
C1955 c_1_13/QB c_2_13/Q 0
C1956 rc12/WL bl12 0.00159f
C1957 cs4/n/Y ch0 0.00131f
C1958 blb13 c_6_14/Q 0.00303f
C1959 blb2 c_0_3/QB 0
C1960 rc11/WL bl5 0.00159f
C1961 c_13_4/Q c_12_4/Q 0.00654f
C1962 bl3 rc13/WL 0.00159f
C1963 bl2 rc12/WL 0.00175f
C1964 blb2 cl2 0.00107f
C1965 bl11 rc12/WL 0.00159f
C1966 rc0/s/wd/A c_0_0/Q 0
C1967 bl1 c_0_0/Q 0
C1968 blb7 rc7/WL 0.00159f
C1969 rc5/WL c_6_7/QB 0
C1970 rc12/WL c_11_6/QB 0
C1971 c_9_13/QB c_9_14/QB 0
C1972 c_7_1/QB VDD 0.00969f
C1973 c_1_8/QB dl 0.0021f
C1974 c_0_1/Q c_1_1/Q 0.00654f
C1975 c_0_4/QB c_0_5/Q 0.01135f
C1976 bl7 rc3/WL 0.00159f
C1977 cs12/n/a_162_47# cl0 0.00134f
C1978 c_2_9/Q rc3/WL 0
C1979 rc15/WL c_14_10/Q 0
C1980 c_6_12/QB rc6/WL 0
C1981 c_11_15/QB rc10/WL 0
C1982 ch1 cs11/n/Y 0
C1983 c_2_11/QB c_2_12/QB 0
C1984 c_8_11/QB c_8_10/QB 0
C1985 rl3 cl0 0.02782f
C1986 rc11/WL c_12_9/Q 0
C1987 c_6_7/Q rc7/WL 0
C1988 ch3 cs15/n/Y 0.09809f
C1989 blb3 rc6/WL 0.00159f
C1990 c_12_13/QB c_12_12/QB 0
C1991 pcb dl 0.68952f
C1992 c_13_2/QB c_13_1/Q 0.00377f
C1993 c_13_2/Q c_13_1/QB 0.01135f
C1994 rh3 c_13_0/QB 0
C1995 c_2_3/QB rc3/WL 0
C1996 rc4/WL c_3_5/QB 0
C1997 c_2_7/Q rc3/WL 0
C1998 c_2_11/QB c_3_11/Q 0
C1999 c_7_4/Q rc8/WL 0
C2000 rc13/WL bl12 0.00159f
C2001 rc12/WL blb1 0.00178f
C2002 c_10_1/QB c_10_0/Q 0.00377f
C2003 VDD c_0_12/QB 0.00969f
C2004 c_3_14/QB bl15 0.00303f
C2005 cs9/n/Y dl 0
C2006 c_1_2/Q c_1_1/QB 0.01135f
C2007 VDD c_12_9/QB 0.00969f
C2008 bl2 rc13/WL 0.00175f
C2009 bl11 rc13/WL 0.00159f
C2010 rc11/WL bl10 0.00159f
C2011 rc8/WL c_8_11/Q 0
C2012 blb2 c_2_3/Q 0.00303f
C2013 rl0 rc4/WL 0.0029f
C2014 rc2/WL bl13 0.00159f
C2015 ch2 bl0 0
C2016 rc1/WL csel11 0
C2017 c_1_14/QB rc1/WL 0
C2018 c_8_0/QB rc8/WL 0.00535f
C2019 rc5/WL c_4_13/QB 0
C2020 ch1 c_0_5/Q 0
C2021 c_2_3/QB bl4 0.00303f
C2022 c_14_8/Q VDD 0.00756f
C2023 bl6 dlb 0
C2024 csel14 csel15 0.03263f
C2025 c_14_8/QB c_13_8/Q 0
C2026 clkb cl2 0.03872f
C2027 rc1/s/wd/A blb0 0
C2028 c_2_0/Q rc1/WL 0
C2029 c_8_8/Q rc9/WL 0
C2030 bl3 csel2 0.00103f
C2031 rc11/WL c_10_13/QB 0
C2032 pcb rc15/s/n3/a_302_47# 0.00233f
C2033 VDD c_0_8/QB 0.00969f
C2034 rc0/WL cl1 0.00217f
C2035 rc5/WL rc4/s/wd/A 0
C2036 c_10_0/QB rl2 0
C2037 rc9/WL c_9_9/QB 0
C2038 rc0/WL VDD 0.05907f
C2039 c_2_11/Q blb10 0.00303f
C2040 blb1 rc13/WL 0.00178f
C2041 c_4_5/Q c_4_6/QB 0.00377f
C2042 clkb c_6_0/Q 0
C2043 pcb blb15 0.07158f
C2044 c_14_8/Q c_14_7/QB 0.01135f
C2045 ch1 c_0_0/QB 0
C2046 csel10 rc2/WL 0
C2047 ch2 c_0_14/QB 0
C2048 rc4/WL c_4_2/Q 0
C2049 rc11/WL c_11_7/Q 0
C2050 c_7_10/QB c_6_10/Q 0
C2051 c_5_13/Q c_6_13/QB 0
C2052 c_2_10/QB c_2_9/QB 0
C2053 rc13/s/n3/a_302_47# rc13/s/wd/A -0
C2054 rc2/WL c_1_4/Q 0
C2055 rc4/s/n3/a_302_47# rh1 0.0045f
C2056 c_8_1/Q blb0 0.00303f
C2057 cs12/n/Y cs11/n/a_162_47# 0
C2058 bl6 c_12_5/Q 0
C2059 blb14 c_11_15/Q 0.00303f
C2060 blb7 c_9_8/Q 0.00303f
C2061 c_12_0/Q c_12_1/Q 0
C2062 cl0 bl7 0
C2063 c_5_7/Q c_4_7/QB 0
C2064 c_10_4/QB c_10_3/QB 0
C2065 c_11_13/QB c_11_12/QB 0
C2066 VDD c_11_7/QB 0.00969f
C2067 c_3_2/Q c_2_2/Q 0.00654f
C2068 blb2 pcb 0.07118f
C2069 cl3 cs13/n/a_162_47# 0
C2070 csel12 dlb 0.10216f
C2071 c_4_5/QB rc3/WL 0
C2072 bl2 csel2 0.00807f
C2073 c_10_3/Q VDD 0.00756f
C2074 c_1_10/QB c_0_10/QB 0.01281f
C2075 c_12_3/Q VDD 0.00756f
C2076 c_10_9/QB rc10/WL 0
C2077 rc5/WL c_4_12/QB 0
C2078 c_4_14/QB c_4_13/Q 0.00377f
C2079 c_4_14/Q c_4_13/QB 0.01135f
C2080 c_7_3/Q c_7_2/QB 0.01135f
C2081 VDD rc9/s/wd/A -0.00408f
C2082 c_7_13/QB rc6/WL 0
C2083 ch2 blb7 0
C2084 blb6 rc7/WL 0.00159f
C2085 rc14/WL c_15_14/QB 0
C2086 cs14/n/Y cl1 0.04734f
C2087 c_1_13/QB c_1_14/Q 0.01135f
C2088 c_1_13/Q c_1_14/QB 0.00377f
C2089 c_5_9/Q blb8 0.00303f
C2090 c_14_1/QB rc13/WL 0
C2091 cs14/n/Y VDD 0.01448f
C2092 VDD c_0_15/QB 0.00479f
C2093 rc15/s/wd/A c_15_1/Q 0
C2094 c_8_6/QB rc7/WL 0
C2095 c_3_1/Q rc3/s/wd/A 0
C2096 blb10 c_3_11/Q 0.00303f
C2097 bl6 rc3/WL 0.00159f
C2098 cl3 blb4 0
C2099 c_15_6/QB blb6 0
C2100 rc14/WL blb4 0.00159f
C2101 rc2/s/wd/A rc3/s/wd/A 0.02158f
C2102 c_13_6/QB c_13_7/QB 0
C2103 rc14/WL c_15_1/Q 0
C2104 cl3 cs0/n/a_162_47# 0
C2105 clkb rc14/s/wd/A 0.09749f
C2106 c_11_6/QB c_11_5/QB 0
C2107 c_2_10/Q VDD 0.00756f
C2108 blb1 csel2 0.00103f
C2109 rc14/WL c_13_15/Q 0
C2110 c_9_12/Q c_9_11/Q 0
C2111 c_9_12/QB c_9_11/QB 0
C2112 ch1 c_0_9/Q 0
C2113 ch3 rh2 0.02782f
C2114 rc12/WL c_13_13/Q 0
C2115 c_0_13/QB bl14 0.00303f
C2116 c_6_7/QB rc7/WL 0
C2117 c_4_4/Q c_3_4/Q 0.00634f
C2118 c_10_5/QB rc9/WL 0
C2119 rc2/s/wd/A rl1 0.00205f
C2120 c_0_10/Q rc1/WL 0
C2121 c_15_3/QB c_14_3/Q 0
C2122 csel3 dlb 0.10216f
C2123 c_11_4/Q c_11_3/Q 0
C2124 c_7_10/Q c_7_9/QB 0.01135f
C2125 rc5/WL c_6_2/Q 0
C2126 clkb pcb 0.00945f
C2127 c_12_9/Q c_13_9/Q 0.00654f
C2128 cs4/n/Y cs3/n/a_162_47# 0
C2129 c_6_15/Q rc6/WL 0
C2130 rc5/WL rc4/WL 0.07019f
C2131 VDD c_13_4/QB 0.00969f
C2132 c_7_8/QB c_8_8/Q 0
C2133 csel13 cs12/n/Y 0
C2134 c_4_6/Q c_4_7/QB 0.00377f
C2135 c_4_6/QB c_4_7/Q 0.01135f
C2136 bl1 rc0/s/wd/A 0
C2137 c_0_6/Q blb5 0.00303f
C2138 rc11/s/wd/A blb0 0
C2139 c_1_2/Q rc1/WL 0
C2140 blb9 rc4/WL 0.00159f
C2141 c_4_12/Q bl13 0
C2142 c_14_14/QB bl15 0.00303f
C2143 c_15_7/Q c_15_8/QB 0.00377f
C2144 c_15_7/QB c_15_8/Q 0.01135f
C2145 blb5 c_8_6/QB 0
C2146 rc5/WL bl14 0.00159f
C2147 c_10_2/QB VDD 0.00969f
C2148 rc13/WL c_13_13/Q 0
C2149 bl10 c_13_9/Q 0
C2150 VDD c_12_0/QB 0.01264f
C2151 c_7_10/QB c_8_10/QB 0.0025f
C2152 c_8_4/Q rc7/WL 0
C2153 rc12/s/n3/a_302_47# bl0 0.00159f
C2154 rc9/WL bl5 0.00159f
C2155 c_15_11/Q blb10 0.00303f
C2156 rh3 rc11/s/n3/a_162_47# 0
C2157 c_2_12/Q c_2_11/Q 0
C2158 c_1_11/Q dl 0.00273f
C2159 c_1_11/QB dlb 0
C2160 rc11/WL c_12_5/QB 0
C2161 clkb c_14_0/QB 0
C2162 c_12_13/Q c_11_13/Q 0.00634f
C2163 rl0 rl2 0.17174f
C2164 c_1_8/QB c_1_9/Q 0.01135f
C2165 c_1_8/Q c_1_9/QB 0.00377f
C2166 c_1_5/QB c_1_5/Q -0
C2167 bl6 cl0 0
C2168 blb10 c_9_11/Q 0.00303f
C2169 rc1/s/wd/A bl0 0.00934f
C2170 c_12_11/Q c_12_10/Q 0
C2171 c_10_4/Q VDD 0.00756f
C2172 cl1 blb12 0
C2173 c_1_6/Q c_2_6/QB 0
C2174 c_10_10/QB VDD 0.00969f
C2175 VDD blb12 -0.00917f
C2176 c_4_8/Q c_4_7/QB 0.01135f
C2177 rl3 rc2/s/wd/A 0.00228f
C2178 rc11/WL blb15 0
C2179 bl9 c_11_8/QB 0.00303f
C2180 c_8_7/Q c_8_8/Q 0
C2181 cl1 cs7/n/Y 0
C2182 ch0 cl1 0.36945f
C2183 VDD cs7/n/Y 0.01448f
C2184 cs0/n/a_162_47# cs0/n/Y -0
C2185 ch0 VDD 0.34243f
C2186 c_12_11/QB c_11_11/Q 0
C2187 c_12_11/Q c_11_11/QB 0
C2188 c_4_14/Q rc4/WL 0
C2189 cl3 cs13/n/Y 0.01311f
C2190 VDD c_15_13/Q 0.015f
C2191 rc15/WL bl13 0.00298f
C2192 c_15_6/Q c_15_5/QB 0.01135f
C2193 c_15_6/QB c_15_5/Q 0.00377f
C2194 pcb cl2 0.02782f
C2195 c_1_10/Q bl11 0
C2196 c_2_0/QB rh0 0
C2197 rc11/WL c_10_12/Q 0
C2198 c_9_0/Q c_10_0/QB 0
C2199 ch2 blb6 0
C2200 c_0_6/Q ch2 0
C2201 c_2_6/QB bl7 0.00303f
C2202 bl10 rc9/WL 0.00159f
C2203 c_14_8/QB rc13/WL 0
C2204 VDD c_11_12/Q 0.00756f
C2205 rc11/WL c_10_11/QB 0
C2206 cl2 cs9/n/Y 0
C2207 ch1 c_0_4/Q 0
C2208 c_4_9/Q bl10 0
C2209 c_10_4/QB c_9_4/QB 0.0025f
C2210 rc8/WL rc9/WL 0.07019f
C2211 rh3 rc15/s/wd/A 0.03687f
C2212 c_8_13/Q rc9/WL 0
C2213 rc2/WL csel2 0
C2214 c_4_9/QB c_4_8/Q 0.00377f
C2215 csel6 rc0/WL 0.02369f
C2216 csel3 bl4 0.00103f
C2217 blb2 rc11/WL 0.00159f
C2218 c_0_1/QB rc0/WL 0
C2219 clkb rc14/s/n3/a_162_47# 0.00107f
C2220 c_3_11/QB rc4/WL 0
C2221 c_14_12/Q c_13_12/QB 0
C2222 cl3 rh3 0.0418f
C2223 cl0 csel12 0.03107f
C2224 rh3 rc14/WL 0.00372f
C2225 VDD rc3/s/wd/A -0.00408f
C2226 c_0_6/Q c_1_6/QB 0
C2227 c_2_8/QB rc1/WL 0
C2228 VDD c_6_14/Q 0.00756f
C2229 ch1 cs12/n/Y 0
C2230 c_2_6/QB c_2_7/Q 0.01135f
C2231 c_9_1/QB c_8_1/QB 0.01281f
C2232 c_15_6/Q VDD 0.015f
C2233 VDD c_10_6/Q 0.00756f
C2234 c_8_13/QB c_8_12/QB 0
C2235 VDD c_13_12/Q 0.00756f
C2236 bl6 c_9_5/QB 0.00303f
C2237 c_7_1/QB blb0 0
C2238 c_13_0/Q rc14/WL 0
C2239 c_10_13/QB rc9/WL 0
C2240 c_5_7/QB c_6_7/Q 0
C2241 c_7_0/QB rc7/WL 0.00535f
C2242 c_9_15/QB rc10/WL 0
C2243 cl3 cs6/n/Y 0.01311f
C2244 cl1 rl1 0.02782f
C2245 dlb bl5 0
C2246 c_4_1/QB c_4_2/Q 0.01135f
C2247 c_4_1/Q c_4_2/QB 0.00377f
C2248 blb3 c_0_4/QB 0
C2249 c_2_14/QB c_2_15/QB 0
C2250 blb4 c_7_5/Q 0.00303f
C2251 VDD rl1 0.53376f
C2252 c_7_11/Q VDD 0.00756f
C2253 blb5 c_15_5/Q 0
C2254 c_4_6/QB c_3_6/Q 0
C2255 c_4_6/Q c_3_6/QB 0
C2256 c_1_5/QB rc1/WL 0
C2257 c_2_7/QB c_3_7/QB 0.01281f
C2258 c_2_3/QB c_2_4/QB 0
C2259 bl10 c_7_9/Q 0
C2260 bl2 c_15_1/QB 0.00303f
C2261 c_7_9/Q rc8/WL 0
C2262 blb10 csel11 0.00103f
C2263 c_0_12/Q dlb 0
C2264 c_7_7/Q rc7/WL 0
C2265 rc8/s/wd/A rl2 0.00155f
C2266 c_8_14/Q rc7/WL 0
C2267 c_1_4/QB c_0_4/Q 0
C2268 c_9_6/QB rc8/WL 0
C2269 bl2 c_8_1/QB 0.00303f
C2270 c_2_14/QB c_3_14/QB 0.01281f
C2271 c_5_9/Q c_5_8/QB 0.01135f
C2272 c_5_9/QB c_5_8/Q 0.00377f
C2273 c_12_7/Q rc11/WL 0
C2274 bl0 rc10/s/n3/a_302_47# 0.00159f
C2275 bl2 c_1_1/Q 0
C2276 c_7_10/Q rc6/WL 0
C2277 blb6 c_2_7/QB 0
C2278 c_5_11/QB VDD 0.00969f
C2279 c_5_13/QB c_4_13/Q 0
C2280 pcb rc14/s/wd/A 0.00187f
C2281 csel3 cl0 0.02918f
C2282 c_11_14/QB c_11_15/QB 0
C2283 rl0 rc7/s/wd/A 0.00281f
C2284 clkb rc8/s/n3/a_302_47# 0.00768f
C2285 c_6_2/Q rc7/WL 0
C2286 rc13/s/n3/a_162_47# rl2 0.0024f
C2287 clkb rc11/WL 0.00509f
C2288 ch1 c_0_2/QB 0
C2289 c_12_7/QB VDD 0.00969f
C2290 c_10_10/Q c_10_11/QB 0.00377f
C2291 bl10 dlb 0
C2292 blb1 c_15_1/QB 0
C2293 c_0_6/QB c_0_5/QB 0
C2294 rc5/WL c_5_1/Q 0.00103f
C2295 clkb c_8_0/QB 0
C2296 ch1 blb3 0
C2297 c_3_0/Q rc3/s/wd/A 0
C2298 c_14_9/QB rc13/WL 0
C2299 c_10_8/Q c_9_8/Q 0.00634f
C2300 rc11/s/wd/A bl0 0.00934f
C2301 c_9_10/QB VDD 0.00969f
C2302 bl5 c_7_4/QB 0.00303f
C2303 rc11/s/wd/A rc11/s/n3/a_302_47# -0
C2304 dlb c_0_8/Q 0
C2305 bl14 rc7/WL 0.00159f
C2306 c_15_8/Q blb7 0.00303f
C2307 rc0/WL blb0 0.00366f
C2308 blb10 ch3 0
C2309 rc2/WL blb8 0.00159f
C2310 bl15 c_1_14/QB 0.00303f
C2311 bl5 rc3/WL 0.00159f
C2312 c_11_2/QB rc10/WL 0
C2313 c_15_9/Q blb8 0.00303f
C2314 c_14_5/Q c_14_6/QB 0.00377f
C2315 c_5_2/Q c_5_1/QB 0.01135f
C2316 c_4_6/QB rc3/WL 0
C2317 c_13_14/QB blb13 0
C2318 rl3 cl1 0.02782f
C2319 rc2/WL csel15 0
C2320 rc7/s/n3/a_302_47# bl0 0.00159f
C2321 rl3 VDD 0.54356f
C2322 c_6_1/Q c_5_1/QB 0
C2323 rc8/WL c_7_8/QB 0
C2324 c_14_0/QB rc14/s/wd/A 0.00246f
C2325 c_9_15/Q blb14 0.00303f
C2326 c_14_5/QB pcb 0.00169f
C2327 c_2_8/Q c_2_9/QB 0.00377f
C2328 c_7_6/QB c_7_7/QB 0
C2329 blb11 c_9_12/QB 0
C2330 bl1 rc12/s/wd/A 0
C2331 bl12 c_11_11/Q 0
C2332 csel3 c_0_3/Q 0.00119f
C2333 csel13 ch3 0.25619f
C2334 rl0 rh1 0.36794f
C2335 c_14_5/Q c_14_4/Q 0
C2336 c_5_7/QB blb6 0
C2337 c_14_1/QB c_15_1/QB 0.01281f
C2338 blb7 c_8_8/QB 0
C2339 rc13/WL c_14_13/Q 0
C2340 c_1_10/Q rc2/WL 0
C2341 rc5/WL c_4_1/QB 0
C2342 c_2_8/Q c_2_7/QB 0.01135f
C2343 pcb c_14_0/QB 0.00169f
C2344 cl3 cs11/n/Y 0.06061f
C2345 rc8/WL c_7_4/QB 0
C2346 blb0 rc9/s/wd/A 0
C2347 ch3 bl15 0
C2348 c_0_0/Q c_1_0/QB 0
C2349 blb5 rc4/WL 0.00159f
C2350 bl10 rc3/WL 0.00159f
C2351 blb9 c_15_10/QB 0
C2352 c_9_1/Q c_9_0/QB 0.01135f
C2353 c_14_5/Q bl6 0
C2354 c_10_1/QB c_10_2/QB 0
C2355 blb3 c_1_4/QB 0
C2356 c_12_0/QB c_12_1/QB 0
C2357 c_10_1/Q VDD 0.00756f
C2358 blb7 c_5_8/Q 0.00303f
C2359 c_10_10/Q c_9_10/Q 0.00634f
C2360 c_15_10/Q c_14_10/QB 0
C2361 c_1_6/Q VDD 0.00756f
C2362 rc14/s/n3/a_162_47# rc14/s/wd/A -0.00121f
C2363 c_0_4/QB ch3 0
C2364 c_5_6/Q c_6_6/Q 0.00634f
C2365 VDD c_1_9/QB 0.00969f
C2366 c_5_7/QB c_6_7/QB 0.0025f
C2367 cs4/n/Y csel3 0.00301f
C2368 csel4 cs3/n/Y 0
C2369 VDD c_5_4/QB 0.00969f
C2370 rc8/WL c_8_7/Q 0
C2371 csel6 cs7/n/Y 0.00301f
C2372 rc8/s/wd/A rc7/s/wd/A 0.02007f
C2373 csel6 ch0 0.03716f
C2374 clkb c_3_0/QB 0
C2375 ch1 csel11 0.03695f
C2376 c_5_5/QB c_5_4/QB 0
C2377 c_0_1/QB ch0 0
C2378 rc8/WL bl4 0.00159f
C2379 c_12_1/Q c_12_2/QB 0.00377f
C2380 csel8 c_0_8/QB 0
C2381 c_6_0/QB VDD 0.01264f
C2382 bl6 c_8_5/Q 0
C2383 rc0/WL csel8 0.02369f
C2384 csel15 c_1_15/QB 0
C2385 cl1 bl7 0
C2386 c_11_1/Q c_11_2/QB 0.00377f
C2387 rl3 c_3_0/Q 0
C2388 c_3_4/Q c_3_5/Q 0
C2389 VDD bl7 -0.00929f
C2390 c_2_5/Q c_1_5/Q 0.00634f
C2391 c_2_9/Q VDD 0.00756f
C2392 c_4_7/QB rc3/WL 0
C2393 c_12_6/QB rc12/WL 0
C2394 cl0 bl5 0
C2395 blb11 c_3_12/QB 0
C2396 VDD c_13_2/QB 0.00969f
C2397 blb15 rc9/WL 0
C2398 c_1_13/QB rc1/WL 0
C2399 c_5_6/Q rc6/WL 0
C2400 rc15/WL c_15_12/QB 0
C2401 rc9/WL c_10_12/Q 0
C2402 c_10_5/QB c_9_5/QB 0.0025f
C2403 c_0_7/QB ch3 0
C2404 c_9_15/Q c_8_15/Q 0.00654f
C2405 rh0 rc6/s/wd/A 0
C2406 c_6_11/QB bl12 0.00303f
C2407 c_14_6/Q c_15_6/QB 0
C2408 bl3 c_4_2/Q 0
C2409 VDD c_2_7/Q 0.00756f
C2410 c_10_11/QB rc9/WL 0
C2411 rc2/WL c_1_1/Q 0
C2412 c_2_3/QB VDD 0.00969f
C2413 c_15_3/QB c_15_2/Q 0.00377f
C2414 c_1_7/QB rc1/WL 0
C2415 c_0_12/Q cl0 0
C2416 blb14 rc1/WL 0.00159f
C2417 c_4_9/QB rc3/WL 0
C2418 c_14_4/Q c_15_4/QB 0
C2419 c_14_12/QB c_13_12/Q 0
C2420 ch1 ch3 0.14944f
C2421 rh0 rh3 0.18122f
C2422 c_0_9/QB blb8 0
C2423 rc8/s/wd/A rh1 0.00114f
C2424 blb2 rc9/WL 0.00159f
C2425 c_12_13/QB c_12_14/QB 0
C2426 ch2 bl14 0
C2427 c_6_5/Q VDD 0.00756f
C2428 c_15_0/Q c_15_1/QB 0.00377f
C2429 blb14 rc10/WL 0.00159f
C2430 c_8_7/QB rc9/WL 0
C2431 dl dlb 4.9707f
C2432 c_0_0/Q rc1/WL 0
C2433 c_6_5/Q c_5_5/QB 0
C2434 c_12_6/QB rc13/WL 0
C2435 c_15_8/QB c_15_9/Q 0.01135f
C2436 c_15_8/Q c_15_9/QB 0.00377f
C2437 c_13_6/QB VDD 0.00969f
C2438 clkb rc6/s/n3/a_162_47# 0.00107f
C2439 bl10 cl0 0
C2440 c_14_2/QB c_13_2/QB 0.0025f
C2441 cl0 c_0_8/Q 0
C2442 c_3_3/QB c_3_4/QB 0
C2443 c_14_6/Q blb5 0.00303f
C2444 rc0/WL bl0 0.06856f
C2445 blb10 c_15_10/Q 0
C2446 csel7 dl 0.08427f
C2447 c_14_9/QB blb8 0
C2448 c_14_6/QB VDD 0.00969f
C2449 VDD c_8_9/Q 0.00756f
C2450 ch0 blb0 0.00109f
C2451 rc5/WL rh1 0.00372f
C2452 rc6/WL blb14 0.00159f
C2453 c_1_13/QB c_1_13/Q -0
C2454 c_2_5/Q rc1/WL 0
C2455 c_5_9/Q rc5/WL 0
C2456 rc8/WL c_7_7/QB 0
C2457 c_9_6/Q c_10_6/Q 0.00634f
C2458 blb15 dlb 0.0282f
C2459 c_4_4/Q rc4/WL 0
C2460 rc5/WL c_5_5/Q 0
C2461 bl6 c_15_5/QB 0.00303f
C2462 c_0_13/QB c_0_14/Q 0.01135f
C2463 ch1 c_0_10/Q 0
C2464 c_14_6/QB c_14_7/QB 0
C2465 blb1 c_4_2/Q 0.00303f
C2466 c_14_4/Q VDD 0.00756f
C2467 c_11_9/QB c_10_9/QB 0.01281f
C2468 c_12_5/QB c_12_5/Q 0
C2469 c_9_10/Q rc9/WL 0
C2470 clkb rc9/WL 0.00509f
C2471 rc0/WL c_0_14/QB 0
C2472 c_4_3/QB rc3/WL 0
C2473 VDD c_4_5/QB 0.00969f
C2474 blb0 rc3/s/wd/A 0
C2475 rc8/WL c_9_5/QB 0
C2476 c_14_8/QB c_15_8/QB 0.01281f
C2477 c_3_3/QB c_3_2/QB 0
C2478 blb2 c_4_3/Q 0.00303f
C2479 c_4_5/QB c_5_5/QB 0.01281f
C2480 c_15_11/QB c_15_12/QB 0
C2481 rc15/WL blb8 0.00298f
C2482 c_3_6/QB rc3/WL 0
C2483 c_5_11/QB c_4_11/Q 0
C2484 c_5_11/Q c_4_11/QB 0
C2485 bl0 rc9/s/wd/A 0.00934f
C2486 rc11/WL c_12_15/QB 0
C2487 rc8/WL blb13 0.00159f
C2488 blb2 dlb 0.0282f
C2489 c_1_7/QB c_1_7/Q -0
C2490 cl1 bl6 0
C2491 rc5/WL bl3 0.00159f
C2492 c_10_3/Q c_11_3/Q 0.00654f
C2493 bl6 VDD -0.00929f
C2494 c_14_4/Q c_15_4/Q 0.00654f
C2495 c_12_3/Q c_11_3/Q 0.00634f
C2496 c_4_12/Q c_5_12/QB 0
C2497 rc5/WL c_5_0/QB 0.00535f
C2498 rh0 rc10/s/wd/A 0
C2499 c_4_3/QB bl4 0.00303f
C2500 blb0 rl1 0
C2501 c_8_10/Q bl11 0
C2502 bl6 c_5_5/QB 0.00303f
C2503 c_14_8/Q blb7 0.00303f
C2504 dl bl4 0.04919f
C2505 c_9_12/QB rc10/WL 0
C2506 c_0_1/Q ch2 0
C2507 c_15_12/Q c_14_12/Q 0.00654f
C2508 c_1_5/Q csel5 0
C2509 csel10 c_0_10/QB 0
C2510 c_11_13/Q c_10_13/Q 0.00654f
C2511 bl1 c_1_0/QB 0.00303f
C2512 blb7 c_0_8/QB 0
C2513 rc5/WL c_5_3/QB 0
C2514 bl9 c_7_8/Q 0
C2515 rc0/WL blb7 0.00289f
C2516 c_0_14/QB c_0_15/QB 0
C2517 blb2 c_6_3/Q 0.00303f
C2518 cs7/n/Y csel8 0
C2519 blb15 rc3/WL 0
C2520 VDD c_5_15/QB 0.00479f
C2521 rc8/s/wd/A blb1 0
C2522 csel6 c_1_6/Q 0
C2523 ch0 csel8 0.03716f
C2524 clkb rc3/s/n3/a_302_47# 0.00768f
C2525 c_5_7/QB rc4/WL 0
C2526 rc5/WL bl12 0.00159f
C2527 c_11_13/Q c_11_14/Q 0
C2528 c_7_14/Q c_8_14/Q 0.00634f
C2529 blb9 c_3_10/QB 0
C2530 rh0 c_1_0/Q 0
C2531 rc2/WL c_3_5/QB 0
C2532 VDD c_12_8/QB 0.00969f
C2533 bl2 rc5/WL 0.00175f
C2534 rc5/WL bl11 0.00159f
C2535 c_10_11/Q c_10_12/Q 0
C2536 cl1 csel12 0.02913f
C2537 c_6_12/Q c_7_12/QB 0
C2538 rh3 rc13/s/wd/A 0.03722f
C2539 VDD csel12 0.02187f
C2540 rl0 rc2/WL 0
C2541 c_5_10/QB c_5_11/Q 0.01135f
C2542 c_5_10/Q c_5_11/QB 0.00377f
C2543 c_4_14/Q c_3_14/Q 0.00634f
C2544 rc13/s/wd/A c_13_0/Q 0
C2545 csel6 bl7 0.00103f
C2546 clkb dlb 0.03893f
C2547 c_2_4/QB bl5 0.00303f
C2548 blb2 rc3/WL 0.00159f
C2549 rc7/s/wd/A rc7/WL -0.00118f
C2550 c_15_6/QB c_15_7/Q 0.01135f
C2551 c_15_6/Q c_15_7/QB 0.00377f
C2552 c_12_11/Q rc12/WL 0
C2553 c_0_11/QB c_0_10/QB 0
C2554 c_2_14/QB c_1_14/QB 0.0025f
C2555 ch2 rl2 0.02782f
C2556 cl0 dl 0.03275f
C2557 c_3_0/QB c_3_1/QB 0
C2558 rl3 blb0 0
C2559 c_14_14/QB rc14/WL 0
C2560 rc5/WL blb1 0.00178f
C2561 c_13_14/QB VDD 0.00969f
C2562 rc12/WL blb4 0.00159f
C2563 c_9_1/Q c_9_2/Q 0
C2564 rc15/WL c_15_1/QB 0
C2565 rl0 rc12/s/n3/a_162_47# 0.01123f
C2566 VDD c_8_8/Q 0.00756f
C2567 c_1_8/Q c_0_8/Q 0.00654f
C2568 c_9_4/Q rc10/WL 0
C2569 rc12/WL c_13_15/Q 0
C2570 cl3 cs12/n/Y 0.05978f
C2571 c_6_12/QB c_6_13/QB 0
C2572 VDD c_9_9/QB 0.00969f
C2573 csel5 rc1/WL 0
C2574 rh0 c_0_0/QB 0
C2575 rc8/s/n3/a_162_47# rh2 0.01096f
C2576 c_9_9/Q c_10_9/QB 0
C2577 csel3 cl1 0.02913f
C2578 csel3 VDD 0.02187f
C2579 bl1 rc1/WL 0.00215f
C2580 c_6_9/Q blb8 0.00303f
C2581 rc8/WL c_8_2/QB 0
C2582 ch1 c_1_5/QB 0
C2583 rc0/s/wd/A rc1/WL 0
C2584 pcb c_14_15/Q 0.00166f
C2585 rh1 rc7/WL 0.00372f
C2586 c_12_11/Q rc13/WL 0
C2587 blb11 c_12_12/Q 0.00303f
C2588 ch0 bl0 0.00109f
C2589 bl3 c_12_2/QB 0.00303f
C2590 c_10_1/Q blb0 0.00303f
C2591 bl1 rc10/WL 0.00215f
C2592 c_1_12/Q bl13 0
C2593 c_3_11/QB c_3_10/QB 0
C2594 rc15/WL c_15_8/QB 0
C2595 ch2 csel0 0.03067f
C2596 blb15 cl0 0
C2597 c_3_11/QB bl12 0.00303f
C2598 VDD c_7_6/QB 0.00969f
C2599 rc13/WL blb4 0.00159f
C2600 c_4_15/QB c_3_15/QB 0.0025f
C2601 c_9_6/Q bl7 0
C2602 clkb rc3/WL 0.00509f
C2603 rc12/WL c_11_1/QB 0
C2604 c_0_3/Q dl 0.00931f
C2605 c_0_3/QB dlb 0.004f
C2606 c_12_14/QB c_12_14/Q 0
C2607 bl3 c_11_2/Q 0
C2608 bl13 c_8_12/Q 0
C2609 c_2_13/Q rc1/WL 0
C2610 cl2 dlb 0.02998f
C2611 blb13 dl 0.02104f
C2612 c_15_11/Q c_14_11/Q 0.00654f
C2613 rc13/WL c_13_15/Q 0
C2614 c_11_8/QB rc10/WL 0
C2615 c_7_2/Q rc6/WL 0
C2616 bl9 rc1/WL 0.00159f
C2617 bl0 rc3/s/wd/A 0.00934f
C2618 c_5_2/Q rc6/WL 0
C2619 ch0 c_0_14/QB 0
C2620 c_15_11/Q rc14/WL 0
C2621 c_11_0/QB c_11_1/QB 0
C2622 c_9_13/QB bl14 0.00303f
C2623 rc8/WL c_8_5/Q 0
C2624 c_6_1/Q rc6/WL 0.00103f
C2625 c_0_6/Q rc0/WL 0
C2626 clkb c_13_1/Q 0
C2627 bl9 rc10/WL 0.00159f
C2628 blb2 cl0 0
C2629 c_1_3/Q c_1_4/Q 0
C2630 rc0/WL blb6 0.00289f
C2631 c_1_11/QB VDD 0.00969f
C2632 bl5 c_15_4/QB 0.00303f
C2633 VDD c_13_11/QB 0.00969f
C2634 bl1 rc6/WL 0.00215f
C2635 bl3 rc7/WL 0.00159f
C2636 c_9_3/QB c_8_3/Q 0
C2637 ch1 cs1/n/Y 0
C2638 rc0/s/wd/A rh2 0
C2639 c_10_5/Q rc11/WL 0
C2640 cl3 blb3 0
C2641 blb3 rc14/WL 0.00159f
C2642 bl0 rl1 0.01657f
C2643 c_8_4/QB bl5 0.00303f
C2644 blb2 c_11_3/QB 0
C2645 cs4/n/Y dl 0
C2646 c_1_5/QB c_1_4/QB 0
C2647 csel13 c_1_13/QB 0
C2648 c_7_6/Q c_7_7/QB 0.00377f
C2649 cl2 csel7 0.05854f
C2650 csel14 ch2 0.0368f
C2651 c_5_14/Q rc6/WL 0
C2652 c_13_13/Q c_13_12/QB 0.01135f
C2653 blb6 c_11_7/QB 0
C2654 c_0_2/Q rc1/WL 0
C2655 rc9/s/n3/a_162_47# rc9/s/wd/A -0.00121f
C2656 c_10_5/QB VDD 0.00969f
C2657 csel6 bl6 0.00807f
C2658 c_10_10/Q rc11/WL 0
C2659 c_8_7/QB c_7_7/QB 0.0025f
C2660 rc4/WL c_5_8/Q 0
C2661 c_13_9/QB c_13_10/QB 0
C2662 bl9 rc6/WL 0.00159f
C2663 c_9_11/QB rc10/WL 0
C2664 ch0 blb7 0.00109f
C2665 bl12 rc7/WL 0.00159f
C2666 bl12 c_0_11/Q 0
C2667 blb9 rc2/WL 0.00159f
C2668 blb9 c_15_9/Q 0
C2669 blb1 c_12_2/QB 0
C2670 rc12/WL c_11_13/Q 0
C2671 c_14_8/Q c_14_9/Q 0
C2672 bl2 rc7/WL 0.00175f
C2673 bl11 rc7/WL 0.00159f
C2674 c_7_13/QB c_6_13/QB 0.01281f
C2675 c_12_7/QB c_13_7/Q 0
C2676 c_12_7/Q c_13_7/QB 0
C2677 c_0_15/Q c_1_15/Q 0.00654f
C2678 c_1_13/Q c_2_13/Q 0.00634f
C2679 c_5_6/QB rc4/WL 0
C2680 c_8_5/QB rc9/WL 0
C2681 blb2 c_0_3/Q 0.00303f
C2682 bl15 blb14 2.86379f
C2683 blb1 c_11_2/Q 0.00303f
C2684 rh3 rc12/WL 0.00372f
C2685 rc12/WL c_11_6/Q 0
C2686 rc8/WL c_8_4/QB 0
C2687 c_11_6/QB c_10_6/QB 0.01281f
C2688 c_9_13/QB c_9_14/Q 0.01135f
C2689 c_1_8/Q dl 0.00273f
C2690 c_1_8/QB dlb 0
C2691 c_7_1/Q VDD 0.00756f
C2692 c_8_12/QB rc7/WL 0
C2693 clkb cl0 0.0388f
C2694 c_0_3/QB bl4 0.00303f
C2695 c_1_2/QB csel2 0
C2696 cl1 bl5 0
C2697 c_7_11/QB bl12 0.00303f
C2698 c_11_5/QB blb4 0
C2699 rc12/WL c_13_0/Q 0
C2700 VDD c_4_6/QB 0.00969f
C2701 VDD bl5 -0.00929f
C2702 c_11_15/Q rc10/WL 0
C2703 cl2 bl4 0
C2704 c_13_5/QB rc14/WL 0
C2705 c_2_6/QB c_3_6/QB 0.01281f
C2706 blb1 rc7/WL 0.00178f
C2707 rl3 bl0 0.01657f
C2708 ch2 rh1 0.02782f
C2709 c_7_1/QB c_7_0/QB 0
C2710 c_12_13/Q c_12_12/QB 0.01135f
C2711 c_12_13/QB c_12_12/Q 0.00377f
C2712 pcb dlb 0.02782f
C2713 rl3 rc11/s/n3/a_302_47# 0.00707f
C2714 cl3 csel11 0.04036f
C2715 c_13_2/Q c_13_1/Q 0
C2716 VDD c_0_12/Q 0.00756f
C2717 c_2_3/Q rc3/WL 0
C2718 rc4/WL c_3_5/Q 0
C2719 rl0 rc7/s/n3/a_162_47# 0.0024f
C2720 c_15_4/Q bl5 0
C2721 rl0 rc15/WL 0
C2722 cs9/n/Y dlb 0
C2723 rc1/s/wd/A rl2 0.00155f
C2724 VDD c_12_9/Q 0.00756f
C2725 rc11/WL c_10_2/Q 0
C2726 rh3 rc13/WL 0.00372f
C2727 bl15 c_15_15/Q 0
C2728 bl10 c_6_9/QB 0.00303f
C2729 c_0_7/QB c_1_7/QB 0.01281f
C2730 c_8_0/Q rc8/WL 0.01507f
C2731 rc13/WL c_13_0/Q 0.01507f
C2732 c_11_6/QB blb5 0
C2733 cs2/n/Y ch3 0
C2734 bl10 cl1 0
C2735 c_1_14/Q rc1/WL 0
C2736 c_14_4/Q c_13_4/Q 0.00634f
C2737 c_2_3/Q bl4 0
C2738 rc5/WL c_4_13/Q 0
C2739 bl10 VDD -0.00929f
C2740 bl15 c_12_14/QB 0.00303f
C2741 rc8/WL VDD 0.05907f
C2742 ch1 c_1_7/QB 0
C2743 c_3_11/QB rc2/WL 0
C2744 VDD c_8_13/Q 0.00756f
C2745 ch1 blb14 0
C2746 csel10 cs11/n/Y 0.00301f
C2747 bl3 ch2 0
C2748 c_10_3/QB c_10_2/QB 0
C2749 csel1 ch3 0.02926f
C2750 c_14_15/QB VDD 0.00479f
C2751 cl0 c_0_3/QB 0
C2752 VDD c_0_8/Q 0.00756f
C2753 cl3 ch3 0.36248f
C2754 c_10_0/Q rl2 0
C2755 c_14_8/Q c_14_7/Q 0
C2756 cl2 cl0 0.15197f
C2757 ch1 c_0_0/Q 0
C2758 ch2 c_0_14/Q 0
C2759 c_4_5/Q c_4_6/Q 0
C2760 c_7_10/Q c_6_10/Q 0.00654f
C2761 c_11_14/QB c_12_14/QB 0.0025f
C2762 c_2_10/QB c_2_9/Q 0.00377f
C2763 c_5_13/Q c_6_13/Q 0.00634f
C2764 VDD c_10_13/QB 0.00969f
C2765 c_5_12/Q VDD 0.00756f
C2766 rc8/WL c_9_7/QB 0
C2767 c_5_2/QB c_4_2/QB 0.01281f
C2768 VDD c_4_7/QB 0.00969f
C2769 c_5_7/Q c_4_7/Q 0.00654f
C2770 c_11_13/Q c_11_12/QB 0.01135f
C2771 VDD c_11_7/Q 0.00756f
C2772 c_10_4/Q c_10_3/QB 0.01135f
C2773 c_0_6/Q ch0 0
C2774 rl0 c_4_0/QB 0
C2775 rc5/WL c_6_6/QB 0
C2776 c_8_11/Q rc9/WL 0
C2777 ch0 blb6 0.00109f
C2778 ch2 bl12 0
C2779 c_15_12/Q bl12 0
C2780 blb12 c_13_13/QB 0
C2781 c_13_10/QB c_12_10/QB 0.01281f
C2782 rc8/WL c_8_14/QB 0
C2783 c_4_14/QB c_3_14/QB 0.0025f
C2784 c_8_14/QB c_8_13/Q 0.00377f
C2785 bl2 ch2 0
C2786 ch2 bl11 0
C2787 c_8_0/QB rc9/WL 0
C2788 c_1_10/QB c_0_10/Q 0
C2789 c_1_10/Q c_0_10/QB 0
C2790 c_10_9/Q rc10/WL 0
C2791 rc5/WL c_4_12/Q 0
C2792 bl13 c_7_12/QB 0.00303f
C2793 blb9 c_3_10/Q 0.00303f
C2794 c_4_14/Q c_4_13/Q 0
C2795 c_7_3/Q c_7_2/Q 0
C2796 c_4_9/QB VDD 0.00969f
C2797 c_6_5/QB c_5_5/Q 0
C2798 c_7_13/Q rc6/WL 0
C2799 pcb bl4 0.07118f
C2800 c_1_13/Q c_1_14/Q 0
C2801 c_2_13/QB blb12 0
C2802 rc6/WL c_5_1/QB 0
C2803 c_8_6/Q rc7/WL 0
C2804 c_3_1/QB rc3/WL 0
C2805 rc8/WL c_7_15/Q 0
C2806 rc10/s/n3/a_302_47# rl2 0.00707f
C2807 cl2 blb13 0
C2808 c_15_6/Q blb6 0
C2809 rc12/s/wd/A rh2 0
C2810 csel4 ch2 0.02936f
C2811 bl8 ch3 0
C2812 rc9/s/n3/a_162_47# rl1 0.01123f
C2813 c_13_6/Q c_13_7/QB 0.00377f
C2814 c_13_6/QB c_13_7/Q 0.01135f
C2815 c_1_1/QB c_1_0/QB 0
C2816 c_4_8/Q c_3_8/QB 0
C2817 c_11_6/QB c_11_5/Q 0.00377f
C2818 c_11_6/Q c_11_5/QB 0.01135f
C2819 ch2 blb1 0
C2820 rl1 rc5/s/n3/a_302_47# 0.00707f
C2821 c_9_12/Q c_9_11/QB 0.01135f
C2822 c_9_2/QB c_9_3/Q 0.01135f
C2823 c_5_12/QB c_5_13/Q 0.01135f
C2824 c_13_13/QB c_13_12/Q 0.00377f
C2825 rc11/s/wd/A rl2 0.00262f
C2826 c_10_5/Q rc9/WL 0
C2827 c_7_8/Q c_7_9/QB 0.00377f
C2828 rc0/WL bl14 0.00289f
C2829 cs0/n/Y ch3 0
C2830 cs4/n/Y cl2 0
C2831 bl7 blb7 -0.00665f
C2832 rl3 rc4/s/n3/a_162_47# 0.0024f
C2833 c_4_13/QB blb12 0
C2834 blb9 rc15/WL 0.00298f
C2835 c_4_6/Q c_4_7/Q 0
C2836 c_10_10/Q rc9/WL 0
C2837 pcb cl0 0.02782f
C2838 c_14_14/Q bl15 0
C2839 blb11 rc1/WL 0.00159f
C2840 c_15_7/Q c_15_8/Q 0
C2841 c_14_10/QB c_13_10/QB 0.0025f
C2842 blb5 c_8_6/Q 0.00303f
C2843 cl0 cs9/n/Y 0.0472f
C2844 rc2/s/n3/a_162_47# rh0 0.01115f
C2845 c_12_7/QB blb6 0
C2846 c_6_8/QB c_7_8/QB 0.01281f
C2847 rc12/WL c_12_2/Q 0
C2848 rc2/WL blb5 0.00159f
C2849 rc1/s/wd/A rh1 0
C2850 c_3_11/QB c_3_10/Q 0.00377f
C2851 c_4_3/QB VDD 0.00969f
C2852 blb11 rc10/WL 0.00159f
C2853 c_7_10/Q c_8_10/QB 0
C2854 cl1 dl 0.03158f
C2855 VDD dl 0.23218f
C2856 clkb c_3_1/Q 0
C2857 bl1 rc5/s/wd/A 0
C2858 c_5_14/Q bl15 0
C2859 VDD c_3_6/QB 0.00969f
C2860 c_1_2/QB c_1_1/Q 0.00377f
C2861 rc11/WL c_12_5/Q 0
C2862 rc1/s/wd/A rc1/s/n3/a_302_47# -0
C2863 clkb rc2/s/wd/A 0.09749f
C2864 c_1_8/Q c_1_9/Q 0
C2865 rc8/WL c_9_14/QB 0
C2866 blb10 c_9_11/QB 0
C2867 c_1_1/QB rc1/WL 0
C2868 c_4_8/Q c_4_7/Q 0
C2869 VDD c_12_5/QB 0.00969f
C2870 bl9 c_11_8/Q 0
C2871 c_15_10/Q rc14/WL 0
C2872 rc5/WL c_4_0/QB 0
C2873 rc4/s/wd/A rc3/s/wd/A 0.02007f
C2874 blb11 rc6/WL 0.00159f
C2875 c_15_3/QB rc14/WL 0
C2876 c_12_2/Q rc13/WL 0
C2877 c_12_11/Q c_11_11/Q 0.00634f
C2878 bl3 c_9_2/QB 0.00303f
C2879 c_15_6/Q c_15_5/Q 0
C2880 bl13 c_2_12/QB 0.00303f
C2881 c_2_0/Q rh0 0
C2882 pcb blb13 0.07118f
C2883 VDD rc15/s/n3/a_302_47# -0
C2884 c_9_0/Q c_10_0/Q 0.00634f
C2885 c_9_1/QB c_9_2/QB 0
C2886 cl1 blb15 0
C2887 c_2_12/Q c_3_12/QB 0
C2888 rc11/WL c_10_11/Q 0
C2889 rc9/WL c_10_2/Q 0
C2890 rc0/s/n3/a_162_47# rc0/s/wd/A -0.00121f
C2891 VDD blb15 -0.07738f
C2892 c_10_4/Q c_9_4/QB 0
C2893 ch1 csel5 0.31115f
C2894 c_6_6/QB rc7/WL 0
C2895 rc14/WL c_14_3/QB 0
C2896 c_4_9/Q c_4_8/Q 0
C2897 rc4/s/wd/A rl1 0.00312f
C2898 c_9_13/Q blb12 0.00303f
C2899 c_0_1/Q rc0/WL 0.00103f
C2900 rl3 c_15_0/QB 0
C2901 bl9 c_13_8/QB 0.00303f
C2902 VDD c_10_12/Q 0.00756f
C2903 ch1 rc0/s/wd/A 0
C2904 ch1 bl1 0
C2905 VDD c_7_6/Q 0.00756f
C2906 VDD c_10_11/QB 0.00969f
C2907 c_0_6/Q c_1_6/Q 0.00654f
C2908 rh0 ch3 0.02794f
C2909 c_9_1/Q c_8_1/QB 0
C2910 c_9_1/QB c_8_1/Q 0
C2911 c_8_13/QB c_8_12/Q 0.00377f
C2912 blb2 cl1 0
C2913 rc2/WL csel9 0
C2914 rc11/WL bl4 0.00159f
C2915 blb2 VDD -0.0098f
C2916 c_7_1/Q blb0 0.00303f
C2917 c_1_6/QB rc2/WL 0
C2918 c_7_0/Q rc7/WL 0.01507f
C2919 ch2 c_0_5/QB 0
C2920 c_9_15/Q rc10/WL 0
C2921 VDD c_8_7/QB 0.00969f
C2922 c_8_5/QB c_9_5/QB 0.01281f
C2923 rc7/s/n3/a_302_47# rc7/s/wd/A -0
C2924 c_15_15/QB rc14/WL 0
C2925 c_4_1/Q c_4_2/Q 0
C2926 c_6_9/Q rc5/WL 0
C2927 VDD c_13_1/QB 0.00969f
C2928 c_1_0/QB rc1/WL 0.00535f
C2929 c_0_6/Q bl7 0
C2930 ch1 bl9 0
C2931 c_4_6/Q c_3_6/Q 0.00634f
C2932 blb6 bl7 2.86379f
C2933 c_1_5/Q rc1/WL 0
C2934 c_2_3/QB c_2_4/Q 0.01135f
C2935 c_2_3/Q c_2_4/QB 0.00377f
C2936 c_2_7/QB c_3_7/Q 0
C2937 c_2_7/Q c_3_7/QB 0
C2938 c_14_13/QB blb12 0
C2939 rc4/WL blb12 0.00159f
C2940 bl7 c_8_6/QB 0.00303f
C2941 c_1_8/QB c_1_8/Q -0
C2942 c_13_4/Q bl5 0
C2943 cs1/n/Y cs2/n/Y 0.02812f
C2944 rc0/s/n3/a_302_47# dl 0.00263f
C2945 rc9/s/n3/a_302_47# rc10/s/wd/A 0
C2946 rc2/WL c_2_9/QB 0
C2947 c_2_12/Q c_2_13/Q 0
C2948 c_7_8/Q rc6/WL 0
C2949 c_9_2/Q c_9_3/QB 0.00377f
C2950 c_1_4/Q c_0_4/Q 0.00654f
C2951 c_9_6/Q rc8/WL 0
C2952 bl2 c_8_1/Q 0
C2953 c_5_9/Q c_5_8/Q 0
C2954 c_9_7/QB c_8_7/QB 0.01281f
C2955 c_6_3/QB rc6/WL 0
C2956 c_14_13/QB c_15_13/Q 0
C2957 blb5 c_6_6/QB 0
C2958 blb1 c_9_2/QB 0
C2959 rc11/s/wd/A rh1 0
C2960 cs1/n/Y csel1 0.07585f
C2961 blb1 rc1/s/wd/A 0
C2962 blb6 c_2_7/Q 0.00303f
C2963 c_5_11/Q VDD 0.00756f
C2964 c_11_14/Q c_11_15/QB 0.00377f
C2965 c_11_14/QB c_11_15/Q 0.01135f
C2966 cl3 cs1/n/Y 0.01311f
C2967 c_3_5/QB blb4 0
C2968 c_7_9/QB rc6/WL 0
C2969 ch0 bl14 0.00109f
C2970 rc4/s/wd/A rl3 0.00121f
C2971 c_12_7/Q VDD 0.00756f
C2972 c_10_10/Q c_10_11/Q 0
C2973 ch1 c_0_2/Q 0
C2974 rc2/WL c_2_7/QB 0
C2975 bl14 c_15_13/Q 0
C2976 c_4_5/Q rc3/WL 0
C2977 rc6/WL c_5_4/Q 0
C2978 rc7/s/n3/a_302_47# rh1 0.0045f
C2979 rc8/WL blb0 0.00236f
C2980 c_0_6/QB c_0_5/Q 0.00377f
C2981 c_5_6/QB c_5_5/Q 0.00377f
C2982 clkb c_8_0/Q 0
C2983 c_12_8/QB blb7 0
C2984 c_10_14/QB c_10_13/QB 0
C2985 rc15/WL c_15_6/QB 0
C2986 c_11_9/QB c_11_8/QB 0
C2987 clkb cl1 0.03873f
C2988 c_3_0/QB rc3/WL 0.00535f
C2989 rc4/WL rc3/s/wd/A 0
C2990 clkb VDD 1.69555f
C2991 c_9_10/Q VDD 0.00756f
C2992 c_6_12/QB bl13 0.00303f
C2993 c_3_8/QB rc3/WL 0
C2994 c_4_15/QB blb14 0
C2995 bl3 c_8_2/Q 0
C2996 bl15 c_1_14/Q 0
C2997 ch3 c_0_15/Q 0
C2998 c_11_3/QB rc11/WL 0
C2999 c_4_6/Q rc3/WL 0
C3000 c_13_14/Q blb13 0.00303f
C3001 c_7_1/QB rc7/s/wd/A 0
C3002 rc4/WL rl1 0
C3003 rc9/s/wd/A rl2 0.00155f
C3004 c_14_5/Q pcb 0.00166f
C3005 c_8_10/Q c_8_11/QB 0.00377f
C3006 c_2_8/Q c_2_9/Q 0
C3007 c_13_9/QB c_13_10/Q 0.01135f
C3008 c_9_6/QB rc9/WL 0
C3009 rc0/WL csel0 0.02369f
C3010 blb11 c_9_12/Q 0.00303f
C3011 cs6/n/Y cs6/n/a_162_47# -0
C3012 ch2 c_0_9/QB 0
C3013 rl3 c_7_0/QB 0
C3014 csel6 dl 0.08427f
C3015 blb7 c_8_8/Q 0.00303f
C3016 rc5/WL c_4_1/Q 0
C3017 rh3 c_12_0/Q 0
C3018 c_0_1/QB dl 0.0049f
C3019 c_2_8/Q c_2_7/Q 0
C3020 rc5/s/wd/A c_5_1/QB 0
C3021 rc15/WL blb5 0.00298f
C3022 csel9 c_0_9/QB 0
C3023 pcb rc2/s/wd/A 0
C3024 c_5_11/QB rc4/WL 0
C3025 c_9_12/QB c_10_12/QB 0.0025f
C3026 c_13_0/Q c_12_0/Q 0.00654f
C3027 rc11/WL blb13 0.00159f
C3028 blb3 c_1_4/Q 0.00303f
C3029 c_4_8/Q rc3/WL 0
C3030 c_12_0/QB c_12_1/Q 0.01135f
C3031 bl1 c_13_0/QB 0.00303f
C3032 c_15_10/Q c_14_10/Q 0.00654f
C3033 c_14_14/QB rc13/WL 0
C3034 VDD c_0_3/QB 0.00969f
C3035 c_3_9/QB blb8 0
C3036 VDD c_1_9/Q 0.00756f
C3037 cl1 cl2 4.29175f
C3038 c_10_7/Q c_10_6/QB 0.01135f
C3039 cl2 VDD 0.44519f
C3040 cs1/n/Y cs0/n/Y 0.02812f
C3041 csel14 rc0/WL 0.02369f
C3042 bl6 blb6 -0.00665f
C3043 c_10_0/QB rc10/s/wd/A 0.00246f
C3044 clkb c_3_0/Q 0
C3045 cs9/n/Y cs9/n/a_162_47# -0
C3046 c_0_1/Q ch0 0
C3047 csel8 c_0_8/Q 0.00119f
C3048 rc2/WL rc1/s/wd/A 0
C3049 c_6_0/Q VDD 0.01304f
C3050 csel15 c_1_15/Q 0
C3051 blb1 c_8_2/Q 0.00303f
C3052 c_4_7/Q rc3/WL 0
C3053 c_12_6/Q rc12/WL 0
C3054 rh2 rc10/WL 0.00372f
C3055 c_6_6/Q rc6/WL 0
C3056 rc5/WL c_6_15/QB 0
C3057 rc14/WL blb14 0.00159f
C3058 VDD c_13_2/Q 0.00756f
C3059 c_12_15/QB c_12_15/Q 0
C3060 rc11/s/wd/A blb1 0
C3061 cl3 blb14 0
C3062 c_6_9/Q rc7/WL 0
C3063 c_1_13/Q rc1/WL 0
C3064 clkb rc0/s/n3/a_302_47# 0.00463f
C3065 c_6_0/QB c_7_0/QB 0.01281f
C3066 c_1_1/Q c_1_0/Q 0
C3067 rc5/WL c_4_10/QB 0
C3068 c_7_3/QB c_7_2/QB 0
C3069 rc15/WL c_15_12/Q 0
C3070 pcb c_15_4/QB 0.00493f
C3071 c_10_5/Q c_9_5/QB 0
C3072 blb3 rc12/WL 0.00159f
C3073 rh2 rc10/s/n3/a_162_47# 0.01115f
C3074 c_0_7/Q ch3 0
C3075 rl0 rc6/s/wd/A 0.00281f
C3076 c_6_11/Q bl12 0
C3077 c_14_6/Q c_15_6/Q 0.00654f
C3078 c_10_11/Q rc9/WL 0
C3079 c_2_3/Q VDD 0.00756f
C3080 blb9 c_4_10/QB 0
C3081 c_4_9/Q rc3/WL 0
C3082 c_14_12/Q c_13_12/Q 0.00634f
C3083 c_1_7/Q rc1/WL 0
C3084 c_6_5/QB c_6_6/QB 0
C3085 rl0 rh3 0.36262f
C3086 c_0_9/Q blb8 0.00303f
C3087 c_5_9/QB bl10 0.00303f
C3088 rc5/WL blb4 0.00159f
C3089 c_7_9/Q c_7_8/QB 0.01135f
C3090 c_12_13/QB c_12_14/Q 0.01135f
C3091 c_12_13/Q c_12_14/QB 0.00377f
C3092 bl13 c_12_12/QB 0.00303f
C3093 csel10 csel11 0.02813f
C3094 csel14 cs14/n/Y 0.07585f
C3095 c_10_3/Q c_9_3/Q 0.00634f
C3096 c_8_7/Q rc9/WL 0
C3097 dl blb0 0.02104f
C3098 c_6_10/QB c_5_10/QB 0.0025f
C3099 c_11_1/Q rc10/WL 0
C3100 ch2 cs5/n/Y 0
C3101 blb9 c_0_10/QB 0
C3102 bl13 ch3 0
C3103 c_13_6/Q VDD 0.00756f
C3104 c_12_6/Q rc13/WL 0
C3105 rc12/WL c_11_15/QB 0
C3106 rc5/WL c_5_13/Q 0
C3107 c_15_8/Q c_15_9/Q 0
C3108 rc9/WL bl4 0.00159f
C3109 ch0 rl2 0.02782f
C3110 c_3_4/Q bl5 0
C3111 rc4/WL c_5_4/QB 0
C3112 blb3 c_6_4/QB 0
C3113 pcb c_15_5/QB 0.00493f
C3114 c_12_6/QB blb5 0
C3115 c_14_2/Q c_13_2/QB 0
C3116 c_14_2/QB c_13_2/Q 0
C3117 rc8/WL bl0 0.06726f
C3118 c_14_11/QB c_14_10/QB 0
C3119 VDD rc14/s/wd/A -0.00408f
C3120 rc14/WL c_15_15/Q 0
C3121 c_13_1/QB c_12_1/QB 0.01281f
C3122 c_2_14/QB c_2_13/Q 0.00377f
C3123 blb3 rc13/WL 0.00159f
C3124 c_4_11/QB rc3/WL 0
C3125 VDD c_1_8/QB 0.00969f
C3126 bl2 c_7_1/QB 0.00303f
C3127 c_12_10/QB c_13_10/Q 0
C3128 ch2 cs8/n/Y 0.09756f
C3129 bl8 c_1_7/QB 0.00303f
C3130 c_14_5/QB c_15_5/QB 0.01281f
C3131 c_3_3/Q c_3_4/QB 0.00377f
C3132 rc4/WL bl7 0.00159f
C3133 c_7_3/Q c_6_3/QB 0
C3134 c_8_5/QB c_8_4/QB 0
C3135 csel7 dlb 0.10216f
C3136 csel10 ch3 0.02926f
C3137 rl2 rc3/s/wd/A 0.00262f
C3138 c_13_14/QB c_13_13/QB 0
C3139 rc12/WL c_13_5/QB 0
C3140 c_0_13/Q ch3 0
C3141 pcb cl1 0.02782f
C3142 cs8/n/Y csel9 0
C3143 c_9_7/Q rc10/WL 0
C3144 c_0_11/QB csel11 0
C3145 pcb VDD 1.97663f
C3146 c_5_14/QB rc6/WL 0
C3147 rc9/s/wd/A rh1 0
C3148 bl6 c_15_5/Q 0
C3149 cl1 cs9/n/Y 0.04813f
C3150 bl3 rc0/WL 0.00289f
C3151 c_14_6/QB c_14_7/Q 0.01135f
C3152 c_14_1/Q rc14/WL 0.00103f
C3153 VDD cs9/n/Y 0.01448f
C3154 c_2_11/QB rc1/WL 0
C3155 c_7_14/QB c_7_15/QB 0
C3156 ch0 csel0 0.31814f
C3157 c_4_9/QB c_5_9/QB 0.01281f
C3158 c_9_0/Q rc9/s/wd/A 0
C3159 rl1 rl2 3.64313f
C3160 c_11_9/QB c_10_9/Q 0
C3161 c_11_9/Q c_10_9/QB 0
C3162 c_1_12/QB c_0_12/QB 0.01281f
C3163 c_4_3/Q rc3/WL 0
C3164 c_14_5/QB VDD 0.00969f
C3165 rc0/WL c_0_14/Q 0
C3166 pcb c_14_7/QB 0.00169f
C3167 c_8_10/Q c_7_10/QB 0
C3168 c_7_6/QB c_8_6/QB 0.0025f
C3169 c_3_3/QB c_3_2/Q 0.00377f
C3170 c_3_3/Q c_3_2/QB 0.01135f
C3171 c_15_11/QB c_15_12/Q 0.01135f
C3172 c_15_11/Q c_15_12/QB 0.00377f
C3173 c_14_8/QB c_15_8/Q 0
C3174 pcb c_15_4/Q 0.00484f
C3175 c_13_3/QB c_14_3/QB 0.0025f
C3176 VDD c_7_12/Q 0.00756f
C3177 c_3_6/Q rc3/WL 0
C3178 c_5_11/Q c_4_11/Q 0.00654f
C3179 rc11/WL c_12_15/Q 0
C3180 c_15_2/QB rc14/WL 0
C3181 ch1 blb11 0
C3182 rc6/WL c_7_5/QB 0
C3183 c_0_2/QB csel2 0
C3184 dl csel8 0.08427f
C3185 VDD c_3_1/QB 0.00969f
C3186 c_14_4/QB c_13_4/QB 0.0025f
C3187 rh3 rc8/s/wd/A 0
C3188 rc13/WL c_13_5/QB 0
C3189 rl0 rc10/s/wd/A 0.00281f
C3190 c_8_11/QB rc7/WL 0
C3191 rc5/WL c_5_0/Q 0.01507f
C3192 c_13_1/QB blb0 0
C3193 rc0/WL c_1_3/QB 0
C3194 rc0/WL bl12 0.00289f
C3195 c_4_3/Q bl4 0
C3196 VDD c_14_0/QB 0.01264f
C3197 VDD c_12_15/QB 0.00479f
C3198 rc12/WL c_12_12/QB 0
C3199 c_9_12/Q rc10/WL 0
C3200 VDD c_8_5/QB 0.00969f
C3201 dlb bl4 0
C3202 ch3 c_0_11/QB 0
C3203 rc8/WL blb7 0.00159f
C3204 bl2 rc0/WL 0.00305f
C3205 rc0/WL bl11 0.00289f
C3206 c_2_12/Q blb11 0.00303f
C3207 c_14_2/QB pcb 0.00169f
C3208 csel10 c_0_10/Q 0.00119f
C3209 c_9_1/QB rc9/s/wd/A 0
C3210 rh3 rc13/s/n3/a_162_47# 0.01115f
C3211 rc0/WL c_1_12/QB 0
C3212 cs2/n/Y cs1/n/a_162_47# 0
C3213 blb7 c_0_8/Q 0.00303f
C3214 rc5/WL c_5_3/Q 0
C3215 c_14_10/QB c_13_10/Q 0
C3216 csel14 ch0 0.03716f
C3217 c_0_14/Q c_0_15/QB 0.00377f
C3218 blb9 c_7_10/QB 0
C3219 c_7_11/QB c_8_11/QB 0.0025f
C3220 rc5/WL rc6/s/wd/A 0
C3221 c_14_11/QB blb10 0
C3222 c_6_15/QB rc7/WL 0
C3223 csel4 rc0/WL 0.02369f
C3224 rc2/WL c_3_5/Q 0
C3225 c_11_6/QB c_11_7/QB 0
C3226 cl3 cs1/n/a_162_47# 0
C3227 csel6 cl2 0.03033f
C3228 rc9/WL c_9_5/QB 0
C3229 c_6_3/Q bl4 0
C3230 c_6_15/QB c_6_14/QB 0
C3231 c_10_14/Q c_10_13/QB 0.01135f
C3232 blb13 rc9/WL 0.00159f
C3233 rc0/WL blb1 0.00308f
C3234 c_5_10/Q c_5_11/Q 0
C3235 rl3 rl2 3.6321f
C3236 c_7_4/Q c_8_4/QB 0
C3237 rc13/WL c_12_12/QB 0
C3238 c_4_5/QB rc4/WL 0
C3239 rc14/s/n3/a_162_47# VDD 0
C3240 c_14_6/Q bl7 0
C3241 c_2_4/Q bl5 0
C3242 c_15_6/Q c_15_7/Q 0
C3243 clkb blb0 0
C3244 rc7/WL blb4 0.00159f
C3245 bl1 rc15/s/wd/A 0
C3246 blb10 rc1/WL 0.00159f
C3247 c_2_14/QB c_1_14/Q 0
C3248 cl3 csel5 0.03848f
C3249 c_0_11/Q c_0_10/QB 0.01135f
C3250 c_0_11/QB c_0_10/Q 0.00377f
C3251 c_2_10/Q c_3_10/QB 0
C3252 cl0 dlb 0.03157f
C3253 c_3_0/Q c_3_1/QB 0.00377f
C3254 c_3_0/QB c_3_1/Q 0.01135f
C3255 bl6 rc4/WL 0.00159f
C3256 c_14_14/Q rc14/WL 0
C3257 cs14/n/a_162_47# ch3 0.00134f
C3258 bl0 dl 0.04919f
C3259 bl4 rc3/WL 0.00159f
C3260 c_4_4/QB blb3 0
C3261 c_13_14/Q VDD 0.00756f
C3262 bl1 csel1 0.00807f
C3263 bl1 rc14/WL 0.00215f
C3264 blb10 rc10/WL 0.00159f
C3265 cl3 rc0/s/wd/A 0
C3266 cl3 bl1 0
C3267 bl11 c_2_10/Q 0
C3268 c_7_3/Q c_8_3/QB 0
C3269 bl3 c_10_2/QB 0.00303f
C3270 ch0 rh1 0.02782f
C3271 blb5 c_2_6/Q 0.00303f
C3272 rl1 rc7/s/wd/A 0.00205f
C3273 blb1 rc9/s/wd/A 0
C3274 c_13_9/QB c_13_8/QB 0
C3275 c_6_12/QB c_6_13/Q 0.01135f
C3276 c_11_1/QB c_11_2/Q 0.01135f
C3277 cs4/n/a_162_47# cl0 0.00134f
C3278 c_6_8/QB c_6_9/QB 0
C3279 rl0 c_0_0/QB 0
C3280 rh0 c_0_0/Q 0
C3281 csel13 rc1/WL 0
C3282 blb3 c_12_4/QB 0
C3283 c_9_9/Q c_10_9/Q 0.00634f
C3284 VDD c_6_8/QB 0.00969f
C3285 c_9_6/QB c_9_5/QB 0
C3286 c_13_6/QB c_14_6/Q 0
C3287 ch1 c_1_5/Q 0
C3288 csel7 cl0 0.02918f
C3289 c_0_14/QB dl 0.0049f
C3290 rc4/WL c_5_15/QB 0
C3291 c_7_3/Q rc6/WL 0
C3292 rc11/WL c_10_8/QB 0
C3293 ch1 cs15/n/Y 0
C3294 c_7_4/Q VDD 0.00756f
C3295 cl3 bl9 0
C3296 bl15 rc1/WL 0.00159f
C3297 c_3_15/Q rc3/WL 0
C3298 bl9 rc14/WL 0.00159f
C3299 rh1 rc3/s/wd/A 0.00114f
C3300 c_4_15/Q c_3_15/QB 0
C3301 c_6_0/QB rl2 0
C3302 rc15/s/n3/a_302_47# bl0 0.00159f
C3303 blb3 c_11_4/QB 0
C3304 VDD c_8_11/Q 0.00756f
C3305 blb10 rc6/WL 0.00159f
C3306 VDD rc8/s/n3/a_302_47# -0
C3307 rc15/WL c_15_8/Q 0
C3308 rc11/WL VDD 0.05907f
C3309 c_5_6/QB c_6_6/QB 0.0025f
C3310 c_11_12/QB c_12_12/QB 0.0025f
C3311 c_2_5/QB c_3_5/QB 0.01281f
C3312 bl15 rc10/WL 0.00159f
C3313 c_0_3/Q dlb 0
C3314 c_7_8/QB c_7_7/QB 0
C3315 c_2_1/QB c_3_1/QB 0.01281f
C3316 bl3 ch0 0.00109f
C3317 blb13 dlb 0.0282f
C3318 c_0_4/QB rc1/WL 0
C3319 c_8_0/QB VDD 0.01264f
C3320 c_11_8/Q rc10/WL 0
C3321 cl2 blb0 0
C3322 csel2 ch3 0.02926f
C3323 rc8/WL blb6 0.00159f
C3324 rh1 rl1 0.41099f
C3325 rc8/WL c_8_6/QB 0
C3326 c_5_7/Q VDD 0.00756f
C3327 bl10 c_15_9/QB 0.00303f
C3328 ch0 c_0_14/Q 0
C3329 c_4_7/QB c_3_7/QB 0.0025f
C3330 c_11_0/Q c_11_1/QB 0.00377f
C3331 c_9_0/Q rl1 0
C3332 c_11_14/QB rc10/WL 0
C3333 blb7 dl 0.02104f
C3334 c_1_11/Q VDD 0.00756f
C3335 c_11_13/QB blb12 0
C3336 VDD c_13_11/Q 0.00756f
C3337 pcb c_14_12/QB 0.00169f
C3338 rc1/s/n3/a_302_47# rl1 0.00707f
C3339 bl12 blb12 -0.00665f
C3340 blb14 c_0_15/Q 0.00303f
C3341 rl3 rc7/s/wd/A 0.05286f
C3342 c_8_2/QB rc9/WL 0
C3343 c_10_10/QB bl11 0.00303f
C3344 c_6_12/QB c_5_12/QB 0.0025f
C3345 bl15 rc6/WL 0.00159f
C3346 blb2 c_11_3/Q 0.00303f
C3347 cs4/n/Y dlb 0
C3348 cl0 bl4 0
C3349 c_1_5/Q c_1_4/QB 0.01135f
C3350 c_1_5/QB c_1_4/Q 0.00377f
C3351 c_8_4/Q bl5 0
C3352 c_10_2/QB blb1 0
C3353 csel13 c_1_13/Q 0
C3354 c_7_7/Q c_7_6/QB 0.01135f
C3355 ch0 c_1_3/QB 0
C3356 ch0 bl12 0.00109f
C3357 blb6 c_4_7/QB 0
C3358 blb6 c_11_7/Q 0.00303f
C3359 c_0_7/QB rc1/WL 0
C3360 bl2 ch0 0.00109f
C3361 c_1_6/QB c_2_6/Q 0
C3362 c_11_13/QB c_11_12/Q 0.00377f
C3363 bl11 ch0 0.00109f
C3364 c_10_5/Q VDD 0.00756f
C3365 rc5/s/wd/A rc6/WL 0
C3366 c_11_3/QB bl4 0.00303f
C3367 c_7_10/QB rc7/WL 0
C3368 rc5/s/wd/A rh2 0
C3369 c_8_7/Q c_7_7/QB 0
C3370 c_0_6/QB ch3 0
C3371 rc0/WL c_0_5/QB 0
C3372 cs4/n/Y cs4/n/a_162_47# -0
C3373 cs7/n/Y cs7/n/a_162_47# -0
C3374 c_5_0/QB rl1 0
C3375 rc6/s/wd/A rc7/WL 0
C3376 bl5 c_15_5/Q 0
C3377 ch2 blb4 0
C3378 ch2 c_0_10/QB 0
C3379 bl10 c_14_9/Q 0
C3380 blb13 rc3/WL 0.00159f
C3381 c_12_7/Q c_13_7/Q 0.00654f
C3382 c_7_13/Q c_6_13/QB 0
C3383 c_7_13/QB c_6_13/Q 0
C3384 c_10_10/Q VDD 0.00756f
C3385 csel4 ch0 0.0748f
C3386 c_4_5/Q VDD 0.00756f
C3387 c_8_5/Q rc9/WL 0
C3388 c_2_12/Q rc1/WL 0
C3389 c_4_5/Q c_5_5/QB 0
C3390 rl3 rh1 0.4961f
C3391 blb0 rc14/s/wd/A 0
C3392 ch0 blb1 0.00109f
C3393 VDD c_3_0/QB 0.01264f
C3394 c_7_11/QB c_7_10/QB 0
C3395 c_11_6/Q c_10_6/QB 0
C3396 c_11_6/QB c_10_6/Q 0
C3397 cl2 csel8 0.0291f
C3398 rc8/WL c_8_4/Q 0
C3399 c_5_14/QB bl15 0.00303f
C3400 c_8_12/Q rc7/WL 0
C3401 cs10/n/Y cs11/n/Y 0.02812f
C3402 c_1_2/Q csel2 0
C3403 c_0_3/Q bl4 0
C3404 VDD c_3_8/QB 0.00969f
C3405 clkb bl0 0.15063f
C3406 c_7_11/Q bl12 0
C3407 c_15_7/Q bl7 0
C3408 c_13_10/QB rc14/WL 0
C3409 c_11_5/Q blb4 0.00303f
C3410 c_2_6/Q c_2_7/QB 0.00377f
C3411 VDD c_4_6/Q 0.00756f
C3412 clkb rc11/s/n3/a_302_47# 0.00768f
C3413 rc2/WL c_2_10/Q 0
C3414 c_2_11/QB blb10 0
C3415 ch3 blb8 0
C3416 c_13_5/Q rc14/WL 0
C3417 rc0/WL c_1_15/QB 0
C3418 c_2_6/QB c_3_6/Q 0
C3419 c_10_9/QB blb8 0
C3420 cs8/n/Y cs8/n/a_162_47# -0
C3421 ch3 csel15 0.26689f
C3422 c_7_1/QB c_7_0/Q 0.00377f
C3423 c_7_1/Q c_7_0/QB 0.01135f
C3424 blb11 c_10_12/QB 0
C3425 ch1 rh2 0.02782f
C3426 c_12_13/Q c_12_12/Q 0
C3427 blb1 rc3/s/wd/A 0
C3428 pcb blb0 0.07118f
C3429 c_1_4/QB rc1/WL 0
C3430 rc13/WL c_14_3/QB 0
C3431 c_12_3/QB c_12_2/Q 0.00377f
C3432 c_7_13/QB c_8_13/QB 0.0025f
C3433 c_5_11/QB bl12 0.00303f
C3434 bl1 c_9_0/QB 0.00303f
C3435 c_9_4/QB bl5 0.00303f
C3436 c_3_6/QB c_3_7/QB 0
C3437 c_11_9/QB rc10/WL 0
C3438 c_0_7/QB c_1_7/Q 0
C3439 c_0_7/Q c_1_7/QB 0
C3440 rc12/WL c_11_2/QB 0
C3441 c_11_6/Q blb5 0.00303f
C3442 VDD c_10_2/Q 0.00756f
C3443 VDD c_4_8/Q 0.00756f
C3444 c_7_14/QB c_7_13/QB 0
C3445 c_8_4/QB rc9/WL 0
C3446 bl15 c_12_14/Q 0
C3447 ch1 c_1_7/Q 0
C3448 c_0_6/Q dl 0.00931f
C3449 c_0_9/QB c_0_8/QB 0
C3450 blb0 c_3_1/QB 0
C3451 VDD c_13_9/Q 0.00756f
C3452 blb6 dl 0.02104f
C3453 rc10/WL c_11_10/Q 0
C3454 rc0/WL c_0_9/QB 0
C3455 rc6/s/n3/a_162_47# VDD 0
C3456 c_5_5/Q c_5_4/QB 0.01135f
C3457 c_0_15/QB c_1_15/QB 0.01281f
C3458 c_6_0/QB rh1 0
C3459 c_6_5/QB blb4 0
C3460 rh0 rc0/s/wd/A 0.03707f
C3461 c_14_15/Q VDD 0.00565f
C3462 cl0 c_0_3/Q 0
C3463 c_9_10/QB bl11 0.00303f
C3464 blb13 cl0 0
C3465 cl2 bl0 0
C3466 c_2_6/QB rc3/WL 0
C3467 rc8/WL c_7_0/QB 0
C3468 c_11_14/Q c_12_14/QB 0
C3469 c_11_14/QB c_12_14/Q 0
C3470 c_1_8/QB csel8 0
C3471 rc4/WL bl5 0.00159f
C3472 c_4_6/QB rc4/WL 0
C3473 ch2 cs13/n/Y 0
C3474 c_14_8/Q c_14_9/QB 0.00377f
C3475 c_9_1/QB c_10_1/Q 0
C3476 c_9_4/QB rc8/WL 0
C3477 rc8/WL c_9_13/Q 0
C3478 rc2/WL blb12 0.00159f
C3479 c_5_2/QB c_4_2/Q 0
C3480 c_5_2/Q c_4_2/QB 0
C3481 VDD c_4_7/Q 0.00756f
C3482 c_0_13/Q c_1_13/QB 0
C3483 c_9_13/Q c_8_13/Q 0.00654f
C3484 rl0 c_4_0/Q 0
C3485 c_5_12/Q c_4_12/QB 0
C3486 pcb c_15_7/QB 0.00493f
C3487 c_2_4/QB rc3/WL 0
C3488 c_7_7/Q rc8/WL 0
C3489 blb12 c_13_13/Q 0.00303f
C3490 rc8/WL c_8_14/Q 0
C3491 c_13_10/QB c_12_10/Q 0
C3492 c_10_8/QB rc9/WL 0
C3493 c_8_14/Q c_8_13/Q 0
C3494 cs4/n/Y cl0 0.04796f
C3495 c_4_14/Q c_3_14/QB 0
C3496 c_8_0/Q rc9/WL 0
C3497 ch2 rh3 0.02852f
C3498 rc11/WL c_12_1/QB 0
C3499 cs9/n/Y csel8 0.00301f
C3500 c_1_10/Q c_0_10/Q 0.00654f
C3501 c_10_1/QB rc11/WL 0
C3502 c_6_0/QB c_5_0/QB 0.0025f
C3503 VDD rc9/WL 0.05907f
C3504 c_9_13/Q c_10_13/QB 0
C3505 c_5_4/QB c_5_3/QB 0
C3506 c_4_9/Q VDD 0.00756f
C3507 c_6_5/Q c_5_5/Q 0.00634f
C3508 bl3 c_13_2/QB 0.00303f
C3509 c_14_8/Q rc15/WL 0
C3510 c_12_10/QB c_11_10/Q 0
C3511 c_3_1/Q rc3/WL 0.00103f
C3512 bl2 c_10_1/Q 0
C3513 rc6/s/n3/a_302_47# rc5/s/wd/A 0
C3514 ch2 cs6/n/Y 0
C3515 bl10 rc4/WL 0.00159f
C3516 c_7_6/Q c_8_6/QB 0
C3517 ch0 c_0_5/QB 0
C3518 rc2/s/wd/A rc3/WL 0
C3519 rc2/WL rc3/s/wd/A 0
C3520 c_6_12/QB c_6_11/QB 0
C3521 c_13_6/Q c_13_7/Q 0
C3522 c_4_8/Q c_3_8/Q 0.00634f
C3523 c_11_6/Q c_11_5/Q 0
C3524 c_12_2/Q c_12_2/QB 0
C3525 blb6 c_8_7/QB 0
C3526 c_9_7/QB rc9/WL 0
C3527 rc8/WL bl14 0.00159f
C3528 c_8_6/QB c_8_7/QB 0
C3529 c_2_12/Q c_2_11/QB 0.01135f
C3530 c_8_13/Q bl14 0
C3531 c_2_3/QB c_2_2/QB 0
C3532 c_2_10/Q c_3_10/Q 0.00654f
C3533 blb2 c_10_3/QB 0
C3534 cl2 blb7 0
C3535 VDD c_4_11/QB 0.00969f
C3536 bl0 rc14/s/wd/A 0.00934f
C3537 c_13_13/Q c_13_12/Q 0
C3538 rc2/WL rl1 0
C3539 c_12_2/Q c_11_2/Q 0.00634f
C3540 c_7_9/Q c_6_9/QB 0
C3541 cl3 blb11 0
C3542 clkb rc4/s/n3/a_162_47# 0.00107f
C3543 c_5_12/Q rc4/WL 0
C3544 blb11 rc14/WL 0.00159f
C3545 rc11/WL c_10_14/QB 0
C3546 c_8_14/QB rc9/WL 0
C3547 c_11_6/QB bl7 0.00303f
C3548 c_7_9/Q VDD 0.00756f
C3549 rc4/WL c_4_7/QB 0
C3550 c_9_12/QB bl13 0.00303f
C3551 c_9_9/Q rc10/WL 0
C3552 cs1/n/Y csel2 0
C3553 rc3/s/n3/a_302_47# VDD -0
C3554 clkb c_14_0/Q 0
C3555 rc12/WL blb14 0.00159f
C3556 bl14 c_10_13/QB 0.00303f
C3557 c_9_6/QB VDD 0.00969f
C3558 c_4_13/Q blb12 0.00303f
C3559 c_2_3/QB c_1_3/QB 0.0025f
C3560 c_2_14/QB rc1/WL 0
C3561 rc15/s/wd/A rc15/s/n3/a_162_47# -0.00121f
C3562 c_6_10/QB c_6_9/QB 0
C3563 rc11/WL blb0 0.00236f
C3564 pcb bl0 0.07941f
C3565 c_14_10/Q c_13_10/QB 0
C3566 c_4_5/QB c_5_5/Q 0
C3567 c_6_10/QB VDD 0.00969f
C3568 c_6_8/Q c_7_8/QB 0
C3569 c_12_7/Q blb6 0.00303f
C3570 rc5/WL c_5_2/QB 0
C3571 clkb rc9/s/n3/a_162_47# 0.00107f
C3572 c_4_9/QB rc4/WL 0
C3573 csel1 c_1_1/QB 0
C3574 c_4_3/Q VDD 0.00756f
C3575 rc5/WL c_6_1/QB 0
C3576 cs3/n/Y ch3 0
C3577 cl1 dlb 0.03061f
C3578 VDD dlb 0.04645f
C3579 blb1 c_13_2/QB 0
C3580 c_8_4/QB c_7_4/QB 0.0025f
C3581 clkb rc5/s/n3/a_302_47# 0.00768f
C3582 c_7_12/QB rc7/WL 0
C3583 c_9_6/QB c_9_7/QB 0
C3584 bl1 rc13/s/wd/A 0
C3585 VDD c_3_6/Q 0.00756f
C3586 bl6 c_5_5/Q 0
C3587 c_5_10/QB VDD 0.00969f
C3588 c_1_2/Q c_1_1/Q 0
C3589 rc8/WL c_9_14/Q 0
C3590 rc13/WL blb14 0.00159f
C3591 bl6 c_9_5/Q 0
C3592 c_3_11/QB c_2_11/Q 0
C3593 bl15 c_11_14/QB 0.00303f
C3594 rc10/WL c_10_12/QB 0
C3595 ch1 blb10 0
C3596 ch0 c_0_9/QB 0
C3597 VDD c_7_8/QB 0.00969f
C3598 VDD c_12_5/Q 0.00756f
C3599 cl1 csel7 0.02913f
C3600 VDD csel7 0.02187f
C3601 rc5/WL c_4_0/Q 0
C3602 c_7_11/QB c_7_12/QB 0
C3603 c_1_8/QB blb7 0
C3604 rc6/WL c_6_10/Q 0
C3605 c_6_3/Q VDD 0.00756f
C3606 rc12/WL c_12_14/QB 0
C3607 ch2 cs11/n/Y 0.0979f
C3608 c_3_12/QB bl13 0.00303f
C3609 c_10_7/Q c_11_7/QB 0
C3610 clkb c_15_0/QB 0
C3611 c_13_14/QB c_13_15/QB 0
C3612 c_9_1/Q c_9_2/QB 0.00377f
C3613 ch1 csel13 0.03695f
C3614 c_12_13/QB c_12_13/Q 0
C3615 cl3 cs10/n/a_162_47# 0
C3616 rc14/WL c_14_3/Q 0
C3617 c_8_15/QB rc7/WL 0
C3618 VDD c_7_4/QB 0.00969f
C3619 rl3 c_15_0/Q 0
C3620 rh0 rc12/s/wd/A 0
C3621 pcb blb7 0.07118f
C3622 bl9 c_13_8/Q 0
C3623 c_10_1/QB c_10_2/Q 0.01135f
C3624 VDD rc3/WL 0.05907f
C3625 VDD c_10_11/Q 0.00756f
C3626 rl3 rc12/s/n3/a_162_47# 0.0024f
C3627 rc12/s/n3/a_302_47# rh3 0.0045f
C3628 ch1 bl15 0
C3629 c_4_3/QB rc4/WL 0
C3630 rc13/s/n3/a_302_47# rl1 0.00707f
C3631 rl0 ch3 0.02793f
C3632 c_9_1/Q c_8_1/Q 0.00654f
C3633 rc14/s/n3/a_162_47# bl0 0
C3634 c_9_14/QB rc9/WL 0
C3635 cl3 cs15/n/Y 0.06061f
C3636 cl2 blb6 0.00107f
C3637 rh0 rc3/s/n3/a_162_47# 0.01096f
C3638 c_6_12/QB rc5/WL 0
C3639 c_1_6/Q rc2/WL 0
C3640 rc13/WL c_12_14/QB 0
C3641 VDD c_8_7/Q 0.00756f
C3642 ch2 c_0_5/Q 0
C3643 rc2/WL c_1_9/QB 0
C3644 rc4/WL c_3_6/QB 0
C3645 c_4_14/QB c_5_14/Q 0
C3646 blb11 c_6_12/Q 0.00303f
C3647 c_8_5/Q c_9_5/QB 0
C3648 VDD c_13_1/Q 0.00756f
C3649 ch1 c_0_4/QB 0
C3650 rh3 rc1/s/wd/A 0
C3651 blb3 rc5/WL 0.00159f
C3652 cl1 bl4 0
C3653 bl14 dl 0.04919f
C3654 c_13_9/QB rc14/WL 0
C3655 VDD bl4 -0.00929f
C3656 rc15/WL blb12 0.00298f
C3657 c_2_7/Q c_3_7/Q 0.00654f
C3658 c_12_11/QB c_13_11/QB 0.01281f
C3659 c_2_3/Q c_2_4/Q 0
C3660 c_14_13/Q blb12 0.00303f
C3661 bl7 c_8_6/Q 0
C3662 ch2 c_0_0/QB 0
C3663 c_14_1/Q rc13/WL 0
C3664 rc2/WL bl7 0.00159f
C3665 c_6_3/Q c_6_2/QB 0.01135f
C3666 rc2/WL c_2_9/Q 0
C3667 rc15/WL c_15_13/Q 0
C3668 c_9_7/QB c_8_7/Q 0
C3669 c_5_15/Q VDD 0.00565f
C3670 c_7_7/Q c_7_6/Q 0
C3671 clkb rc4/s/wd/A 0.09749f
C3672 c_14_13/Q c_15_13/Q 0.00654f
C3673 c_15_4/Q bl4 0
C3674 c_14_11/QB rc14/WL 0
C3675 c_14_0/Q rc14/s/wd/A 0
C3676 c_11_14/Q c_11_15/Q 0
C3677 bl12 csel12 0.00807f
C3678 c_3_5/Q blb4 0.00303f
C3679 blb15 rc4/WL 0
C3680 c_10_1/QB rc9/WL 0
C3681 rc11/s/wd/A c_11_1/QB 0
C3682 ch1 c_0_7/QB 0
C3683 c_1_10/QB rc1/WL 0
C3684 rc2/WL c_2_7/Q 0
C3685 VDD c_3_15/Q 0.00565f
C3686 c_7_7/Q c_8_7/QB 0
C3687 ch0 cs5/n/Y 0
C3688 c_2_3/QB rc2/WL 0
C3689 c_1_12/QB csel12 0
C3690 c_4_15/Q blb14 0.00303f
C3691 rc6/WL c_6_13/QB 0
C3692 bl0 rc8/s/n3/a_302_47# 0.00159f
C3693 rc15/WL c_15_6/Q 0
C3694 c_11_9/QB c_11_8/Q 0.00377f
C3695 c_11_9/Q c_11_8/QB 0.01135f
C3696 rc11/WL bl0 0.06726f
C3697 csel3 bl3 0.00807f
C3698 c_3_0/Q rc3/WL 0.01507f
C3699 c_7_2/QB rc7/WL 0
C3700 rc11/s/n3/a_162_47# rh2 0.01096f
C3701 csel1 rc1/WL 0
C3702 c_0_4/QB c_1_4/QB 0.01281f
C3703 c_3_8/Q rc3/WL 0
C3704 blb2 rc4/WL 0.00159f
C3705 pcb c_14_0/Q 0.00166f
C3706 c_11_3/Q rc11/WL 0
C3707 cs8/n/Y cs7/n/Y 0.02812f
C3708 cl1 cl0 4.29761f
C3709 c_6_1/QB rc7/WL 0
C3710 VDD c_13_7/QB 0.00969f
C3711 cs8/n/Y ch0 0
C3712 VDD cl0 0.44411f
C3713 rc15/WL rl1 0
C3714 c_7_1/Q rc7/s/wd/A 0
C3715 clkb c_7_0/QB 0
C3716 rc11/WL c_10_15/Q 0
C3717 c_9_6/Q rc9/WL 0
C3718 c_2_9/QB c_3_9/QB 0.01281f
C3719 c_0_13/QB ch3 0
C3720 c_14_7/QB c_13_7/QB 0.0025f
C3721 c_10_14/QB rc9/WL 0
C3722 c_11_3/QB VDD 0.00969f
C3723 c_12_12/QB c_13_12/QB 0.01281f
C3724 bl1 rc12/WL 0.00215f
C3725 ch2 c_0_9/Q 0
C3726 c_15_14/Q c_15_13/Q 0
C3727 rl3 c_7_0/Q 0
C3728 csel3 c_1_3/QB 0
C3729 csel6 dlb 0.10216f
C3730 VDD c_7_7/QB 0.00969f
C3731 c_0_1/Q dl 0.00931f
C3732 c_0_1/QB dlb 0.004f
C3733 pcb blb6 0.07118f
C3734 bl1 c_11_0/QB 0.00303f
C3735 rc12/WL c_11_8/QB 0
C3736 csel15 blb14 0.00103f
C3737 blb2 c_15_3/Q 0.00303f
C3738 c_14_4/QB bl5 0.00303f
C3739 rc15/s/wd/A rh2 0
C3740 csel9 c_0_9/Q 0.00119f
C3741 blb0 rc9/WL 0.00236f
C3742 c_10_5/QB c_9_5/Q 0
C3743 c_5_11/Q rc4/WL 0
C3744 pcb c_15_9/QB 0.00493f
C3745 rc12/s/wd/A rc13/s/wd/A 0.02158f
C3746 rc11/WL c_10_15/QB 0
C3747 c_9_12/Q c_10_12/QB 0
C3748 c_2_1/QB rc3/WL 0
C3749 c_6_8/QB blb7 0
C3750 ch1 c_1_4/QB 0
C3751 cl3 rh2 0.04111f
C3752 c_0_9/QB c_1_9/QB 0.01281f
C3753 bl9 rc12/WL 0.00159f
C3754 blb3 c_10_4/QB 0
C3755 rc14/WL c_13_10/Q 0
C3756 rh3 rc11/s/wd/A 0
C3757 c_3_9/Q blb8 0.00303f
C3758 c_14_14/Q rc13/WL 0
C3759 VDD c_0_3/Q 0.00756f
C3760 VDD c_9_5/QB 0.00969f
C3761 cs10/n/Y csel11 0
C3762 cl1 blb13 0.0013f
C3763 c_10_7/Q c_10_6/Q 0
C3764 csel4 csel3 0.01915f
C3765 bl8 rc1/WL 0.00159f
C3766 VDD blb13 -0.00917f
C3767 bl1 rc13/WL 0.00215f
C3768 rc11/WL blb7 0.00159f
C3769 csel6 csel7 0.02364f
C3770 blb9 ch3 0
C3771 rc1/s/wd/A c_1_0/Q 0
C3772 clkb rc4/WL 0.00509f
C3773 rc8/WL rc7/s/wd/A 0
C3774 c_10_0/Q rc10/s/wd/A 0
C3775 rc8/WL c_9_3/Q 0
C3776 c_6_7/Q c_6_8/QB 0.00377f
C3777 rl3 rc7/s/n3/a_162_47# 0.01123f
C3778 pcb c_15_0/QB 0.00493f
C3779 bl8 rc10/WL 0.00159f
C3780 c_1_11/QB bl12 0.00303f
C3781 rc2/WL bl6 0.00159f
C3782 c_2_8/Q c_1_8/QB 0
C3783 rl3 rc15/WL 0.00286f
C3784 rc11/WL c_10_14/Q 0
C3785 bl7 c_6_6/QB 0.00303f
C3786 bl12 c_13_11/QB 0.00303f
C3787 c_6_12/QB rc7/WL 0
C3788 c_8_5/QB c_8_6/QB 0
C3789 c_3_2/QB c_4_2/QB 0.0025f
C3790 rc5/WL c_6_15/Q 0
C3791 rc0/WL blb4 0.00289f
C3792 c_1_12/QB c_1_11/QB 0
C3793 rc0/WL c_0_10/QB 0
C3794 blb3 rc7/WL 0.00159f
C3795 cs4/n/Y cl1 0
C3796 bl9 c_4_8/QB 0.00303f
C3797 bl9 rc13/WL 0.00159f
C3798 cs4/n/Y VDD 0.01448f
C3799 c_14_15/QB c_13_15/QB 0.0025f
C3800 dl rl2 0.03898f
C3801 c_2_15/Q rc3/WL 0
C3802 c_6_0/QB c_7_0/Q 0
C3803 c_6_0/Q c_7_0/QB 0
C3804 c_7_3/QB c_7_2/Q 0.00377f
C3805 pcb c_14_9/Q 0.00166f
C3806 rc5/WL c_4_10/Q 0
C3807 ch3 cs10/n/Y 0
C3808 bl6 c_0_5/QB 0.00303f
C3809 c_5_7/Q c_6_7/Q 0.00634f
C3810 blb9 c_4_10/Q 0.00303f
C3811 blb13 c_8_14/QB 0
C3812 bl8 rc6/WL 0.00159f
C3813 c_15_0/QB c_14_0/QB 0.01281f
C3814 c_6_5/Q c_6_6/QB 0.00377f
C3815 cs14/n/Y cs13/n/a_162_47# 0
C3816 rc0/WL c_1_2/QB 0
C3817 rh0 c_1_0/QB 0
C3818 bl13 c_12_12/Q 0
C3819 c_5_9/Q bl10 0
C3820 c_12_13/Q c_12_14/Q 0
C3821 ch2 c_0_4/Q 0
C3822 c_2_1/Q clkb 0
C3823 rc10/s/wd/A rc10/s/n3/a_302_47# -0
C3824 c_11_11/QB rc10/WL 0
C3825 dlb blb0 0.0282f
C3826 rc2/WL csel12 0
C3827 c_2_14/QB bl15 0.00303f
C3828 c_6_10/QB c_5_10/Q 0
C3829 blb9 c_0_10/Q 0.00303f
C3830 c_9_0/Q rc8/WL 0
C3831 rc12/WL c_11_15/Q 0
C3832 c_5_13/QB c_5_14/Q 0.01135f
C3833 c_11_9/QB c_11_10/Q 0.01135f
C3834 rc8/WL c_9_5/Q 0
C3835 bl9 c_9_8/QB 0.00303f
C3836 blb3 c_6_4/Q 0.00303f
C3837 pcb c_15_5/Q 0.00484f
C3838 c_12_6/Q blb5 0.00303f
C3839 c_14_2/Q c_13_2/Q 0.00634f
C3840 c_13_1/Q c_12_1/QB 0
C3841 c_13_1/QB c_12_1/Q 0
C3842 rc10/WL c_11_10/QB 0
C3843 rc4/s/wd/A pcb 0
C3844 c_14_11/Q c_14_10/QB 0.01135f
C3845 c_14_11/QB c_14_10/Q 0.00377f
C3846 ch2 cs12/n/Y 0.00145f
C3847 csel0 dl 0.08427f
C3848 c_4_11/Q rc3/WL 0
C3849 c_12_6/QB c_12_7/QB 0
C3850 VDD c_1_8/Q 0.00756f
C3851 rc6/s/n3/a_162_47# bl0 0
C3852 bl2 c_7_1/Q 0
C3853 rc15/WL bl7 0.00298f
C3854 c_12_10/Q c_13_10/Q 0.00654f
C3855 rc11/s/wd/A rc10/s/wd/A 0.02158f
C3856 bl8 c_1_7/Q 0
C3857 cl2 bl14 0
C3858 c_14_10/QB rc14/WL 0
C3859 c_14_5/QB c_15_5/Q 0
C3860 c_14_5/Q c_15_5/QB 0
C3861 VDD c_2_6/QB 0.00969f
C3862 c_8_5/QB c_8_4/Q 0.00377f
C3863 c_8_5/Q c_8_4/QB 0.01135f
C3864 c_3_15/Q c_2_15/Q 0.00654f
C3865 bl3 rc8/WL 0.00159f
C3866 rc12/WL c_13_10/QB 0
C3867 blb7 c_3_8/QB 0
C3868 c_13_14/Q c_13_13/QB 0.01135f
C3869 c_13_14/QB c_13_13/Q 0.00377f
C3870 c_9_1/QB rc8/WL 0
C3871 rc14/WL c_15_13/QB 0
C3872 rc12/WL c_13_5/Q 0
C3873 rc6/WL c_6_12/Q 0
C3874 c_12_10/QB c_12_10/Q 0
C3875 c_0_11/Q csel11 0.00119f
C3876 VDD c_8_2/QB 0.00969f
C3877 clkb c_0_1/Q 0
C3878 csel3 rc2/WL 0
C3879 c_7_14/Q c_7_15/QB 0.00377f
C3880 csel4 bl5 0.00103f
C3881 c_2_4/QB VDD 0.00969f
C3882 c_4_9/QB c_5_9/Q 0
C3883 c_4_9/Q c_5_9/QB 0
C3884 c_9_0/QB rc10/WL 0
C3885 c_11_9/Q c_10_9/Q 0.00654f
C3886 c_1_12/QB c_0_12/Q 0
C3887 c_1_12/Q c_0_12/QB 0
C3888 c_14_5/Q VDD 0.00756f
C3889 cl3 cs11/n/a_162_47# 0.0022f
C3890 csel6 cl0 0.02918f
C3891 rc10/WL c_10_7/QB 0
C3892 c_7_13/QB rc7/WL 0
C3893 pcb c_14_7/Q 0.00166f
C3894 rc11/WL blb6 0.00159f
C3895 c_0_1/QB cl0 0
C3896 blb0 rc3/WL 0.00236f
C3897 csel14 dl 0.08427f
C3898 c_8_10/Q c_7_10/Q 0.00634f
C3899 c_7_6/QB c_8_6/Q 0
C3900 c_3_3/Q c_3_2/Q 0
C3901 c_15_11/Q c_15_12/Q 0
C3902 c_13_3/QB c_14_3/Q 0
C3903 c_13_3/Q c_14_3/QB 0
C3904 rc8/WL bl12 0.00159f
C3905 rh0 rc1/WL 0.00372f
C3906 bl0 rc9/WL 0.06726f
C3907 c_15_2/Q rc14/WL 0
C3908 clkb c_12_1/Q 0
C3909 c_9_7/Q bl8 0
C3910 c_12_10/QB c_11_10/QB 0.0025f
C3911 c_10_3/QB rc11/WL 0
C3912 c_0_2/QB ch2 0
C3913 rc6/WL c_7_5/Q 0
C3914 c_6_8/QB c_6_7/QB 0
C3915 bl2 rc8/WL 0.00175f
C3916 rc13/WL c_13_10/QB 0
C3917 c_0_2/Q csel2 0.00119f
C3918 dlb csel8 0.10216f
C3919 VDD c_3_1/Q 0.00756f
C3920 bl11 rc8/WL 0.00159f
C3921 c_5_7/Q blb6 0.00303f
C3922 c_14_1/Q c_15_1/QB 0
C3923 rc13/WL c_13_5/Q 0
C3924 c_13_1/Q blb0 0.00303f
C3925 rc12/s/wd/A rc12/WL -0.00118f
C3926 rc0/WL c_1_3/Q 0
C3927 rc12/WL c_12_12/Q 0
C3928 blb3 ch2 0
C3929 ch3 c_0_11/Q 0
C3930 rc2/s/wd/A VDD -0.00408f
C3931 VDD c_12_15/Q 0.00565f
C3932 VDD c_8_5/Q 0.00756f
C3933 blb7 c_4_8/Q 0.00303f
C3934 c_11_13/QB c_10_13/QB 0.01281f
C3935 blb13 c_9_14/QB 0
C3936 c_14_2/Q pcb 0.00166f
C3937 rc8/WL c_8_12/QB 0
C3938 c_9_0/QB rh2 0
C3939 c_9_1/Q rc9/s/wd/A 0
C3940 blb9 c_15_10/Q 0.00303f
C3941 c_10_15/Q rc9/WL 0
C3942 c_8_12/QB c_8_13/Q 0.01135f
C3943 rc2/WL c_1_11/QB 0
C3944 c_14_6/QB rc15/WL 0
C3945 rc0/WL c_1_12/Q 0
C3946 clkb c_5_1/Q 0
C3947 c_14_10/Q c_13_10/Q 0.00634f
C3948 cl1 cs9/n/a_162_47# 0.00134f
C3949 c_15_2/QB c_15_1/QB 0
C3950 csel7 csel8 0.02364f
C3951 blb9 c_7_10/Q 0.00303f
C3952 c_7_11/Q c_8_11/QB 0
C3953 c_5_7/Q c_6_7/QB 0
C3954 rc8/WL blb1 0.00178f
C3955 c_15_5/QB c_15_4/QB 0
C3956 clkb rl2 1.02799f
C3957 c_14_11/Q blb10 0.00303f
C3958 c_6_15/Q rc7/WL 0
C3959 c_15_14/QB c_15_13/Q 0.00377f
C3960 pcb c_14_13/QB 0.00169f
C3961 c_11_6/QB c_11_7/Q 0.01135f
C3962 c_11_6/Q c_11_7/QB 0.00377f
C3963 cs14/n/Y cs13/n/Y 0.02812f
C3964 c_5_13/Q blb12 0.00303f
C3965 rc15/WL c_14_4/Q 0
C3966 c_12_6/QB bl7 0.00303f
C3967 ch0 blb4 0.00109f
C3968 cl3 blb10 0
C3969 blb10 rc14/WL 0.00159f
C3970 rc12/s/wd/A rc13/WL 0
C3971 rh0 rh2 0.19112f
C3972 ch0 c_0_10/QB 0
C3973 rc3/s/n3/a_302_47# bl0 0.00159f
C3974 c_6_15/Q c_6_14/QB 0.01135f
C3975 c_6_15/QB c_6_14/Q 0.00377f
C3976 c_10_15/QB rc9/WL 0
C3977 rc13/WL c_12_12/Q 0
C3978 dl rh1 0.04127f
C3979 c_7_4/Q c_8_4/Q 0.00634f
C3980 cs0/n/a_162_47# ch0 0.00134f
C3981 pcb bl14 0.07118f
C3982 bl9 blb8 2.86379f
C3983 c_3_8/QB c_3_7/QB 0
C3984 rh3 rc9/s/wd/A 0
C3985 rc15/WL bl6 0.00298f
C3986 VDD c_15_4/QB 0.01187f
C3987 blb7 rc9/WL 0.00159f
C3988 c_5_9/QB c_5_10/QB 0
C3989 blb5 ch3 0
C3990 c_0_15/Q rc1/WL 0
C3991 c_1_2/QB ch0 0
C3992 cl0 blb0 0.00156f
C3993 c_0_11/Q c_0_10/Q 0
C3994 cl3 csel13 0.03848f
C3995 rc4/WL c_3_1/QB 0
C3996 bl0 dlb 0
C3997 c_3_0/Q c_3_1/Q 0
C3998 c_4_4/Q blb3 0.00303f
C3999 c_10_14/Q rc9/WL 0
C4000 pcb c_15_3/Q 0.00484f
C4001 VDD c_8_4/QB 0.00969f
C4002 clkb csel0 0
C4003 blb2 c_9_3/Q 0.00303f
C4004 c_7_3/Q c_8_3/Q 0.00634f
C4005 ch2 csel11 0.29434f
C4006 bl15 rc14/WL 0.00159f
C4007 c_12_6/QB c_13_6/QB 0.01281f
C4008 cl3 bl15 0
C4009 c_13_9/QB c_13_8/Q 0.00377f
C4010 rc2/WL bl5 0.00159f
C4011 bl3 dl 0.04919f
C4012 c_6_8/Q c_6_9/QB 0.00377f
C4013 rl0 c_0_0/Q 0
C4014 blb3 c_12_4/Q 0.00303f
C4015 VDD c_6_8/Q 0.00756f
C4016 c_9_6/Q c_9_5/QB 0.01135f
C4017 c_9_7/Q c_10_7/QB 0
C4018 cl2 rl2 0.02782f
C4019 c_0_14/Q dl 0.00931f
C4020 c_0_14/QB dlb 0.004f
C4021 VDD c_15_5/QB 0.01187f
C4022 c_13_6/Q c_14_6/Q 0.00634f
C4023 blb11 rc12/WL 0.00159f
C4024 rc11/WL c_10_8/Q 0
C4025 blb13 c_10_14/QB 0
C4026 c_4_3/QB c_5_3/QB 0.01281f
C4027 c_7_6/QB c_6_6/QB 0.01281f
C4028 c_6_0/Q rl2 0
C4029 rc14/s/n3/a_302_47# rc13/s/wd/A 0
C4030 blb3 c_11_4/Q 0.00303f
C4031 c_11_12/QB c_12_12/Q 0
C4032 c_2_5/Q c_3_5/QB 0
C4033 c_2_5/QB c_3_5/Q 0
C4034 VDD c_10_8/QB 0.00969f
C4035 c_2_10/QB rc3/WL 0
C4036 c_9_2/QB c_9_3/QB 0
C4037 c_15_4/Q c_15_5/QB 0.00377f
C4038 rc14/WL c_13_8/QB 0
C4039 c_2_1/QB c_3_1/Q 0
C4040 c_2_1/Q c_3_1/QB 0
C4041 VDD c_6_9/QB 0.00969f
C4042 ch2 ch3 4.30701f
C4043 c_1_3/QB dl 0.0021f
C4044 bl12 dl 0.04919f
C4045 c_8_0/Q VDD 0.01304f
C4046 rc10/WL c_10_13/Q 0
C4047 cl1 VDD 0.44457f
C4048 c_3_12/Q rc3/WL 0
C4049 rh3 c_12_0/QB 0
C4050 rc8/WL c_8_6/Q 0
C4051 bl2 dl 0.04919f
C4052 c_2_1/QB rc2/s/wd/A 0
C4053 rc2/WL bl10 0.00159f
C4054 bl1 c_10_0/QB 0.00303f
C4055 bl11 dl 0.04919f
C4056 bl10 c_15_9/Q 0
C4057 ch1 cs2/n/Y 0
C4058 bl0 rc3/WL 0.06726f
C4059 c_4_7/QB c_3_7/Q 0
C4060 c_4_7/Q c_3_7/QB 0
C4061 c_10_3/QB c_10_2/Q 0.00377f
C4062 VDD c_5_5/QB 0.00969f
C4063 clkb rc7/s/wd/A 0.09749f
C4064 c_1_12/QB dl 0.0021f
C4065 pcb c_14_6/Q 0.00166f
C4066 c_11_14/Q rc10/WL 0
C4067 rc0/WL c_1_0/Q 0
C4068 c_2_8/Q c_3_8/QB 0
C4069 blb11 rc13/WL 0.00159f
C4070 c_13_0/Q c_12_0/QB 0
C4071 c_11_13/Q blb12 0.00303f
C4072 blb7 dlb 0.0282f
C4073 csel9 ch3 0.02926f
C4074 rc5/WL c_5_6/Q 0
C4075 ch0 cs13/n/Y 0
C4076 cl2 csel0 0.03041f
C4077 cl0 csel8 0.03107f
C4078 c_8_0/QB c_7_0/QB 0.0025f
C4079 pcb c_14_12/Q 0.00166f
C4080 rc9/s/wd/A rc10/s/wd/A 0.02007f
C4081 VDD c_14_7/QB 0.00969f
C4082 ch1 csel1 0.02951f
C4083 c_0_13/QB c_1_13/QB 0.01281f
C4084 c_15_4/Q VDD 0.015f
C4085 blb10 c_11_11/QB 0
C4086 ch1 cl3 0.36138f
C4087 c_14_5/QB c_14_6/Q 0.01135f
C4088 c_1_5/Q c_1_4/Q 0
C4089 csel4 dl 0.08427f
C4090 blb6 c_4_7/Q 0.00303f
C4091 VDD c_9_7/QB 0.00969f
C4092 cl1 cs5/n/a_162_47# 0.00134f
C4093 ch0 c_1_3/Q 0
C4094 blb2 bl3 2.73705f
C4095 blb1 dl 0.02104f
C4096 c_1_6/Q c_2_6/Q 0.00634f
C4097 c_0_7/Q rc1/WL 0
C4098 c_11_13/Q c_11_12/Q 0
C4099 rh3 ch0 0.02852f
C4100 blb7 c_7_8/QB 0
C4101 c_7_10/Q rc7/WL 0
C4102 c_11_3/Q bl4 0
C4103 rc13/s/wd/A rh2 0
C4104 rl2 rc14/s/wd/A 0.05309f
C4105 VDD c_8_14/QB 0.00969f
C4106 rc0/WL c_0_5/Q 0
C4107 csel7 blb7 0.00807f
C4108 c_3_4/Q rc3/WL 0
C4109 bl9 c_15_8/QB 0.00303f
C4110 c_5_0/Q rl1 0
C4111 c_14_2/QB VDD 0.00969f
C4112 blb6 rc9/WL 0.00159f
C4113 cs7/n/Y cs6/n/Y 0.02812f
C4114 ch2 c_0_10/Q 0
C4115 c_8_2/Q c_7_2/QB 0
C4116 c_8_6/QB rc9/WL 0
C4117 ch0 cs6/n/Y 0
C4118 blb2 c_5_3/QB 0
C4119 clkb rh1 0.42406f
C4120 c_2_6/Q bl7 0
C4121 bl13 rc1/WL 0.00159f
C4122 c_7_13/Q c_6_13/Q 0.00654f
C4123 c_10_11/QB bl12 0.00303f
C4124 c_14_9/Q c_13_9/Q 0.00634f
C4125 csel14 cl2 0.03033f
C4126 bl1 c_12_0/Q 0
C4127 rc0/WL c_0_0/QB 0.00535f
C4128 clkb c_9_0/Q 0
C4129 c_10_3/QB rc9/WL 0
C4130 c_6_2/QB VDD 0.00969f
C4131 VDD c_7_15/Q 0.00565f
C4132 blb2 c_1_3/QB 0
C4133 rh3 rc3/s/wd/A 0
C4134 rc11/WL bl14 0.00159f
C4135 bl13 rc10/WL 0.00159f
C4136 c_7_11/Q c_7_10/QB 0.01135f
C4137 c_7_11/QB c_7_10/Q 0.00377f
C4138 c_0_7/QB bl8 0.00303f
C4139 clkb rc1/s/n3/a_302_47# 0.00768f
C4140 VDD c_3_0/Q 0.01304f
C4141 c_11_2/QB c_12_2/QB 0.0025f
C4142 c_11_6/Q c_10_6/Q 0.00654f
C4143 pcb rl2 0.0012f
C4144 c_5_7/Q rc4/WL 0
C4145 bl2 blb2 -0.00665f
C4146 blb7 rc3/WL 0.00159f
C4147 rc6/s/wd/A rl1 0.00205f
C4148 c_9_2/Q rc10/WL 0
C4149 rc5/WL blb14 0.00159f
C4150 VDD c_3_8/Q 0.00756f
C4151 blb11 c_15_12/QB 0
C4152 blb11 c_11_12/QB 0
C4153 c_2_6/Q c_2_7/Q 0
C4154 c_6_4/QB c_6_3/QB 0
C4155 ch1 bl8 0
C4156 rl0 rc8/s/n3/a_162_47# 0.01123f
C4157 bl2 c_13_1/QB 0.00303f
C4158 rc0/WL c_1_15/Q 0
C4159 rh3 rl1 0.40505f
C4160 bl0 cl0 0
C4161 c_12_13/QB rc12/WL 0
C4162 c_13_9/QB rc12/WL 0
C4163 c_10_9/Q blb8 0.00303f
C4164 csel10 rc1/WL 0
C4165 c_7_1/Q c_7_0/Q 0
C4166 c_0_13/Q rc1/WL 0
C4167 rc5/s/wd/A rc5/s/n3/a_162_47# -0.00121f
C4168 rc13/WL c_14_3/Q 0
C4169 c_13_0/Q rl1 0
C4170 rc0/s/n3/a_302_47# VDD -0
C4171 c_1_4/Q rc1/WL 0
C4172 bl9 c_5_8/QB 0.00303f
C4173 c_6_4/QB c_5_4/Q 0
C4174 clkb c_5_0/QB 0
C4175 bl13 rc6/WL 0.00159f
C4176 c_12_3/Q c_12_2/Q 0
C4177 c_7_13/Q c_8_13/QB 0
C4178 c_5_11/Q bl12 0
C4179 pcb c_15_10/QB 0.00493f
C4180 c_14_0/QB rl2 0
C4181 c_9_6/QB c_8_6/QB 0.01281f
C4182 ch1 cs0/n/Y 0
C4183 bl10 c_0_9/QB 0.00303f
C4184 c_3_6/QB c_3_7/Q 0.01135f
C4185 c_3_6/Q c_3_7/QB 0.00377f
C4186 c_11_9/Q rc10/WL 0
C4187 c_10_1/Q c_11_1/QB 0
C4188 cs13/n/Y cs12/n/a_162_47# 0
C4189 c_0_7/Q c_1_7/Q 0.00654f
C4190 c_0_14/QB cl0 0
C4191 cl2 rh1 0.02782f
C4192 c_2_1/QB VDD 0.00969f
C4193 c_0_6/Q dlb 0
C4194 c_7_14/Q c_7_13/QB 0.01135f
C4195 c_7_14/QB c_7_13/Q 0.00377f
C4196 c_8_4/Q rc9/WL 0
C4197 blb6 dlb 0.0282f
C4198 c_0_9/Q c_0_8/QB 0.01135f
C4199 c_0_9/QB c_0_8/Q 0.00377f
C4200 blb0 c_3_1/Q 0.00303f
C4201 rc0/WL c_0_9/Q 0
C4202 c_4_5/Q rc4/WL 0
C4203 c_12_13/QB rc13/WL 0
C4204 c_13_9/QB rc13/WL 0
C4205 c_6_0/Q rh1 0
C4206 cs14/n/a_162_47# cs15/n/Y 0
C4207 c_0_15/QB c_1_15/Q 0
C4208 c_6_5/Q blb4 0.00303f
C4209 bl1 rl0 0
C4210 rl0 rc0/s/wd/A 0.05406f
C4211 c_4_1/QB c_3_1/QB 0.0025f
C4212 c_7_3/QB c_6_3/QB 0.01281f
C4213 c_9_10/Q bl11 0
C4214 rc2/WL dl 0
C4215 rc2/s/wd/A blb0 0
C4216 c_4_4/QB c_3_4/QB 0.0025f
C4217 rc4/WL c_3_0/QB 0
C4218 c_0_11/QB rc1/WL 0
C4219 rl3 rc6/s/wd/A 0.00228f
C4220 rc2/WL c_3_6/QB 0
C4221 rc15/WL bl5 0.00298f
C4222 c_4_14/QB c_5_14/QB 0.01281f
C4223 rc8/WL c_7_0/Q 0
C4224 c_11_14/Q c_12_14/Q 0.00634f
C4225 c_1_8/Q csel8 0
C4226 rc4/WL c_3_8/QB 0
C4227 VDD c_9_14/QB 0.00969f
C4228 c_4_6/Q rc4/WL 0
C4229 c_7_1/QB c_7_2/QB 0
C4230 c_14_9/QB bl10 0.00303f
C4231 rl3 rh3 0.48407f
C4232 c_9_1/Q c_10_1/Q 0.00634f
C4233 c_14_11/QB rc13/WL 0
C4234 c_13_0/QB rc14/WL 0
C4235 rc14/s/n3/a_162_47# rl2 0.01123f
C4236 rh0 rc5/s/wd/A 0
C4237 c_5_2/Q c_4_2/Q 0.00654f
C4238 ch0 cs11/n/Y 0
C4239 cl0 blb7 0
C4240 c_0_13/Q c_1_13/Q 0.00654f
C4241 bl3 cl2 0
C4242 blb6 csel7 0.00103f
C4243 c_7_1/QB c_6_1/QB 0.01281f
C4244 c_14_1/QB c_13_1/QB 0.0025f
C4245 ch0 c_1_0/Q 0
C4246 c_0_5/QB dl 0.0049f
C4247 c_5_12/Q c_4_12/Q 0.00654f
C4248 pcb c_15_7/Q 0.00484f
C4249 c_2_4/Q rc3/WL 0
C4250 c_3_7/QB rc3/WL 0
C4251 rc8/s/wd/A rc8/s/n3/a_162_47# -0.00121f
C4252 c_10_8/Q rc9/WL 0
C4253 csel6 cl1 0.06555f
C4254 VDD c_2_15/Q 0.00565f
C4255 csel6 VDD 0.02187f
C4256 blb13 c_0_14/QB 0
C4257 c_11_0/QB rc10/WL 0
C4258 c_0_1/QB VDD 0.00969f
C4259 pcb rc7/s/wd/A 0
C4260 rc10/s/wd/A rl1 0.00205f
C4261 VDD c_14_12/QB 0.00969f
C4262 rc11/WL c_12_1/Q 0
C4263 c_6_0/Q c_5_0/QB 0
C4264 c_6_0/QB c_5_0/Q 0
C4265 rc2/WL blb15 0
C4266 c_5_4/QB c_5_3/Q 0.00377f
C4267 bl3 c_13_2/Q 0
C4268 rc15/WL bl10 0.00298f
C4269 c_12_10/Q c_11_10/Q 0.00634f
C4270 blb6 rc3/WL 0.00159f
C4271 c_8_14/QB c_9_14/QB 0.01281f
C4272 c_1_3/QB c_0_3/QB 0.01281f
C4273 pcb c_14_4/QB 0.00169f
C4274 rh1 rc14/s/wd/A 0
C4275 VDD c_12_1/QB 0.00969f
C4276 c_10_1/QB VDD 0.00969f
C4277 c_7_6/Q c_8_6/Q 0.00634f
C4278 rc4/WL c_4_8/Q 0
C4279 rc0/s/n3/a_162_47# rh0 0.01096f
C4280 ch0 c_0_5/Q 0
C4281 cl2 bl12 0
C4282 c_4_5/QB blb4 0
C4283 rc15/WL c_14_15/QB 0
C4284 rc12/WL c_13_10/Q 0
C4285 c_6_12/QB c_6_11/Q 0.00377f
C4286 bl2 cl2 0
C4287 bl11 cl2 0
C4288 rc3/s/n3/a_302_47# rc4/s/wd/A 0
C4289 c_11_11/QB c_11_10/Q 0.00377f
C4290 c_11_9/QB c_11_10/QB 0
C4291 c_1_15/QB dl 0.0021f
C4292 c_1_6/QB c_1_5/QB 0
C4293 c_6_0/QB rc6/s/wd/A 0.00246f
C4294 blb6 c_8_7/Q 0.00303f
C4295 blb2 rc2/WL 0.00159f
C4296 c_2_9/QB c_2_8/QB 0
C4297 c_6_7/Q c_7_7/QB 0
C4298 c_14_5/QB c_14_4/QB 0
C4299 rl1 c_1_0/Q 0
C4300 ch1 rh0 0.028f
C4301 c_9_4/QB rc9/WL 0
C4302 c_8_6/Q c_8_7/QB 0.00377f
C4303 c_8_6/QB c_8_7/Q 0.01135f
C4304 c_11_0/QB rh2 0
C4305 c_9_13/Q rc9/WL 0
C4306 c_2_3/Q c_2_2/QB 0.01135f
C4307 c_2_3/QB c_2_2/Q 0.00377f
C4308 VDD c_4_11/Q 0.00756f
C4309 rc12/WL c_12_10/QB 0
C4310 ch0 c_0_0/QB 0
C4311 c_6_15/QB c_5_15/QB 0.0025f
C4312 c_5_6/Q blb5 0.00303f
C4313 bl1 rc8/s/wd/A 0
C4314 pcb rh1 0.00256f
C4315 blb14 rc7/WL 0.00159f
C4316 blb13 c_10_14/Q 0.00303f
C4317 c_11_6/Q bl7 0
C4318 c_8_14/Q rc9/WL 0
C4319 rc0/WL c_0_4/Q 0
C4320 c_2_8/QB c_2_7/QB 0
C4321 c_4_12/QB c_4_11/QB 0
C4322 csel4 cl2 0.0291f
C4323 rc4/WL c_4_7/Q 0
C4324 c_10_3/QB bl4 0.00303f
C4325 c_9_12/Q bl13 0
C4326 ch2 cs1/n/Y 0
C4327 c_2_13/QB rc3/WL 0
C4328 c_6_4/QB rc6/WL 0
C4329 blb11 c_5_12/QB 0
C4330 rc12/WL c_11_1/Q 0
C4331 c_2_11/Q c_2_10/Q 0
C4332 c_4_4/QB c_5_4/Q 0
C4333 c_13_15/QB c_12_15/QB 0.01281f
C4334 c_9_6/Q VDD 0.00756f
C4335 cl2 blb1 0
C4336 c_9_8/QB rc10/WL 0
C4337 c_2_3/QB c_1_3/Q 0
C4338 c_2_3/Q c_1_3/QB 0
C4339 rc13/WL c_13_10/Q 0
C4340 rc12/s/wd/A c_12_0/Q 0
C4341 VDD c_10_14/QB 0.00969f
C4342 rl3 rc10/s/wd/A 0.00228f
C4343 c_0_9/QB dl 0.0049f
C4344 c_11_0/QB c_11_1/Q 0.01135f
C4345 rc5/WL c_5_2/Q 0
C4346 c_7_9/QB blb8 0
C4347 c_2_8/Q rc3/WL 0
C4348 c_4_9/Q rc4/WL 0
C4349 cl1 blb0 0
C4350 rc5/WL c_6_1/Q 0
C4351 rc13/WL c_12_10/QB 0
C4352 csel2 rc1/WL 0
C4353 VDD blb0 -0.00917f
C4354 c_8_4/Q c_7_4/QB 0
C4355 blb1 c_13_2/Q 0.00303f
C4356 c_9_6/Q c_9_7/QB 0.00377f
C4357 bl1 rc5/WL 0.00215f
C4358 bl3 pcb 0.07118f
C4359 bl14 rc9/WL 0.00159f
C4360 c_11_12/QB rc10/WL 0
C4361 c_7_3/QB c_8_3/QB 0.0025f
C4362 c_5_10/Q VDD 0.00756f
C4363 clkb rc2/WL 0.00509f
C4364 blb6 c_13_7/QB 0
C4365 c_0_6/Q cl0 0
C4366 VDD c_13_4/Q 0.00756f
C4367 blb6 cl0 0
C4368 c_4_13/QB rc3/WL 0
C4369 c_12_8/Q c_11_8/QB 0
C4370 rc5/WL c_5_14/Q 0
C4371 bl15 c_11_14/Q 0
C4372 c_10_1/Q rc10/s/wd/A 0
C4373 c_8_5/QB c_9_5/Q 0
C4374 ch0 c_0_9/Q 0
C4375 ch1 c_0_15/Q 0
C4376 cs15/n/Y csel15 0.07585f
C4377 rc2/s/wd/A bl0 0.00934f
C4378 rc4/WL c_4_11/QB 0
C4379 c_5_13/QB rc6/WL 0
C4380 c_7_3/QB rc6/WL 0
C4381 c_13_9/QB blb8 0
C4382 c_7_11/Q c_7_12/QB 0.00377f
C4383 c_12_8/Q bl9 0
C4384 c_1_8/Q blb7 0.00303f
C4385 rc4/s/wd/A rc3/WL 0
C4386 rc5/WL bl9 0.00159f
C4387 c_11_5/QB rc10/WL 0
C4388 c_2_4/QB c_3_4/Q 0
C4389 c_6_9/Q bl10 0
C4390 rc12/WL c_12_14/Q 0
C4391 c_10_7/Q c_11_7/Q 0.00654f
C4392 c_10_3/Q c_9_3/QB 0
C4393 pcb bl12 0.07118f
C4394 c_13_14/Q c_13_15/QB 0.00377f
C4395 c_13_14/QB c_13_15/Q 0.01135f
C4396 c_0_2/QB rc0/WL 0
C4397 bl9 blb9 -0.00665f
C4398 clkb c_15_0/Q 0
C4399 c_10_3/QB c_11_3/QB 0.01281f
C4400 blb6 c_7_7/QB 0
C4401 bl2 pcb 0.07118f
C4402 c_0_6/QB rc1/WL 0
C4403 pcb bl11 0.07118f
C4404 clkb rc12/s/n3/a_162_47# 0.00107f
C4405 c_1_1/QB c_1_1/Q -0
C4406 blb1 rc14/s/wd/A 0
C4407 c_8_15/Q rc7/WL 0
C4408 blb3 rc0/WL 0.00289f
C4409 c_3_11/QB c_3_12/QB 0
C4410 c_7_6/Q c_6_6/QB 0
C4411 rl0 rc12/s/wd/A 0.05406f
C4412 c_12_11/QB rc11/WL 0
C4413 bl13 csel13 0.00807f
C4414 rc8/s/n3/a_302_47# rc7/s/wd/A 0
C4415 cs15/n/a_162_47# ch3 0.00134f
C4416 c_4_3/Q rc4/WL 0
C4417 c_7_7/Q c_7_8/QB 0.00377f
C4418 VDD c_15_7/QB 0.01187f
C4419 c_9_14/Q rc9/WL 0
C4420 blb10 csel10 0.00807f
C4421 c_4_14/QB bl15 0.00303f
C4422 cl1 csel8 0.02913f
C4423 rh0 rc2/s/n3/a_302_47# 0.0045f
C4424 rl0 rc3/s/n3/a_162_47# 0.0024f
C4425 c_7_7/QB c_6_7/QB 0.01281f
C4426 rc13/WL c_14_10/QB 0
C4427 VDD csel8 0.02187f
C4428 c_4_12/QB rc3/WL 0
C4429 bl2 c_3_1/QB 0.00303f
C4430 rc4/WL c_3_6/Q 0
C4431 c_5_13/QB c_5_14/QB 0
C4432 c_4_14/Q c_5_14/Q 0.00654f
C4433 rc13/WL c_12_14/Q 0
C4434 rc2/WL c_1_9/Q 0
C4435 pcb blb1 0.07118f
C4436 ch2 blb14 0
C4437 c_5_10/QB rc4/WL 0
C4438 bl14 dlb 0
C4439 c_15_7/QB c_14_7/QB 0.01281f
C4440 rc1/WL blb8 0.00159f
C4441 c_7_12/Q c_8_12/QB 0
C4442 dl cs5/n/Y 0
C4443 c_10_4/QB c_9_4/Q 0
C4444 c_12_11/Q c_13_11/QB 0
C4445 c_12_11/QB c_13_11/Q 0
C4446 csel15 rc1/WL 0
C4447 ch2 c_0_0/Q 0
C4448 rc10/WL blb8 0.00159f
C4449 c_9_7/Q c_9_8/QB 0.00377f
C4450 csel1 cs2/n/Y 0.00301f
C4451 c_14_1/QB rc14/s/wd/A 0
C4452 c_0_13/Q csel13 0.00119f
C4453 c_6_3/Q c_6_2/Q 0
C4454 cs13/n/Y csel12 0.00301f
C4455 cl3 cs2/n/Y 0.01311f
C4456 c_1_6/QB c_1_7/QB 0
C4457 rc15/s/wd/A rc14/WL 0
C4458 rc6/s/n3/a_162_47# rl2 0.01123f
C4459 c_11_4/QB rc10/WL 0
C4460 rc15/WL blb15 0.00228f
C4461 c_14_11/Q rc14/WL 0
C4462 cs8/n/Y dl 0
C4463 c_1_1/Q c_1_0/QB 0.01135f
C4464 cl3 csel1 0.03848f
C4465 clkb rc13/s/n3/a_302_47# 0.00768f
C4466 c_7_7/Q c_8_7/Q 0.00634f
C4467 ch0 c_0_4/Q 0
C4468 ch1 c_0_7/Q 0
C4469 c_1_10/Q rc1/WL 0
C4470 blb10 c_0_11/QB 0
C4471 c_2_1/QB blb0 0
C4472 c_2_3/Q rc2/WL 0
C4473 c_5_9/QB c_6_9/QB 0.0025f
C4474 c_14_1/QB pcb 0.00169f
C4475 c_10_5/QB blb4 0
C4476 c_9_14/QB c_10_14/QB 0.0025f
C4477 blb10 rc12/WL 0.00159f
C4478 rc0/WL csel11 0.02369f
C4479 rc0/WL c_1_14/QB 0
C4480 c_9_0/Q c_8_0/QB 0
C4481 c_0_12/QB ch3 0
C4482 c_1_12/Q csel12 0
C4483 c_5_9/QB VDD 0.00969f
C4484 rc6/WL c_6_13/Q 0
C4485 rc4/WL rc3/WL 0.88432f
C4486 rc6/WL blb8 0.00159f
C4487 c_11_9/Q c_11_8/Q 0
C4488 c_2_10/QB VDD 0.00969f
C4489 c_7_2/Q rc7/WL 0
C4490 blb2 rc15/WL 0.00298f
C4491 c_0_4/QB c_1_4/Q 0
C4492 rc9/s/n3/a_302_47# rh2 0.0045f
C4493 ch0 cs12/n/Y 0
C4494 c_3_4/QB c_3_5/QB 0
C4495 VDD c_13_7/Q 0.00756f
C4496 ch1 bl13 0
C4497 VDD c_3_12/Q 0.00756f
C4498 c_5_7/QB c_5_6/Q 0.00377f
C4499 bl14 rc3/WL 0.00159f
C4500 c_6_1/Q rc7/WL 0
C4501 blb9 c_13_10/QB 0
C4502 cl1 bl0 0
C4503 VDD bl0 0.3898f
C4504 c_8_11/QB rc8/WL 0
C4505 blb3 c_13_4/QB 0
C4506 bl3 rc11/WL 0.00159f
C4507 c_1_7/QB c_2_7/QB 0.0025f
C4508 bl1 rc7/WL 0.00215f
C4509 c_12_2/Q c_13_2/QB 0
C4510 c_15_12/QB c_15_13/QB 0
C4511 rc11/s/n3/a_302_47# VDD -0
C4512 c_2_9/Q c_3_9/QB 0
C4513 c_2_9/QB c_3_9/Q 0
C4514 rc4/WL bl4 0.00159f
C4515 clkb c_7_0/Q 0
C4516 rc2/WL c_1_8/QB 0
C4517 c_14_7/Q c_13_7/QB 0
C4518 c_14_7/QB c_13_7/Q 0
C4519 c_11_3/Q VDD 0.00756f
C4520 c_12_12/Q c_13_12/QB 0
C4521 c_2_12/Q bl13 0
C4522 c_14_1/QB c_14_0/QB 0
C4523 ch3 c_0_8/QB 0
C4524 bl5 blb4 2.86378f
C4525 blb10 rc13/WL 0.00159f
C4526 csel3 c_1_3/Q 0
C4527 rc0/WL ch3 0.0029f
C4528 rc12/WL bl15 0.00159f
C4529 VDD c_10_15/Q 0.00565f
C4530 c_0_1/Q dlb 0
C4531 c_0_1/QB blb0 0
C4532 c_5_15/Q rc4/WL 0
C4533 c_6_12/Q c_6_13/QB 0.00377f
C4534 rc12/WL c_11_8/Q 0
C4535 bl1 c_11_0/Q 0
C4536 VDD c_0_14/QB 0.00969f
C4537 c_5_14/Q c_6_14/QB 0
C4538 cl3 bl8 0
C4539 ch1 csel10 0.03695f
C4540 rc5/WL c_5_1/QB 0
C4541 bl8 rc14/WL 0.00159f
C4542 c_11_13/QB rc11/WL 0
C4543 bl9 rc7/WL 0.00159f
C4544 c_10_5/Q c_9_5/Q 0.00634f
C4545 ch1 c_0_13/Q 0
C4546 pcb c_15_9/Q 0.00484f
C4547 c_8_11/Q bl12 0
C4548 c_2_1/Q rc3/WL 0
C4549 c_6_8/Q blb7 0.00303f
C4550 c_12_6/QB c_12_5/QB 0
C4551 rc11/WL bl12 0.00159f
C4552 ch1 c_1_4/Q 0
C4553 c_3_4/Q VDD 0.00756f
C4554 c_0_9/Q c_1_9/QB 0
C4555 c_0_9/QB c_1_9/Q 0
C4556 c_1_1/Q rc1/WL 0.00103f
C4557 rc4/WL c_3_15/Q 0
C4558 rc12/WL c_11_14/QB 0
C4559 blb3 c_10_4/Q 0.00303f
C4560 bl2 rc11/WL 0.00175f
C4561 c_15_3/Q bl4 0
C4562 bl11 rc11/WL 0.00159f
C4563 c_0_2/QB ch0 0
C4564 clkb rc7/s/n3/a_162_47# 0.00107f
C4565 blb0 c_12_1/QB 0
C4566 c_11_6/QB rc11/WL 0
C4567 c_10_1/QB blb0 0
C4568 rc6/WL c_5_12/QB 0
C4569 c_4_5/Q c_5_5/Q 0.00654f
C4570 c_7_14/QB rc6/WL 0
C4571 clkb rc15/WL 0.00509f
C4572 VDD c_10_15/QB 0.00479f
C4573 csel1 cs0/n/Y 0
C4574 blb5 csel5 0.00807f
C4575 rc12/WL c_13_8/QB 0
C4576 c_10_0/QB rc10/WL 0.00535f
C4577 blb3 ch0 0.00109f
C4578 c_8_11/Q c_8_12/QB 0.00377f
C4579 cl3 cs0/n/Y 0.01311f
C4580 c_6_7/Q c_6_8/Q 0
C4581 blb7 c_10_8/QB 0
C4582 pcb c_15_0/Q 0.00484f
C4583 rc13/WL bl15 0.00159f
C4584 c_13_5/QB c_13_4/QB 0
C4585 rc8/WL blb4 0.00159f
C4586 c_1_11/Q bl12 0
C4587 rc2/WL c_3_1/QB 0
C4588 c_2_8/Q c_1_8/Q 0.00634f
C4589 bl12 c_13_11/Q 0
C4590 c_13_0/QB rc13/s/wd/A 0.00246f
C4591 cs14/n/Y ch3 0.09885f
C4592 cl1 blb7 0
C4593 ch3 c_0_15/QB 0
C4594 c_8_5/Q c_8_6/QB 0.00377f
C4595 c_8_5/QB c_8_6/Q 0.01135f
C4596 VDD blb7 -0.00917f
C4597 c_3_2/Q c_4_2/QB 0
C4598 c_3_2/QB c_4_2/Q 0
C4599 rc11/WL blb1 0.00178f
C4600 c_1_12/QB c_1_11/Q 0.00377f
C4601 c_1_12/Q c_1_11/QB 0.01135f
C4602 c_9_4/QB c_9_5/QB 0
C4603 rc0/WL c_0_10/Q 0
C4604 ch1 c_0_11/QB 0
C4605 cl0 bl14 0
C4606 VDD c_10_14/Q 0.00756f
C4607 c_14_15/Q c_13_15/QB 0
C4608 c_14_15/QB c_13_15/Q 0
C4609 dlb rl2 0.02782f
C4610 c_6_0/Q c_7_0/Q 0.00654f
C4611 bl6 c_0_5/Q 0
C4612 c_6_7/Q VDD 0.00756f
C4613 cs12/n/a_162_47# cs12/n/Y -0
C4614 c_1_4/QB c_1_4/Q -0
C4615 cs11/n/Y csel12 0
C4616 c_10_0/QB rh2 0
C4617 c_14_8/QB pcb 0.00169f
C4618 rc13/WL c_13_8/QB 0
C4619 blb13 c_8_14/Q 0.00303f
C4620 rc0/s/n3/a_302_47# bl0 0.00159f
C4621 c_15_0/Q c_14_0/QB 0
C4622 c_5_12/Q c_5_13/Q 0
C4623 rc0/WL c_1_2/Q 0
C4624 c_4_9/QB c_4_10/QB 0
C4625 blb11 c_13_12/QB 0
C4626 c_11_11/Q rc10/WL 0
C4627 clkb c_4_0/QB 0
C4628 rc6/s/n3/a_162_47# rh1 0.01115f
C4629 ch2 csel5 0.02936f
C4630 rc13/s/n3/a_302_47# rc14/s/wd/A 0
C4631 c_9_3/Q rc9/WL 0
C4632 bl1 ch2 0
C4633 c_10_10/Q bl11 0
C4634 c_11_9/Q c_11_10/Q 0
C4635 ch2 rc0/s/wd/A 0
C4636 bl9 c_9_8/Q 0
C4637 blb13 rc4/WL 0.00159f
C4638 c_13_1/Q c_12_1/Q 0.00654f
C4639 c_14_11/Q c_14_10/Q 0
C4640 csel0 dlb 0.09791f
C4641 c_12_6/QB c_12_7/Q 0.01135f
C4642 c_12_6/Q c_12_7/QB 0.00377f
C4643 ch0 csel11 0.03716f
C4644 rc5/WL blb11 0.00159f
C4645 blb13 bl14 2.86379f
C4646 c_14_10/Q rc14/WL 0
C4647 c_7_13/QB blb12 0
C4648 c_14_5/Q c_15_5/Q 0.00654f
C4649 bl3 c_10_2/Q 0
C4650 c_8_5/Q c_8_4/Q 0
C4651 cl2 cs5/n/Y 0
C4652 rc2/s/n3/a_162_47# rl1 0.0024f
C4653 VDD rc4/s/n3/a_162_47# 0
C4654 c_2_5/QB bl6 0.00303f
C4655 rh0 rc15/s/wd/A 0
C4656 rc12/WL c_11_9/QB 0
C4657 blb7 c_3_8/Q 0.00303f
C4658 c_13_14/Q c_13_13/Q 0
C4659 bl9 ch2 0
C4660 c_9_1/Q rc8/WL 0
C4661 c_10_13/Q c_10_12/QB 0.01135f
C4662 c_9_10/QB c_9_11/Q 0.01135f
C4663 c_2_14/Q rc3/WL 0
C4664 c_6_0/QB c_6_1/QB 0
C4665 c_14_0/Q VDD 0.01304f
C4666 cl3 rh0 0.04111f
C4667 ch3 blb12 0
C4668 c_2_6/Q c_3_6/QB 0
C4669 rc6/WL c_5_8/QB 0
C4670 rc12/WL c_11_10/Q 0
C4671 cs8/n/Y cl2 0
C4672 c_2_4/Q VDD 0.00756f
C4673 VDD c_3_7/QB 0.00969f
C4674 c_4_9/Q c_5_9/Q 0.00654f
C4675 c_9_0/Q rc9/WL 0.01507f
C4676 c_10_10/QB c_10_9/QB 0
C4677 bl9 csel9 0.00807f
C4678 c_1_12/Q c_0_12/Q 0.00654f
C4679 c_7_10/QB rc8/WL 0
C4680 cs7/n/Y ch3 0
C4681 c_0_1/Q cl0 0
C4682 c_7_13/Q rc7/WL 0
C4683 ch0 ch3 0.14583f
C4684 csel14 dlb 0.10216f
C4685 c_11_12/Q c_12_12/QB 0
C4686 c_13_3/Q c_14_3/Q 0.00634f
C4687 rc9/s/n3/a_162_47# VDD 0
C4688 rc9/WL c_9_5/Q 0
C4689 c_4_1/QB rc3/WL 0
C4690 rl0 rc1/WL 0
C4691 VDD rc5/s/n3/a_302_47# -0
C4692 c_14_9/QB pcb 0.00169f
C4693 c_12_10/Q c_11_10/QB 0
C4694 c_0_2/Q ch2 0
C4695 cl1 blb6 0
C4696 c_0_6/Q VDD 0.00756f
C4697 c_6_8/Q c_6_7/QB 0.01135f
C4698 blb6 VDD -0.00917f
C4699 rc15/WL rc14/s/wd/A 0
C4700 rl0 rc10/WL 0
C4701 VDD c_8_6/QB 0.00969f
C4702 ch1 csel2 0.02951f
C4703 dl blb4 0.02104f
C4704 VDD c_15_9/QB 0.01187f
C4705 bl8 c_10_7/QB 0.00303f
C4706 c_0_10/QB dl 0.0049f
C4707 bl3 rc9/WL 0.00159f
C4708 c_12_12/QB c_13_12/Q 0
C4709 c_11_13/Q c_10_13/QB 0
C4710 c_11_11/QB c_11_10/QB 0
C4711 c_10_3/QB VDD 0.00969f
C4712 blb13 c_9_14/Q 0.00303f
C4713 rc8/WL c_8_12/Q 0
C4714 c_9_1/QB rc9/WL 0
C4715 blb6 c_14_7/QB 0
C4716 VDD c_13_13/QB 0.00969f
C4717 c_8_12/Q c_8_13/Q 0
C4718 rc2/WL c_1_11/Q 0
C4719 rc5/WL c_6_3/QB 0
C4720 rc0/WL c_1_5/QB 0
C4721 c_15_2/Q c_15_1/QB 0.01135f
C4722 blb1 c_10_2/Q 0.00303f
C4723 blb6 c_9_7/QB 0
C4724 VDD c_6_7/QB 0.00969f
C4725 pcb rc15/WL 0.15379f
C4726 c_15_5/Q c_15_4/QB 0.01135f
C4727 rc12/WL c_13_0/QB 0
C4728 ch3 rl1 0.02782f
C4729 c_1_2/QB dl 0.0021f
C4730 bl13 c_10_12/QB 0.00303f
C4731 blb3 c_5_4/QB 0
C4732 rc5/WL c_5_4/Q 0
C4733 c_6_11/QB rc6/WL 0
C4734 pcb c_14_13/Q 0.00166f
C4735 c_15_0/QB VDD 0.01482f
C4736 c_12_5/QB blb4 0
C4737 c_11_6/Q c_11_7/Q 0
C4738 bl15 csel15 0.00807f
C4739 VDD c_2_13/QB 0.00969f
C4740 rl0 rc6/WL 0
C4741 c_12_6/Q bl7 0
C4742 c_10_14/Q c_9_14/QB 0
C4743 rl0 rh2 0.36737f
C4744 c_9_6/QB c_9_5/Q 0.00377f
C4745 cl0 rl2 0.02782f
C4746 c_6_15/Q c_6_14/Q 0
C4747 c_14_5/QB rc15/WL 0
C4748 c_0_7/QB c_0_6/QB 0
C4749 ch0 c_0_10/Q 0
C4750 bl12 rc9/WL 0.00159f
C4751 dlb rh1 0.02782f
C4752 c_9_12/QB c_9_13/QB 0
C4753 bl2 rc9/WL 0.00175f
C4754 c_3_8/QB c_3_7/Q 0.00377f
C4755 c_3_8/Q c_3_7/QB 0.01135f
C4756 bl11 rc9/WL 0.00159f
C4757 ch1 c_0_6/QB 0
C4758 c_13_3/QB rc14/WL 0
C4759 c_2_0/QB clkb 0
C4760 VDD c_14_9/Q 0.00756f
C4761 c_2_8/Q VDD 0.00756f
C4762 c_5_9/Q c_5_10/QB 0.00377f
C4763 c_5_9/QB c_5_10/Q 0.01135f
C4764 clkb c_4_1/Q 0
C4765 c_1_2/Q ch0 0
C4766 rc4/WL c_3_1/Q 0
C4767 c_4_15/QB c_4_14/QB 0
C4768 rc15/WL c_14_0/QB 0
C4769 c_8_12/QB rc9/WL 0
C4770 bl0 blb0 -0.00665f
C4771 c_13_0/QB rc13/WL 0.00535f
C4772 cs10/n/Y cs10/n/a_162_47# -0
C4773 c_10_14/QB c_10_15/Q 0.01135f
C4774 VDD c_8_4/Q 0.00756f
C4775 rc2/WL c_3_0/QB 0
C4776 bl12 c_4_11/QB 0.00303f
C4777 cs8/n/Y cs9/n/Y 0.02812f
C4778 rc2/WL c_3_8/QB 0
C4779 c_0_13/QB rc1/WL 0
C4780 VDD c_4_13/QB 0.00969f
C4781 blb1 rc9/WL 0.00178f
C4782 c_12_6/Q c_13_6/QB 0
C4783 c_12_6/QB c_13_6/Q 0
C4784 csel0 cl0 0.03238f
C4785 bl3 dlb 0
C4786 cs12/n/a_162_47# ch3 0.00134f
C4787 blb11 rc7/WL 0.00159f
C4788 c_9_3/Q bl4 0
C4789 pcb c_15_14/Q 0.00484f
C4790 ch1 blb8 0
C4791 bl1 rc1/s/wd/A 0
C4792 c_7_14/QB bl15 0.00303f
C4793 rc0/s/wd/A rc1/s/wd/A 0.02158f
C4794 VDD c_15_5/Q 0.015f
C4795 c_0_14/Q dlb 0
C4796 rc4/s/wd/A VDD -0.00408f
C4797 rc13/s/wd/A rc14/WL 0
C4798 rl3 ch3 0.02782f
C4799 ch1 csel15 0.03587f
C4800 c_2_14/Q blb13 0.00303f
C4801 c_10_14/QB c_10_15/QB 0
C4802 c_9_4/QB c_8_4/QB 0.01281f
C4803 c_4_3/Q c_5_3/QB 0
C4804 c_4_3/QB c_5_3/Q 0
C4805 cs13/n/Y dl 0
C4806 c_2_5/Q c_3_5/Q 0.00654f
C4807 c_15_4/Q c_15_5/Q 0
C4808 VDD c_10_8/Q 0.00756f
C4809 c_2_1/Q c_3_1/Q 0.00654f
C4810 c_6_10/QB bl11 0.00303f
C4811 c_15_11/QB pcb 0.00493f
C4812 rc14/WL c_13_8/Q 0
C4813 c_1_3/Q dl 0.00273f
C4814 c_1_3/QB dlb 0
C4815 bl12 dlb 0
C4816 blb9 rc1/WL 0.00159f
C4817 rc8/s/wd/A rh2 0.0369f
C4818 bl2 dlb 0
C4819 bl11 dlb 0
C4820 c_2_1/Q rc2/s/wd/A 0
C4821 bl1 c_10_0/Q 0
C4822 rh3 dl 0.04197f
C4823 csel14 cl0 0.02918f
C4824 c_4_7/Q c_3_7/Q 0.00634f
C4825 rc5/WL c_6_6/Q 0
C4826 c_1_12/QB dlb 0
C4827 c_1_12/Q dl 0.00273f
C4828 blb9 rc10/WL 0.00159f
C4829 c_2_8/Q c_3_8/Q 0.00654f
C4830 c_4_12/QB VDD 0.00969f
C4831 c_5_10/QB bl11 0.00303f
C4832 c_8_0/Q c_7_0/QB 0
C4833 c_8_0/QB c_7_0/Q 0
C4834 VDD c_14_7/Q 0.00756f
C4835 cs12/n/Y csel12 0.07585f
C4836 c_6_3/Q c_5_3/QB 0
C4837 clkb c_15_1/Q 0
C4838 cs6/n/Y dl 0
C4839 c_0_13/QB c_1_13/Q 0
C4840 c_3_14/Q rc3/WL 0
C4841 VDD c_7_0/QB 0.01264f
C4842 blb3 c_14_4/Q 0.00303f
C4843 blb10 c_11_11/Q 0.00303f
C4844 bl3 rc3/WL 0.00159f
C4845 c_14_5/Q c_14_6/Q 0
C4846 c_9_9/Q c_9_8/QB 0.01135f
C4847 csel4 dlb 0.10216f
C4848 c_11_9/QB blb8 0
C4849 rc0/WL c_1_13/QB 0
C4850 c_7_8/Q rc7/WL 0
C4851 c_9_4/QB VDD 0.00969f
C4852 c_2_2/QB rc3/WL 0
C4853 c_13_14/QB c_14_14/QB 0.0025f
C4854 c_13_6/QB c_13_5/QB 0
C4855 VDD c_9_13/Q 0.00756f
C4856 blb1 dlb 0.0282f
C4857 cl3 bl13 0
C4858 bl13 rc14/WL 0.00159f
C4859 c_6_3/QB rc7/WL 0
C4860 rc5/WL rc6/WL 0.88789f
C4861 c_0_6/Q csel6 0.00119f
C4862 c_2_11/Q c_1_11/QB 0
C4863 c_15_3/Q c_15_4/QB 0.00377f
C4864 csel6 blb6 0.00807f
C4865 ch3 bl7 0
C4866 c_3_13/Q blb12 0.00303f
C4867 c_7_7/Q VDD 0.00756f
C4868 rh3 rc15/s/n3/a_302_47# 0.0045f
C4869 blb9 rc6/WL 0.00159f
C4870 bl9 c_15_8/Q 0
C4871 c_10_2/QB c_11_2/QB 0.01281f
C4872 VDD c_8_14/Q 0.00756f
C4873 c_7_9/QB rc7/WL 0
C4874 rc0/WL c_1_7/QB 0
C4875 c_1_10/QB csel10 0
C4876 c_14_2/Q VDD 0.00756f
C4877 rc0/WL blb14 0.00289f
C4878 blb9 c_13_10/Q 0.00303f
C4879 c_3_10/QB rc3/WL 0
C4880 blb2 c_5_3/Q 0.00303f
C4881 c_8_2/Q c_7_2/Q 0.00634f
C4882 c_8_6/Q rc9/WL 0
C4883 bl10 c_3_9/QB 0.00303f
C4884 bl12 rc3/WL 0.00159f
C4885 c_10_11/Q bl12 0
C4886 csel14 blb13 0.00103f
C4887 rc0/WL c_0_0/Q 0.01507f
C4888 bl2 rc3/WL 0.00175f
C4889 c_6_2/Q VDD 0.00756f
C4890 cl0 rh1 0.02782f
C4891 bl11 rc3/WL 0.00159f
C4892 blb2 c_1_3/Q 0.00303f
C4893 blb9 c_12_10/QB 0
C4894 cl3 csel10 0.03848f
C4895 c_5_3/QB bl4 0.00303f
C4896 VDD rc4/WL 0.05907f
C4897 c_7_11/Q c_7_10/Q 0
C4898 VDD c_14_13/QB 0.00969f
C4899 c_0_7/Q bl8 0
C4900 rc8/WL c_7_12/QB 0
C4901 rc4/WL c_5_5/QB 0
C4902 ch2 blb11 0
C4903 c_3_15/Q c_3_14/Q 0
C4904 blb11 c_15_12/Q 0.00303f
C4905 bl1 rc11/s/wd/A 0
C4906 bl9 c_8_8/QB 0.00303f
C4907 c_1_3/QB bl4 0.00303f
C4908 cl1 bl14 0
C4909 c_6_4/Q c_6_3/QB 0.01135f
C4910 c_15_7/QB blb7 0
C4911 bl2 c_13_1/Q 0
C4912 cl2 blb4 0
C4913 VDD bl14 -0.00929f
C4914 blb7 csel8 0.00103f
C4915 rc5/WL c_5_14/QB 0
C4916 c_12_13/Q rc12/WL 0
C4917 cs1/n/Y ch0 0.09835f
C4918 c_13_1/QB c_13_0/Q 0.00377f
C4919 rc11/s/n3/a_302_47# bl0 0.00159f
C4920 c_0_15/QB blb14 0
C4921 blb1 rc3/WL 0.00178f
C4922 clkb c_5_0/Q 0
C4923 bl9 c_5_8/Q 0
C4924 c_6_4/Q c_5_4/Q 0.00634f
C4925 c_6_11/QB blb10 0
C4926 clkb c_9_1/Q 0
C4927 c_11_12/QB c_10_12/QB 0.01281f
C4928 ch1 cs6/n/a_162_47# 0.00134f
C4929 bl6 c_13_5/QB 0.00303f
C4930 bl3 cl0 0
C4931 c_15_3/Q VDD 0.015f
C4932 c_9_6/Q c_8_6/QB 0
C4933 c_9_6/QB c_8_6/Q 0
C4934 c_7_15/QB rc8/WL 0
C4935 csel4 bl4 0.00807f
C4936 rc2/s/wd/A rl2 0.05309f
C4937 c_10_4/QB rc10/WL 0
C4938 bl10 c_0_9/Q 0
C4939 c_3_6/Q c_3_7/Q 0
C4940 c_0_14/Q cl0 0
C4941 c_4_9/QB c_3_9/QB 0.0025f
C4942 rc11/WL c_10_7/Q 0
C4943 cs11/n/Y dl 0
C4944 c_2_1/Q VDD 0.00756f
C4945 c_7_14/Q c_7_13/Q 0
C4946 c_11_2/Q rc10/WL 0
C4947 dl c_1_0/Q 0.00273f
C4948 c_0_9/Q c_0_8/Q 0
C4949 clkb rc6/s/wd/A 0.09749f
C4950 c_15_3/Q c_15_4/Q 0
C4951 rc12/s/n3/a_302_47# rc12/s/wd/A -0
C4952 c_12_13/Q rc13/WL 0
C4953 c_4_1/QB c_3_1/Q 0
C4954 c_4_1/Q c_3_1/QB 0
C4955 rc2/WL dlb 0
C4956 cs3/n/Y ch1 0.00102f
C4957 c_4_4/Q c_3_4/QB 0
C4958 c_6_9/Q c_6_8/QB 0.01135f
C4959 clkb rh3 0.41749f
C4960 csel3 blb3 0.00807f
C4961 cl0 bl12 0
C4962 rc4/WL c_3_0/Q 0
C4963 c_0_11/Q rc1/WL 0
C4964 c_12_6/QB rc11/WL 0
C4965 blb9 c_14_10/QB 0
C4966 c_9_9/Q blb8 0.00303f
C4967 rc2/WL c_3_6/Q 0
C4968 c_4_14/Q c_5_14/QB 0
C4969 bl2 cl0 0
C4970 bl11 cl0 0
C4971 rc4/WL c_3_8/Q 0
C4972 c_3_13/QB blb12 0
C4973 bl13 c_6_12/Q 0
C4974 VDD c_9_14/Q 0.00756f
C4975 c_7_1/QB c_7_2/Q 0.01135f
C4976 c_7_1/Q c_7_2/QB 0.00377f
C4977 clkb c_13_0/Q 0
C4978 c_6_6/Q rc7/WL 0
C4979 c_14_11/Q rc13/WL 0
C4980 c_14_9/QB c_13_9/Q 0
C4981 bl6 ch3 0
C4982 rl0 rc5/s/wd/A 0.00388f
C4983 rh0 rc13/s/wd/A 0
C4984 blb13 c_3_14/Q 0.00303f
C4985 c_5_13/QB c_6_13/QB 0.0025f
C4986 c_10_6/QB rc10/WL 0
C4987 csel12 csel11 0.02813f
C4988 c_7_1/Q c_6_1/QB 0
C4989 c_7_1/QB c_6_1/Q 0
C4990 c_14_1/QB c_13_1/Q 0
C4991 c_0_5/Q dl 0.00931f
C4992 c_0_5/QB dlb 0.004f
C4993 rc7/WL c_8_3/QB 0
C4994 ch2 cs10/n/a_162_47# 0.00134f
C4995 c_0_4/Q bl5 0
C4996 c_15_0/QB blb0 0
C4997 rc13/WL rc14/WL 0.88789f
C4998 c_3_7/Q rc3/WL 0
C4999 rc2/WL csel7 0
C5000 csel4 cl0 0.03107f
C5001 c_1_13/QB blb12 0
C5002 blb13 c_0_14/Q 0.00303f
C5003 c_11_0/Q rc10/WL 0
C5004 pcb c_15_14/QB 0.00493f
C5005 c_14_6/Q VDD 0.00756f
C5006 c_0_1/Q VDD 0.00756f
C5007 VDD c_14_12/Q 0.00756f
C5008 c_6_0/Q c_5_0/Q 0.00634f
C5009 c_9_14/QB c_9_13/Q 0.00377f
C5010 cl2 cs13/n/Y 0
C5011 cl3 cs14/n/a_162_47# 0
C5012 c_0_0/QB dl 0.0049f
C5013 blb1 cl0 0
C5014 pcb blb4 0.07118f
C5015 rc6/WL rc7/WL 0.07019f
C5016 rc12/WL bl8 0.00159f
C5017 ch2 cs15/n/Y 0
C5018 c_14_6/Q c_14_7/QB 0.00377f
C5019 pcb c_15_1/Q 0.00484f
C5020 c_8_14/Q c_9_14/QB 0
C5021 c_8_14/QB c_9_14/Q 0
C5022 c_1_3/Q c_0_3/QB 0
C5023 c_1_3/QB c_0_3/Q 0
C5024 VDD c_12_1/Q 0.00756f
C5025 c_4_0/QB c_3_0/QB 0.0025f
C5026 rc6/WL c_6_14/QB 0
C5027 c_10_14/Q c_10_15/Q 0
C5028 rc0/s/n3/a_162_47# rl0 0.01123f
C5029 blb6 c_15_7/QB 0
C5030 c_14_5/QB blb4 0
C5031 blb5 rc1/WL 0.00159f
C5032 rc2/WL rc3/WL 0.07019f
C5033 rc15/WL c_14_15/Q 0
C5034 c_11_1/Q c_11_2/Q 0
C5035 ch3 csel12 0.25032f
C5036 ch0 blb14 0.00109f
C5037 c_11_9/Q c_11_10/QB 0.00377f
C5038 c_1_15/QB dlb 0
C5039 c_1_15/Q dl 0.00273f
C5040 rc8/WL c_7_2/QB 0
C5041 c_11_11/Q c_11_10/Q 0
C5042 rh3 cl2 0.02852f
C5043 c_1_6/QB c_1_5/Q 0.00377f
C5044 c_1_6/Q c_1_5/QB 0.01135f
C5045 c_2_9/Q c_2_8/QB 0.01135f
C5046 c_6_0/Q rc6/s/wd/A 0
C5047 c_14_5/Q c_14_4/QB 0.01135f
C5048 blb5 rc10/WL 0.00159f
C5049 c_8_6/Q c_8_7/Q 0
C5050 ch1 rl0 0.02798f
C5051 blb5 c_6_6/Q 0.00303f
C5052 c_11_0/Q rh2 0
C5053 c_2_3/Q c_2_2/Q 0
C5054 c_7_11/QB rc6/WL 0
C5055 ch0 c_0_0/Q 0
C5056 rc12/WL c_12_10/Q 0
C5057 cs2/n/Y csel2 0.07585f
C5058 c_0_13/QB csel13 0
C5059 c_6_15/Q c_5_15/QB 0
C5060 c_3_11/QB c_2_11/QB 0.01281f
C5061 cl2 cs6/n/Y 0.04836f
C5062 c_5_1/Q VDD 0.00756f
C5063 rc2/WL bl4 0.00159f
C5064 c_10_14/Q c_10_15/QB 0.00377f
C5065 c_8_5/QB blb4 0
C5066 c_14_15/QB c_14_14/QB 0
C5067 bl8 rc13/WL 0.00159f
C5068 rc0/WL csel5 0.02369f
C5069 c_2_8/QB c_2_7/Q 0.00377f
C5070 c_4_12/QB c_4_11/Q 0.00377f
C5071 c_4_12/Q c_4_11/QB 0.01135f
C5072 clkb rc10/s/wd/A 0.09749f
C5073 rc4/s/wd/A blb0 0
C5074 c_6_4/Q rc6/WL 0
C5075 cl1 rl2 0.02782f
C5076 csel1 csel2 0.01915f
C5077 rc5/WL blb10 0.00159f
C5078 rc12/WL c_11_11/QB 0
C5079 c_4_4/Q c_5_4/Q 0.00654f
C5080 VDD rl2 0.53692f
C5081 c_15_12/QB rc14/WL 0
C5082 cl3 csel2 0.03848f
C5083 bl0 rc4/s/n3/a_162_47# 0
C5084 c_13_15/Q c_12_15/QB 0
C5085 c_13_15/QB c_12_15/Q 0
C5086 rc0/WL rc0/s/wd/A -0.00118f
C5087 bl1 rc0/WL 0.00344f
C5088 c_2_14/Q VDD 0.00756f
C5089 c_9_8/Q rc10/WL 0
C5090 c_2_3/Q c_1_3/Q 0.00634f
C5091 blb5 rc6/WL 0.00159f
C5092 c_5_14/QB c_6_14/QB 0.0025f
C5093 c_14_13/QB c_14_12/QB 0
C5094 rc8/WL c_9_3/QB 0
C5095 rc12/WL c_11_10/QB 0
C5096 c_11_0/Q c_11_1/Q 0
C5097 c_0_9/QB dlb 0.004f
C5098 c_0_9/Q dl 0.00931f
C5099 c_14_8/Q bl9 0
C5100 c_10_9/QB c_9_9/QB 0.0025f
C5101 csel3 ch3 0.02926f
C5102 rc13/WL c_12_10/Q 0
C5103 cs4/n/Y csel4 0.07585f
C5104 c_1_11/QB csel11 0
C5105 rc2/WL c_3_15/Q 0
C5106 rc12/s/wd/A rc11/s/wd/A 0.02007f
C5107 clkb c_1_0/Q 0
C5108 bl9 c_0_8/QB 0.00303f
C5109 rc2/s/wd/A rh1 0
C5110 rc7/WL c_7_5/QB 0
C5111 c_7_3/QB c_8_3/Q 0
C5112 bl9 rc0/WL 0.00289f
C5113 c_4_1/QB VDD 0.00969f
C5114 rc9/s/n3/a_162_47# bl0 0
C5115 bl3 c_8_2/QB 0.00303f
C5116 c_15_10/QB VDD 0.01187f
C5117 c_13_0/QB c_12_0/Q 0
C5118 rc5/WL bl15 0.00159f
C5119 blb6 c_13_7/Q 0.00303f
C5120 c_11_7/QB c_11_8/QB 0
C5121 csel9 rc1/WL 0
C5122 bl0 rc5/s/n3/a_302_47# 0.00159f
C5123 cl1 csel0 0.03044f
C5124 c_4_13/Q rc3/WL 0
C5125 bl1 rc9/s/wd/A 0
C5126 c_12_8/Q c_11_8/Q 0.00634f
C5127 VDD csel0 0.01855f
C5128 rc1/s/wd/A c_1_1/QB 0
C5129 rc2/s/wd/A rc1/s/n3/a_302_47# 0
C5130 rh3 rc14/s/wd/A 0.03722f
C5131 c_1_6/QB rc1/WL 0
C5132 c_7_9/QB c_8_9/QB 0.0025f
C5133 c_8_5/Q c_9_5/Q 0.00654f
C5134 rc5/s/wd/A rc5/WL -0.00118f
C5135 rc4/WL c_4_11/Q 0
C5136 rc8/WL c_9_11/Q 0
C5137 c_14_4/QB c_15_4/QB 0.01281f
C5138 c_11_5/Q rc10/WL 0
C5139 c_2_4/Q c_3_4/Q 0.00654f
C5140 pcb rc6/s/wd/A 0
C5141 blb3 rc8/WL 0.00159f
C5142 c_13_14/Q c_13_15/Q 0
C5143 c_0_2/Q rc0/WL 0
C5144 ch1 c_0_13/QB 0
C5145 c_10_3/QB c_11_3/Q 0
C5146 ch2 rh2 0.02782f
C5147 c_2_9/QB rc1/WL 0
C5148 c_12_8/Q c_13_8/QB 0
C5149 c_14_4/Q c_14_3/QB 0.01135f
C5150 pcb rh3 0.08151f
C5151 cl0 c_0_5/QB 0
C5152 c_3_11/QB blb10 0
C5153 c_10_7/Q rc9/WL 0
C5154 clkb c_0_0/QB 0
C5155 c_5_12/Q c_6_12/QB 0
C5156 c_12_11/Q rc11/WL 0
C5157 cl3 blb8 0
C5158 csel14 cl1 0.06555f
C5159 c_5_6/Q bl7 0
C5160 rc14/WL blb8 0.00159f
C5161 csel14 VDD 0.02187f
C5162 cl2 cs11/n/Y 0.04756f
C5163 c_2_7/QB rc1/WL 0
C5164 VDD c_15_7/Q 0.015f
C5165 c_3_10/Q rc3/WL 0
C5166 rc4/WL blb0 0.00236f
C5167 rc11/WL blb4 0.00159f
C5168 cl3 csel15 0.04036f
C5169 c_2_0/QB c_3_0/QB 0.01281f
C5170 c_4_14/Q bl15 0
C5171 c_4_12/Q rc3/WL 0
C5172 rc13/WL c_14_10/Q 0
C5173 c_1_10/QB c_1_10/Q -0
C5174 bl2 c_3_1/Q 0
C5175 c_12_11/QB VDD 0.00969f
C5176 rc2/WL blb13 0.00159f
C5177 VDD rc7/s/wd/A -0.00408f
C5178 c_11_12/QB c_11_11/QB 0
C5179 c_5_10/Q rc4/WL 0
C5180 rc1/s/wd/A c_1_0/QB 0.00246f
C5181 blb1 c_8_2/QB 0
C5182 VDD c_9_3/Q 0.00756f
C5183 c_15_7/QB c_14_7/Q 0
C5184 c_15_7/Q c_14_7/QB 0
C5185 c_0_4/Q dl 0.00931f
C5186 bl6 c_1_5/QB 0.00303f
C5187 ch1 blb9 0
C5188 rh3 c_14_0/QB 0
C5189 c_10_4/Q c_9_4/Q 0.00634f
C5190 c_7_12/Q c_8_12/Q 0.00634f
C5191 dlb cs5/n/Y 0
C5192 c_12_11/Q c_13_11/Q 0.00654f
C5193 bl1 c_12_0/QB 0.00303f
C5194 ch0 cs1/n/a_162_47# 0.00134f
C5195 c_6_5/QB c_6_6/Q 0.01135f
C5196 c_9_7/Q c_9_8/Q 0
C5197 VDD c_13_15/QB 0.00479f
C5198 c_14_0/QB c_13_0/Q 0
C5199 c_14_4/QB VDD 0.00969f
C5200 cs12/n/Y dl 0
C5201 c_1_6/Q c_1_7/QB 0.00377f
C5202 c_1_6/QB c_1_7/Q 0.01135f
C5203 cs4/n/a_162_47# cs5/n/Y 0
C5204 cs8/n/Y dlb 0
C5205 ch3 bl5 0
C5206 c_7_3/Q rc7/WL 0
C5207 c_11_4/Q rc10/WL 0
C5208 blb6 c_6_7/Q 0.00303f
C5209 rc11/WL c_11_1/QB 0
C5210 blb10 c_0_11/Q 0.00303f
C5211 rc2/s/wd/A blb1 0
C5212 rc4/s/wd/A bl0 0.00934f
C5213 blb10 rc7/WL 0.00159f
C5214 c_15_4/Q c_14_4/QB 0
C5215 cl1 rh1 0.02782f
C5216 ch1 cs10/n/Y 0
C5217 ch0 csel5 0.03716f
C5218 c_2_1/Q blb0 0.00303f
C5219 c_6_5/QB rc6/WL 0
C5220 c_5_9/Q c_6_9/QB 0
C5221 bl8 blb8 -0.00665f
C5222 c_10_5/Q blb4 0.00303f
C5223 VDD rh1 0.53827f
C5224 c_9_14/Q c_10_14/QB 0
C5225 c_12_1/QB c_12_1/Q 0
C5226 c_0_12/Q ch3 0
C5227 rc0/WL c_1_14/Q 0
C5228 c_9_0/Q c_8_0/Q 0.00654f
C5229 rc0/s/wd/A ch0 0
C5230 bl1 ch0 0.00109f
C5231 c_5_9/Q VDD 0.00756f
C5232 c_7_13/QB rc8/WL 0
C5233 rc14/s/n3/a_162_47# rh3 0.01115f
C5234 c_7_13/QB c_8_13/Q 0
C5235 c_7_8/Q c_8_8/QB 0
C5236 c_9_0/Q VDD 0.01304f
C5237 c_0_9/QB cl0 0
C5238 VDD c_5_5/Q 0.00756f
C5239 c_3_4/QB c_3_5/Q 0.01135f
C5240 rc15/s/wd/A c_15_1/QB 0
C5241 pcb rc10/s/wd/A 0
C5242 VDD rc1/s/n3/a_302_47# -0
C5243 c_6_9/Q c_7_9/Q 0.00654f
C5244 rc12/WL c_13_3/QB 0
C5245 cs8/n/Y csel7 0.00301f
C5246 c_2_13/Q blb12 0.00303f
C5247 VDD c_9_5/Q 0.00756f
C5248 c_4_5/Q blb4 0.00303f
C5249 c_7_11/QB blb10 0
C5250 c_1_7/Q c_2_7/QB 0
C5251 c_1_7/QB c_2_7/Q 0
C5252 c_2_14/Q c_2_15/Q 0
C5253 c_6_11/QB c_6_10/Q 0.00377f
C5254 rc15/WL bl4 0.00298f
C5255 rc14/WL c_15_1/QB 0
C5256 bl10 ch3 0
C5257 c_2_8/Q blb7 0.00303f
C5258 c_15_12/Q c_15_13/QB 0.00377f
C5259 c_12_2/Q c_13_2/Q 0.00654f
C5260 c_4_12/QB c_3_12/Q 0
C5261 c_2_9/Q c_3_9/Q 0.00654f
C5262 rc2/WL c_1_8/Q 0
C5263 bl1 rc3/s/wd/A 0
C5264 bl10 c_10_9/QB 0.00303f
C5265 c_0_2/QB dl 0.0049f
C5266 bl9 ch0 0.00109f
C5267 rc1/s/wd/A rc1/WL -0.00118f
C5268 bl15 rc7/WL 0.00159f
C5269 c_14_7/Q c_13_7/Q 0.00634f
C5270 c_6_9/Q c_6_10/QB 0.00377f
C5271 blb9 c_11_10/Q 0.00303f
C5272 csel1 c_1_1/Q 0
C5273 bl3 cl1 0
C5274 VDD c_3_14/Q 0.00756f
C5275 ch3 c_0_8/Q 0
C5276 bl3 VDD -0.00929f
C5277 rc2/WL c_2_6/QB 0
C5278 c_5_7/QB rc6/WL 0
C5279 bl15 c_6_14/QB 0.00303f
C5280 c_9_2/QB rc10/WL 0
C5281 blb3 dl 0.02104f
C5282 VDD c_5_0/QB 0.01264f
C5283 c_9_1/QB VDD 0.00969f
C5284 ch2 cs11/n/a_162_47# 0.00134f
C5285 c_0_1/Q blb0 0.00303f
C5286 VDD c_2_2/QB 0.00969f
C5287 c_6_12/Q c_6_13/Q 0
C5288 c_5_14/Q c_6_14/Q 0.00634f
C5289 VDD c_0_14/Q 0.00756f
C5290 bl1 rl1 0
C5291 rc0/s/wd/A rl1 0.00312f
C5292 c_11_13/Q rc11/WL 0
C5293 blb6 c_3_7/QB 0
C5294 c_13_3/QB rc13/WL 0
C5295 rc12/WL rc13/s/wd/A 0
C5296 c_4_0/QB rc3/WL 0
C5297 c_12_6/Q c_12_5/QB 0.01135f
C5298 c_12_6/QB c_12_5/Q 0.00377f
C5299 c_15_8/QB rc14/WL 0
C5300 c_0_9/Q c_1_9/Q 0.00654f
C5301 VDD c_5_3/QB 0.00969f
C5302 rc2/WL c_2_4/QB 0
C5303 rl3 rc8/s/n3/a_162_47# 0.0024f
C5304 blb2 c_9_3/QB 0
C5305 rc12/WL c_11_14/Q 0
C5306 blb0 c_12_1/Q 0.00303f
C5307 c_0_2/Q ch0 0
C5308 c_11_13/QB VDD 0.00969f
C5309 c_11_6/Q rc11/WL 0
C5310 cl1 bl12 0
C5311 c_3_10/QB VDD 0.00969f
C5312 c_7_14/Q rc6/WL 0
C5313 cl3 cs6/n/a_162_47# 0
C5314 c_1_3/QB VDD 0.00969f
C5315 c_5_9/QB rc4/WL 0
C5316 VDD bl12 -0.00929f
C5317 c_6_5/QB c_7_5/QB 0.01281f
C5318 c_8_11/QB rc9/WL 0
C5319 rc12/WL c_13_8/Q 0
C5320 c_10_0/Q rc10/WL 0.01507f
C5321 bl2 cl1 0
C5322 bl11 cl1 0
C5323 c_8_11/Q c_8_12/Q 0
C5324 bl11 VDD -0.00929f
C5325 bl2 VDD -0.00929f
C5326 c_15_0/QB c_14_0/Q 0
C5327 blb7 c_10_8/Q 0.00303f
C5328 rc1/s/wd/A rh2 0
C5329 c_13_5/Q c_13_4/QB 0.01135f
C5330 c_11_6/QB VDD 0.00969f
C5331 rc2/WL c_3_1/Q 0
C5332 blb11 c_0_12/QB 0
C5333 c_3_12/Q rc4/WL 0
C5334 c_14_2/QB bl3 0.00303f
C5335 c_1_12/QB VDD 0.00969f
C5336 cs3/n/Y cs2/n/Y 0.02812f
C5337 bl0 rc4/WL 0.06726f
C5338 c_8_5/Q c_8_6/Q 0
C5339 c_3_2/Q c_4_2/Q 0.00634f
C5340 rc2/s/wd/A rc2/WL -0.00118f
C5341 c_5_1/Q blb0 0.00303f
C5342 c_9_13/QB rc10/WL 0
C5343 rc13/s/wd/A rc13/WL -0.00118f
C5344 VDD c_8_12/QB 0.00969f
C5345 c_1_12/Q c_1_11/Q 0
C5346 c_10_11/QB c_9_11/Q 0
C5347 ch1 c_0_11/Q 0
C5348 csel4 cl1 0.02913f
C5349 bl3 c_6_2/QB 0.00303f
C5350 csel4 VDD 0.02187f
C5351 c_14_15/Q c_13_15/Q 0.00634f
C5352 cl0 cs5/n/Y 0.0472f
C5353 blb0 rl2 0
C5354 cs3/n/Y cl3 0.06061f
C5355 ch2 blb10 0
C5356 blb6 c_6_7/QB 0
C5357 cl1 blb1 0.0013f
C5358 rh0 rc1/s/n3/a_162_47# 0.01115f
C5359 c_6_12/Q c_5_12/QB 0
C5360 blb1 VDD -0.00917f
C5361 c_10_0/Q rh2 0
C5362 bl1 rl3 0
C5363 rc13/WL c_13_8/Q 0
C5364 dl c_1_14/QB 0.0021f
C5365 rl3 rc0/s/wd/A 0.00121f
C5366 dl csel11 0.08427f
C5367 rc12/WL bl13 0.00159f
C5368 rl0 rc11/s/n3/a_162_47# 0.0024f
C5369 blb11 rc0/WL 0.00289f
C5370 c_4_9/Q c_4_10/QB 0.00377f
C5371 c_4_9/QB c_4_10/Q 0.01135f
C5372 cs15/n/a_162_47# cs15/n/Y -0
C5373 cs8/n/Y cl0 0.04796f
C5374 c_3_4/Q rc4/WL 0
C5375 clkb c_4_0/Q 0
C5376 ch2 csel13 0.0368f
C5377 c_12_5/QB c_13_5/QB 0.01281f
C5378 rc4/s/wd/A rc4/s/n3/a_162_47# -0.00121f
C5379 rc15/WL blb13 0.00298f
C5380 c_4_1/QB blb0 0
C5381 rc9/WL blb4 0.00159f
C5382 rc12/s/wd/A c_12_0/QB 0.00246f
C5383 ch2 bl15 0
C5384 blb14 c_5_15/QB 0
C5385 c_14_9/Q c_15_9/QB 0
C5386 csel0 blb0 0.00807f
C5387 c_12_6/Q c_12_7/Q 0
C5388 rc5/WL c_6_10/Q 0
C5389 c_0_3/QB c_0_4/Q 0.01135f
C5390 c_4_10/QB c_4_11/QB 0
C5391 c_7_7/Q c_6_7/Q 0.00654f
C5392 rc11/WL rc10/s/wd/A 0
C5393 rc11/s/wd/A rc10/WL 0
C5394 ch1 blb5 0
C5395 c_7_13/Q blb12 0.00303f
C5396 ch3 dl 0.03417f
C5397 blb9 c_6_10/Q 0.00303f
C5398 c_14_2/QB blb1 0
C5399 c_14_1/QB VDD 0.00969f
C5400 rc13/WL bl13 0.00159f
C5401 rc0/WL c_1_1/QB 0
C5402 rc4/WL blb7 0.00159f
C5403 c_8_2/Q c_8_3/QB 0.00377f
C5404 c_2_5/Q bl6 0
C5405 ch2 c_0_4/QB 0
C5406 c_5_6/QB c_6_6/Q 0
C5407 rl0 rc15/s/wd/A 0.00281f
C5408 rc12/WL c_11_9/Q 0
C5409 rh2 rc10/s/n3/a_302_47# 0.0045f
C5410 c_9_10/QB c_9_11/QB 0
C5411 c_9_10/Q c_9_11/Q 0
C5412 c_2_1/QB c_2_2/QB 0
C5413 c_15_10/Q bl10 0
C5414 c_6_0/QB c_6_1/Q 0.01135f
C5415 c_6_0/Q c_6_1/QB 0.00377f
C5416 c_6_2/QB blb1 0
C5417 cl2 cs12/n/Y 0
C5418 cl3 rl0 0.04111f
C5419 rl0 rc14/WL 0
C5420 rc6/WL c_5_8/Q 0
C5421 bl1 c_6_0/QB 0.00303f
C5422 c_2_6/Q c_3_6/Q 0.00654f
C5423 VDD c_3_7/Q 0.00756f
C5424 c_10_10/QB c_10_9/Q 0.00377f
C5425 c_7_10/Q rc8/WL 0
C5426 c_9_15/QB rc8/WL 0
C5427 cs4/n/Y cs5/n/Y 0.02812f
C5428 c_2_0/QB rc3/WL 0
C5429 rc11/s/wd/A rh2 0.0369f
C5430 c_11_12/Q c_12_12/Q 0.00634f
C5431 c_5_6/QB rc6/WL 0
C5432 c_4_1/Q rc3/WL 0
C5433 blb13 c_15_14/Q 0.00303f
C5434 bl2 c_2_1/QB 0.00303f
C5435 rc6/s/n3/a_162_47# rc6/s/wd/A -0.00121f
C5436 c_0_7/QB ch2 0
C5437 blb15 ch3 0
C5438 csel15 c_0_15/Q 0.00119f
C5439 c_9_0/QB c_10_0/QB 0.0025f
C5440 c_14_2/QB c_14_1/QB 0
C5441 c_5_10/QB c_4_10/QB 0.01281f
C5442 blb0 rc7/s/wd/A 0
C5443 c_13_9/QB c_12_9/QB 0.01281f
C5444 VDD c_8_6/Q 0.00756f
C5445 ch1 ch2 4.31284f
C5446 rc2/s/n3/a_162_47# clkb 0.00107f
C5447 rc2/WL VDD 0.05907f
C5448 dlb blb4 0.0282f
C5449 c_0_10/QB dlb 0.004f
C5450 c_0_10/Q dl 0.00931f
C5451 VDD c_15_9/Q 0.015f
C5452 c_11_11/Q c_11_10/QB 0.01135f
C5453 c_4_15/QB rc5/WL 0
C5454 c_12_12/Q c_13_12/Q 0.00654f
C5455 rc0/WL c_1_0/QB 0
C5456 blb6 c_14_7/Q 0.00303f
C5457 c_9_1/Q rc9/WL 0.00103f
C5458 VDD c_13_13/Q 0.00756f
C5459 rc12/WL c_11_0/QB 0
C5460 rc3/s/n3/a_162_47# rc3/s/wd/A -0.00121f
C5461 bl13 c_15_12/QB 0.00303f
C5462 bl13 c_11_12/QB 0.00303f
C5463 c_0_2/QB c_0_3/QB 0
C5464 rc0/WL c_1_5/Q 0
C5465 rc12/s/wd/A rl1 0.00312f
C5466 blb2 ch3 0
C5467 rc11/s/wd/A c_11_1/Q 0
C5468 ch1 csel9 0.03695f
C5469 c_15_15/QB c_14_15/QB 0.01281f
C5470 c_2_6/Q rc3/WL 0
C5471 ch1 c_1_6/QB 0
C5472 c_10_1/QB c_9_1/QB 0.0025f
C5473 VDD c_0_5/QB 0.00969f
C5474 c_1_2/Q dl 0.00273f
C5475 c_1_2/QB dlb 0
C5476 c_15_0/Q VDD 0.02048f
C5477 c_14_4/QB c_13_4/Q 0
C5478 c_2_3/QB c_3_3/QB 0.01281f
C5479 c_6_11/Q rc6/WL 0
C5480 c_12_5/Q blb4 0.00303f
C5481 blb3 cl2 0
C5482 rc11/WL c_12_2/Q 0
C5483 c_10_14/Q c_9_14/Q 0.00634f
C5484 c_7_7/Q blb6 0.00303f
C5485 rc5/WL c_6_13/QB 0
C5486 c_14_5/Q rc15/WL 0
C5487 rc12/WL rc13/WL 0.07019f
C5488 rc12/s/n3/a_162_47# VDD 0
C5489 c_9_6/Q c_9_5/Q 0
C5490 c_13_14/QB c_12_14/QB 0.01281f
C5491 bl2 c_0_1/QB 0.00303f
C5492 c_0_7/Q c_0_6/QB 0.01135f
C5493 rc4/WL c_3_7/QB 0
C5494 bl0 rl2 0.01657f
C5495 blb0 rh1 0
C5496 c_9_12/Q c_9_13/QB 0.00377f
C5497 c_3_8/Q c_3_7/Q 0
C5498 c_0_12/QB rc1/WL 0
C5499 c_4_10/QB rc3/WL 0
C5500 c_5_6/Q c_4_6/QB 0
C5501 c_13_3/Q rc14/WL 0
C5502 c_2_0/Q clkb 0
C5503 pcb c_14_14/QB 0.00169f
C5504 blb9 c_8_10/QB 0
C5505 c_4_15/Q c_4_14/QB 0.01135f
C5506 c_5_9/Q c_5_10/Q 0
C5507 bl2 c_12_1/QB 0.00303f
C5508 bl2 c_10_1/QB 0.00303f
C5509 blb11 ch0 0.00109f
C5510 blb6 rc4/WL 0.00159f
C5511 c_4_15/QB c_4_14/Q 0.00377f
C5512 c_14_8/QB VDD 0.00969f
C5513 c_8_12/Q rc9/WL 0
C5514 blb4 rc3/WL 0.00159f
C5515 c_7_1/QB rc6/WL 0
C5516 cs14/n/Y cs15/n/Y 0.02812f
C5517 c_7_7/Q c_6_7/QB 0
C5518 rc14/WL c_13_12/QB 0
C5519 VDD c_1_15/QB 0.00479f
C5520 rc2/WL c_3_0/Q 0
C5521 bl12 c_4_11/Q 0
C5522 c_6_11/QB c_6_12/Q 0.01135f
C5523 blb11 c_11_12/Q 0.00303f
C5524 c_7_10/QB c_7_9/Q 0.00377f
C5525 c_1_10/QB blb9 0
C5526 rc2/WL c_3_8/Q 0
C5527 VDD c_4_13/Q 0.00756f
C5528 c_5_15/Q c_6_15/QB 0
C5529 c_12_6/Q c_13_6/Q 0.00654f
C5530 clkb ch3 0.03881f
C5531 bl6 csel5 0.00103f
C5532 c_14_8/QB c_14_7/QB 0
C5533 c_14_13/QB c_13_13/QB 0.0025f
C5534 rl3 rc12/s/wd/A 0.00121f
C5535 csel0 bl0 0.00807f
C5536 c_0_8/QB rc1/WL 0
C5537 rc7/WL c_6_10/Q 0
C5538 rc0/WL rc1/WL 0.06978f
C5539 c_9_1/QB blb0 0
C5540 bl4 blb4 -0.00665f
C5541 c_4_12/QB c_4_13/QB 0
C5542 c_7_14/Q bl15 0
C5543 bl14 c_13_13/QB 0.00303f
C5544 c_6_10/QB c_7_10/QB 0.01281f
C5545 rc3/s/n3/a_162_47# rl3 0.01123f
C5546 blb11 c_13_12/Q 0.00303f
C5547 c_9_4/QB c_8_4/Q 0
C5548 ch0 c_1_1/QB 0
C5549 cl3 blb9 0
C5550 blb9 rc14/WL 0.00159f
C5551 cs13/n/Y dlb 0
C5552 c_4_3/Q c_5_3/Q 0.00654f
C5553 rc12/WL c_11_12/QB 0
C5554 cl2 csel11 0.05854f
C5555 rc13/s/n3/a_302_47# VDD -0
C5556 VDD c_0_9/QB 0.00969f
C5557 c_2_13/QB bl14 0.00303f
C5558 c_15_11/Q pcb 0.00484f
C5559 VDD c_6_6/QB 0.00969f
C5560 c_11_7/QB rc10/WL 0
C5561 rc15/WL c_15_4/QB 0
C5562 c_12_9/QB c_12_10/QB 0
C5563 c_2_1/QB rc2/WL 0
C5564 rh3 dlb 0.02852f
C5565 c_3_10/Q VDD 0.00756f
C5566 c_10_3/Q rc10/WL 0
C5567 rc12/WL c_11_5/QB 0
C5568 c_1_5/QB dl 0.0021f
C5569 blb3 pcb 0.07118f
C5570 c_3_9/QB c_3_8/QB 0
C5571 c_0_15/QB rc1/WL 0
C5572 c_5_10/Q bl11 0
C5573 c_4_12/Q VDD 0.00756f
C5574 cl3 cs10/n/Y 0.01311f
C5575 c_5_14/Q c_5_15/QB 0.00377f
C5576 rc9/WL rc10/s/wd/A 0
C5577 c_8_0/Q c_7_0/Q 0.00634f
C5578 rc9/s/wd/A rc10/WL 0
C5579 c_6_3/Q c_5_3/Q 0.00634f
C5580 cs6/n/Y dlb 0
C5581 ch3 c_0_3/QB 0
C5582 bl0 rc7/s/wd/A 0.00934f
C5583 VDD c_7_0/Q 0.01304f
C5584 c_12_8/QB c_11_8/QB 0.0025f
C5585 cl2 ch3 0.34574f
C5586 cl0 blb4 0.00156f
C5587 c_4_13/QB rc4/WL 0
C5588 c_6_12/QB c_7_12/Q 0
C5589 c_9_9/Q c_9_8/Q 0
C5590 cl0 c_0_10/QB 0
C5591 c_14_9/QB VDD 0.00969f
C5592 c_11_9/Q blb8 0.00303f
C5593 rh0 rl0 0.3761f
C5594 rc5/WL bl8 0.00159f
C5595 rc0/WL c_1_13/Q 0
C5596 c_2_2/Q rc3/WL 0
C5597 c_2_10/Q rc1/WL 0
C5598 c_13_6/Q c_13_5/QB 0.01135f
C5599 c_13_6/QB c_13_5/Q 0.00377f
C5600 cs0/n/a_162_47# cl0 0.00134f
C5601 rc15/WL c_15_5/QB 0
C5602 c_13_14/QB c_14_14/Q 0
C5603 c_13_14/Q c_14_14/QB 0
C5604 csel14 c_0_14/QB 0
C5605 bl9 c_12_8/QB 0.00303f
C5606 rc8/WL blb14 0.00159f
C5607 c_2_11/Q c_1_11/Q 0.00634f
C5608 c_4_13/QB bl14 0.00303f
C5609 ch0 c_1_0/QB 0
C5610 rc4/s/wd/A rc4/WL -0.00118f
C5611 c_14_15/QB blb14 0
C5612 bl13 c_5_12/QB 0.00303f
C5613 blb2 c_15_3/QB 0
C5614 ch0 cs15/n/Y 0
C5615 rc0/WL c_1_7/Q 0
C5616 c_1_10/Q csel10 0
C5617 c_12_13/QB blb12 0
C5618 csel6 rc2/WL 0
C5619 rc2/WL c_2_15/Q 0
C5620 csel7 cs6/n/Y 0
C5621 rh2 rc9/s/wd/A 0.03724f
C5622 cs1/n/Y dl 0
C5623 bl10 c_3_9/Q 0
C5624 c_6_13/QB rc7/WL 0
C5625 rc7/s/n3/a_162_47# VDD 0
C5626 rc15/WL VDD 0.76786f
C5627 blb2 c_14_3/QB 0
C5628 c_15_15/QB blb15 0
C5629 rc12/WL c_12_4/QB 0
C5630 bl0 rh1 0.01321f
C5631 VDD c_14_13/Q 0.00756f
C5632 blb9 c_12_10/Q 0.00303f
C5633 c_5_3/Q bl4 0
C5634 c_6_13/QB c_6_14/QB 0
C5635 blb13 c_15_14/QB 0
C5636 c_8_10/QB rc7/WL 0
C5637 c_14_0/Q rl2 0
C5638 rc12/WL blb8 0.00159f
C5639 c_11_15/QB c_12_15/QB 0.0025f
C5640 bl9 c_8_8/Q 0
C5641 c_9_5/QB blb4 0
C5642 rc15/WL c_14_7/QB 0
C5643 c_15_7/Q blb7 0
C5644 c_1_3/Q bl4 0
C5645 c_4_12/QB rc4/WL 0
C5646 c_14_1/QB blb0 0
C5647 bl0 rc1/s/n3/a_302_47# 0.00159f
C5648 rc5/WL c_6_12/Q 0
C5649 c_11_4/QB rc12/WL 0
C5650 cl1 cs5/n/Y 0.04813f
C5651 c_10_2/QB rc10/WL 0
C5652 rc15/WL c_15_4/Q 0
C5653 rl3 rc15/s/n3/a_162_47# 0.01123f
C5654 c_14_5/QB c_13_5/QB 0.0025f
C5655 VDD cs5/n/Y 0.01448f
C5656 c_1_0/QB rl1 0
C5657 rc9/s/n3/a_162_47# rl2 0.0024f
C5658 c_14_15/QB c_15_15/Q 0
C5659 c_13_1/Q c_13_0/Q 0
C5660 c_6_11/Q blb10 0.00303f
C5661 blb9 c_11_10/QB 0
C5662 rc5/s/n3/a_302_47# rl2 0.00105f
C5663 bl6 c_13_5/Q 0
C5664 blb12 rc1/WL 0.00159f
C5665 rc13/WL c_12_4/QB 0
C5666 cs8/n/Y cl1 0
C5667 c_9_6/Q c_8_6/Q 0.00654f
C5668 cs8/n/Y VDD 0.01448f
C5669 c_10_4/Q rc10/WL 0
C5670 c_14_2/QB rc15/WL 0
C5671 rc13/WL blb8 0.00159f
C5672 c_10_10/QB rc10/WL 0
C5673 c_9_13/Q bl14 0
C5674 blb12 rc10/WL 0.00159f
C5675 rh0 rc8/s/wd/A 0
C5676 c_1_15/QB c_2_15/Q 0
C5677 c_4_9/QB c_3_9/Q 0
C5678 c_4_9/Q c_3_9/QB 0
C5679 cs5/n/a_162_47# cs5/n/Y -0
C5680 c_8_15/Q rc8/WL 0
C5681 rc8/WL c_9_12/QB 0
C5682 cs11/n/Y dlb 0
C5683 c_4_0/QB VDD 0.01264f
C5684 c_10_7/Q c_10_8/QB 0.00377f
C5685 pcb ch3 0.02782f
C5686 cs13/n/Y cl0 0.0472f
C5687 c_2_10/QB c_3_10/QB 0.01281f
C5688 c_7_13/QB c_7_12/Q 0.00377f
C5689 VDD c_15_14/Q 0.015f
C5690 c_15_6/QB rc14/WL 0
C5691 ch3 cs9/n/Y 0
C5692 c_10_7/Q VDD 0.00756f
C5693 c_4_1/Q c_3_1/Q 0.00634f
C5694 c_2_0/QB rc2/s/wd/A 0.00246f
C5695 rc2/WL blb0 0.00236f
C5696 c_2_10/QB bl11 0.00303f
C5697 c_6_9/Q c_6_8/Q 0
C5698 c_11_12/Q rc10/WL 0
C5699 blb9 c_14_10/Q 0.00303f
C5700 c_12_6/Q rc11/WL 0
C5701 c_8_11/Q c_9_11/Q 0.00654f
C5702 c_2_14/Q c_2_13/QB 0.01135f
C5703 blb3 c_7_4/Q 0.00303f
C5704 rh3 cl0 0.02852f
C5705 c_1_13/QB dl 0.0021f
C5706 c_9_4/Q bl5 0
C5707 c_15_10/QB c_15_9/QB 0
C5708 c_7_1/Q c_7_2/Q 0
C5709 rc6/WL blb12 0.00159f
C5710 c_14_13/QB bl14 0.00303f
C5711 rc4/WL bl14 0.00159f
C5712 c_15_11/QB VDD 0.01187f
C5713 rc14/s/n3/a_302_47# rl1 0.00105f
C5714 blb3 rc11/WL 0.00159f
C5715 c_12_6/QB VDD 0.00969f
C5716 rl0 rc13/s/wd/A 0.00388f
C5717 c_10_6/Q rc10/WL 0
C5718 c_7_1/Q c_6_1/Q 0.00654f
C5719 c_5_13/QB c_6_13/Q 0
C5720 c_0_5/Q dlb 0
C5721 rc7/WL c_8_3/Q 0
C5722 c_10_7/Q c_9_7/QB 0
C5723 rc1/s/wd/A rc2/s/n3/a_302_47# 0
C5724 rl1 rc1/WL 0.00292f
C5725 c_15_0/Q blb0 0
C5726 cs6/n/Y cl0 0
C5727 c_1_7/QB dl 0.0021f
C5728 blb14 dl 0.02104f
C5729 ch0 rh2 0.02782f
C5730 bl5 csel5 0.00807f
C5731 c_1_13/Q blb12 0.00303f
C5732 c_6_9/Q VDD 0.00756f
C5733 c_8_9/QB c_9_9/Q 0
C5734 c_8_15/QB rc9/WL 0
C5735 cl3 blb5 0
C5736 c_2_11/QB c_2_10/Q 0.00377f
C5737 bl8 rc7/WL 0.00159f
C5738 rc10/WL rl1 0
C5739 blb5 rc14/WL 0.00159f
C5740 c_9_14/Q c_9_13/Q 0
C5741 c_0_0/QB dlb 0.004f
C5742 c_0_0/Q dl 0.00931f
C5743 rc10/s/n3/a_162_47# rl1 0.0024f
C5744 c_14_6/Q c_14_7/Q 0
C5745 rc5/WL c_4_2/QB 0
C5746 c_8_14/Q c_9_14/Q 0.00654f
C5747 c_1_3/Q c_0_3/Q 0.00654f
C5748 c_4_0/Q c_3_0/QB 0
C5749 c_4_0/QB c_3_0/Q 0
C5750 rc6/WL c_6_14/Q 0
C5751 c_11_0/QB c_10_0/QB 0.01281f
C5752 rh2 rc3/s/wd/A 0
C5753 rc8/WL c_9_4/Q 0
C5754 blb6 c_15_7/Q 0.00303f
C5755 c_14_5/Q blb4 0.00303f
C5756 rc0/WL blb10 0.00289f
C5757 rc8/WL c_7_2/Q 0
C5758 rc4/s/wd/A rl2 0.00155f
C5759 c_1_6/Q c_1_5/Q 0
C5760 rc6/WL rl1 0
C5761 rc2/WL csel8 0
C5762 rc4/s/n3/a_162_47# rh1 0.01096f
C5763 c_7_11/Q rc6/WL 0
C5764 rh2 rl1 0.40994f
C5765 ch2 cs2/n/Y 0
C5766 c_11_4/QB c_11_5/QB 0
C5767 bl1 rc8/WL 0.00215f
C5768 c_14_15/QB c_14_14/Q 0.00377f
C5769 c_14_15/Q c_14_14/QB 0.01135f
C5770 c_10_3/QB c_9_3/Q 0
C5771 c_8_5/Q blb4 0.00303f
C5772 c_4_12/Q c_4_11/Q 0
C5773 c_5_13/QB c_5_12/QB 0
C5774 rc0/WL csel13 0.02369f
C5775 c_9_10/QB rc10/WL 0
C5776 ch2 csel1 0.02936f
C5777 c_6_12/Q rc7/WL 0
C5778 c_15_12/Q rc14/WL 0
C5779 rc12/WL c_11_11/Q 0
C5780 cl3 ch2 0.36171f
C5781 c_13_15/Q c_12_15/Q 0.00654f
C5782 rc4/s/wd/A c_4_1/QB 0
C5783 rc12/WL c_12_0/Q 0.01507f
C5784 rc15/WL c_14_12/QB 0
C5785 c_5_11/QB rc6/WL 0
C5786 c_13_10/QB c_13_11/QB 0
C5787 c_5_14/QB c_6_14/Q 0
C5788 rc0/WL bl15 0.00289f
C5789 c_14_13/Q c_14_12/QB 0.01135f
C5790 c_14_13/QB c_14_12/Q 0.00377f
C5791 c_0_9/Q dlb 0
C5792 c_2_15/QB rc3/WL 0
C5793 cl3 csel9 0.03848f
C5794 rh1 rc5/s/n3/a_302_47# 0.0045f
C5795 c_10_9/Q c_9_9/QB 0
C5796 bl9 rc8/WL 0.00159f
C5797 c_12_3/QB c_13_3/QB 0.01281f
C5798 c_11_0/QB c_12_0/Q 0
C5799 c_3_9/QB rc3/WL 0
C5800 c_1_11/Q csel11 0
C5801 cs1/n/Y cl2 0
C5802 c_2_0/QB VDD 0.01264f
C5803 csel6 cs5/n/Y 0
C5804 rc0/WL c_0_4/QB 0
C5805 c_15_13/QB blb12 0
C5806 rc11/WL c_12_12/QB 0
C5807 bl9 c_0_8/Q 0
C5808 rc7/WL c_7_5/Q 0
C5809 blb15 c_15_15/Q 0
C5810 rc13/s/n3/a_162_47# rc13/s/wd/A -0.00121f
C5811 c_2_8/QB c_1_8/QB 0.0025f
C5812 c_4_1/Q VDD 0.00756f
C5813 c_14_8/Q c_13_8/QB 0
C5814 c_3_14/QB rc3/WL 0
C5815 cl0 cs11/n/Y 0
C5816 ch1 c_0_12/QB 0
C5817 c_2_10/QB rc2/WL 0
C5818 c_11_7/QB c_11_8/Q 0.01135f
C5819 c_11_7/Q c_11_8/QB 0.00377f
C5820 pcb c_15_10/Q 0.00484f
C5821 cs14/n/Y csel13 0.00301f
C5822 c_11_4/QB c_12_4/QB 0.0025f
C5823 rc11/WL c_10_9/QB 0
C5824 c_2_5/QB rc3/WL 0
C5825 c_15_4/QB blb4 0
C5826 pcb c_15_3/QB 0.00493f
C5827 rc13/WL c_12_0/Q 0
C5828 c_1_6/Q rc1/WL 0
C5829 rc2/WL c_3_12/Q 0
C5830 c_10_1/Q rc10/WL 0.00103f
C5831 c_8_11/QB VDD 0.00969f
C5832 c_7_9/QB c_8_9/Q 0
C5833 rc1/WL c_1_9/QB 0
C5834 rl3 rh2 0.4906f
C5835 rc2/WL bl0 0.06726f
C5836 blb11 csel12 0.00103f
C5837 rc8/WL c_9_11/QB 0
C5838 c_5_8/QB c_4_8/QB 0.01281f
C5839 c_5_1/Q rc4/WL 0
C5840 c_10_6/QB c_10_7/QB 0
C5841 ch2 bl8 0
C5842 c_3_11/Q c_4_11/QB 0
C5843 pcb c_14_3/QB 0.00169f
C5844 c_0_7/QB c_0_8/QB 0
C5845 c_0_7/QB rc0/WL 0
C5846 c_9_3/QB rc9/WL 0
C5847 bl7 rc1/WL 0.00159f
C5848 VDD c_2_6/Q 0.00756f
C5849 c_2_9/Q rc1/WL 0
C5850 c_12_8/Q c_13_8/Q 0.00654f
C5851 c_8_9/QB c_8_10/QB 0
C5852 c_2_15/QB c_3_15/Q 0
C5853 c_14_4/Q c_14_3/Q 0
C5854 cl0 c_0_5/Q 0
C5855 ch1 c_0_8/QB 0
C5856 ch1 rc0/WL 0.00422f
C5857 c_9_12/QB c_10_12/Q 0
C5858 bl7 rc10/WL 0.00159f
C5859 c_15_0/Q bl0 0
C5860 rl0 rc12/WL 0.0029f
C5861 c_6_15/QB VDD 0.00479f
C5862 c_15_5/QB blb4 0
C5863 clkb c_0_0/Q 0
C5864 c_6_6/Q bl7 0
C5865 cl1 cs13/n/a_162_47# 0.00134f
C5866 rc12/s/n3/a_162_47# bl0 0
C5867 rc15/WL blb0 0.00375f
C5868 ch2 cs0/n/Y 0
C5869 c_15_15/QB pcb 0.00493f
C5870 bl13 c_13_12/QB 0.00303f
C5871 rc2/WL c_3_4/Q 0
C5872 c_2_3/QB rc1/WL 0
C5873 c_2_7/Q rc1/WL 0
C5874 c_3_14/QB c_3_15/Q 0.01135f
C5875 c_4_10/QB VDD 0.00969f
C5876 c_0_0/QB cl0 0
C5877 c_14_1/Q c_13_1/QB 0
C5878 c_2_0/Q c_3_0/QB 0
C5879 c_2_0/QB c_3_0/Q 0
C5880 rc6/WL c_5_4/QB 0
C5881 VDD c_15_14/QB 0.01187f
C5882 c_12_11/Q VDD 0.00756f
C5883 c_4_1/QB rc4/WL 0
C5884 c_11_9/QB c_12_9/QB 0.0025f
C5885 c_11_12/QB c_11_11/Q 0.00377f
C5886 cl1 blb4 0
C5887 c_6_0/QB rc6/WL 0.00535f
C5888 c_15_7/Q c_14_7/Q 0.00654f
C5889 c_0_4/Q dlb 0
C5890 rc5/WL c_4_14/QB 0
C5891 VDD blb4 -0.00917f
C5892 blb2 c_15_2/QB 0
C5893 c_9_11/Q rc9/WL 0
C5894 bl6 c_1_5/Q 0
C5895 dl csel5 0.08427f
C5896 VDD c_0_10/QB 0.00969f
C5897 rh3 rc2/s/wd/A 0
C5898 rc6/WL bl7 0.00159f
C5899 c_2_11/Q rc3/WL 0
C5900 VDD c_15_1/Q 0.015f
C5901 cs3/n/Y csel2 0.00301f
C5902 c_5_5/QB blb4 0
C5903 c_6_5/Q c_6_6/Q 0
C5904 rc5/WL bl13 0.00159f
C5905 blb3 rc9/WL 0.00159f
C5906 c_10_10/Q c_10_9/QB 0.01135f
C5907 rl0 rc13/WL 0
C5908 rc0/s/wd/A dl 0.00668f
C5909 bl1 dl 0.04919f
C5910 blb10 ch0 0.00109f
C5911 rc2/WL blb7 0.00159f
C5912 rc4/s/wd/A rh1 0.03699f
C5913 VDD c_5_13/Q 0.00756f
C5914 VDD c_13_15/Q 0.00565f
C5915 c_10_1/Q c_11_1/Q 0.00654f
C5916 ch1 c_0_15/QB 0
C5917 c_7_0/QB rc7/s/wd/A 0.00246f
C5918 ch1 cs14/n/Y 0
C5919 cs12/n/Y dlb 0
C5920 c_1_6/Q c_1_7/Q 0
C5921 bl8 c_2_7/QB 0.00303f
C5922 rc6/s/n3/a_302_47# rl1 0.00105f
C5923 c_15_4/Q blb4 0
C5924 rc0/WL c_1_4/QB 0
C5925 csel13 blb12 0.00103f
C5926 c_1_2/QB VDD 0.00969f
C5927 cl2 blb14 0.00107f
C5928 c_9_4/QB c_9_3/Q 0.00377f
C5929 c_6_15/QB c_7_15/Q 0
C5930 ch0 csel13 0.03716f
C5931 c_2_0/QB c_2_1/QB 0
C5932 c_6_5/Q rc6/WL 0
C5933 clkb c_14_1/Q 0
C5934 bl9 dl 0.04919f
C5935 c_4_3/QB c_3_3/QB 0.0025f
C5936 c_14_1/QB c_14_0/Q 0.00377f
C5937 c_2_12/QB rc3/WL 0
C5938 c_7_13/Q rc8/WL 0
C5939 rc15/WL c_15_7/QB 0
C5940 c_15_8/QB blb8 0
C5941 rc13/s/n3/a_302_47# bl0 0.00159f
C5942 c_7_13/Q c_8_13/Q 0.00634f
C5943 blb9 csel10 0.00103f
C5944 VDD c_11_1/QB 0.00969f
C5945 c_7_8/Q c_8_8/Q 0.00634f
C5946 c_0_9/Q cl0 0
C5947 ch0 bl15 0.00109f
C5948 c_2_10/QB c_3_10/Q 0
C5949 c_3_11/Q rc3/WL 0
C5950 rc12/WL c_13_3/Q 0
C5951 rh1 c_7_0/QB 0
C5952 csel14 bl14 0.00807f
C5953 c_7_11/Q blb10 0.00303f
C5954 blb13 c_3_14/QB 0
C5955 c_1_7/Q c_2_7/Q 0.00634f
C5956 c_6_11/Q c_6_10/Q 0
C5957 ch0 c_0_4/QB 0
C5958 c_4_12/Q c_3_12/Q 0.00634f
C5959 rc12/WL c_13_12/QB 0
C5960 c_14_8/QB blb7 0
C5961 bl10 c_10_9/Q 0
C5962 c_0_2/QB dlb 0.004f
C5963 c_0_2/Q dl 0.00931f
C5964 bl6 rc1/WL 0.00159f
C5965 c_5_7/QB bl8 0.00303f
C5966 rh0 ch2 0.02797f
C5967 csel10 cs10/n/Y 0.07585f
C5968 bl15 c_6_14/Q 0
C5969 bl6 rc10/WL 0.00159f
C5970 blb3 dlb 0.0282f
C5971 VDD c_5_0/Q 0.01304f
C5972 c_9_1/Q VDD 0.00756f
C5973 c_9_4/QB c_9_5/Q 0.01135f
C5974 VDD c_2_2/Q 0.00756f
C5975 c_5_11/QB blb10 0
C5976 clkb rc8/s/n3/a_162_47# 0.00107f
C5977 c_12_8/Q rc12/WL 0
C5978 blb6 c_3_7/Q 0.00303f
C5979 c_13_3/Q rc13/WL 0
C5980 cl1 cs13/n/Y 0.04813f
C5981 c_12_6/Q c_12_5/Q 0
C5982 VDD cs13/n/Y 0.01448f
C5983 cs8/n/Y csel8 0.07585f
C5984 c_4_0/Q rc3/WL 0
C5985 c_15_8/Q rc14/WL 0
C5986 c_1_8/QB c_1_7/QB 0
C5987 c_3_4/QB bl5 0.00303f
C5988 rc2/WL c_3_7/QB 0
C5989 VDD c_5_3/Q 0.00756f
C5990 blb9 rc12/WL 0.00159f
C5991 rc2/WL c_2_4/Q 0
C5992 c_7_10/QB VDD 0.00969f
C5993 c_12_3/QB rc12/WL 0
C5994 c_0_7/QB ch0 0
C5995 ch1 blb12 0
C5996 rc4/WL rh1 0.00372f
C5997 c_11_13/Q VDD 0.00756f
C5998 rc11/s/wd/A rc11/s/n3/a_162_47# -0.00121f
C5999 rc13/WL c_13_12/QB 0
C6000 c_5_9/Q rc4/WL 0
C6001 VDD rc6/s/wd/A -0.00408f
C6002 c_1_3/Q VDD 0.00756f
C6003 blb2 c_3_3/QB 0
C6004 rc5/s/wd/A rl1 0.05346f
C6005 c_6_5/QB c_7_5/Q 0
C6006 c_6_5/Q c_7_5/QB 0
C6007 ch1 cs7/n/Y 0.09772f
C6008 ch1 ch0 4.31875f
C6009 csel12 rc1/WL 0
C6010 bl6 rc6/WL 0.00159f
C6011 rh3 cl1 0.02852f
C6012 rc4/WL c_5_5/Q 0
C6013 c_9_3/QB bl4 0.00303f
C6014 rc7/s/n3/a_162_47# bl0 0
C6015 c_15_0/Q c_14_0/Q 0.00654f
C6016 rh3 VDD 3.64998f
C6017 pcb blb14 0.07118f
C6018 rc15/WL bl0 0.06865f
C6019 c_11_6/Q VDD 0.00756f
C6020 blb11 c_0_12/Q 0.00303f
C6021 rc2/WL blb6 0.00159f
C6022 rc4/s/wd/A blb1 0
C6023 c_14_2/Q bl3 0
C6024 c_1_12/Q VDD 0.00756f
C6025 c_10_9/QB rc9/WL 0
C6026 rc5/WL c_6_4/QB 0
C6027 c_12_8/Q rc13/WL 0
C6028 VDD c_13_0/Q 0.01304f
C6029 clkb c_6_1/Q 0
C6030 cl1 cs6/n/Y 0.04734f
C6031 rl0 rc4/s/n3/a_302_47# 0.00707f
C6032 rc5/WL c_4_8/QB 0
C6033 c_10_11/Q c_9_11/Q 0.00634f
C6034 c_10_11/QB c_9_11/QB 0.0025f
C6035 VDD c_8_12/Q 0.00756f
C6036 VDD cs6/n/Y 0.01448f
C6037 blb3 c_7_4/QB 0
C6038 c_5_1/Q c_4_1/QB 0
C6039 bl3 c_6_2/Q 0
C6040 bl1 clkb 0
C6041 blb9 rc13/WL 0.00159f
C6042 clkb rc0/s/wd/A 0.09679f
C6043 cl0 c_0_4/Q 0
C6044 c_12_3/QB rc13/WL 0
C6045 rc4/WL c_3_14/Q 0
C6046 blb3 rc3/WL 0.00159f
C6047 ch2 c_0_15/Q 0
C6048 bl3 rc4/WL 0.00159f
C6049 c_6_7/Q c_6_6/QB 0.01135f
C6050 c_0_6/Q c_0_5/QB 0.01135f
C6051 rc6/WL c_5_15/QB 0
C6052 blb11 rc8/WL 0.00159f
C6053 bl13 rc7/WL 0.00159f
C6054 rc4/WL c_5_0/QB 0
C6055 rc11/WL c_11_2/QB 0
C6056 dlb csel11 0.10216f
C6057 c_2_5/QB c_2_6/QB 0
C6058 bl8 c_15_8/Q 0
C6059 dl c_1_14/Q 0.00273f
C6060 dlb c_1_14/QB 0
C6061 cl3 cs8/n/a_162_47# 0
C6062 cl0 cs12/n/Y 0.04796f
C6063 c_4_9/Q c_4_10/Q 0
C6064 ch1 rl1 0.02782f
C6065 rc2/WL c_2_13/QB 0
C6066 blb14 c_12_15/QB 0
C6067 csel3 rc1/WL 0
C6068 blb3 bl4 2.86379f
C6069 rc10/WL c_9_9/QB 0
C6070 cs6/n/Y cs5/n/a_162_47# 0
C6071 rc4/WL c_5_3/QB 0
C6072 pcb c_15_15/Q 0.00484f
C6073 c_12_5/QB c_13_5/Q 0
C6074 c_12_5/Q c_13_5/QB 0
C6075 c_4_1/Q blb0 0.00303f
C6076 c_14_1/Q rc14/s/wd/A 0
C6077 rc5/s/wd/A rl3 0.00121f
C6078 c_5_12/Q blb11 0.00303f
C6079 c_10_10/QB c_11_10/Q 0
C6080 c_2_5/QB c_2_4/QB 0
C6081 c_2_8/QB c_3_8/QB 0.01281f
C6082 c_3_10/QB rc4/WL 0
C6083 rc4/WL bl12 0.00159f
C6084 c_14_11/QB c_13_11/QB 0.0025f
C6085 bl3 c_15_3/Q 0
C6086 c_5_13/QB rc5/WL 0
C6087 c_14_9/Q c_15_9/Q 0.00654f
C6088 c_2_8/Q rc2/WL 0
C6089 bl2 rc4/WL 0.00175f
C6090 bl11 rc4/WL 0.00159f
C6091 c_11_13/QB bl14 0.00303f
C6092 c_0_3/Q c_0_4/Q 0
C6093 bl6 c_7_5/QB 0.00303f
C6094 rc15/WL blb7 0.00298f
C6095 c_5_4/Q bl5 0
C6096 c_4_10/QB c_4_11/Q 0.01135f
C6097 c_4_10/Q c_4_11/QB 0.00377f
C6098 ch3 dlb 0.04042f
C6099 c_5_14/QB c_5_15/QB 0
C6100 c_6_6/Q c_7_6/QB 0
C6101 c_8_2/Q c_8_3/Q 0
C6102 c_14_2/Q blb1 0.00303f
C6103 cl2 csel5 0.02844f
C6104 c_14_14/QB blb13 0
C6105 rc12/WL c_12_2/QB 0
C6106 c_14_1/Q pcb 0.00166f
C6107 bl1 cl2 0
C6108 c_9_10/Q c_9_11/QB 0.00377f
C6109 rc0/s/wd/A cl2 0
C6110 c_2_1/Q c_2_2/QB 0.00377f
C6111 c_2_1/QB c_2_2/Q 0.01135f
C6112 c_13_0/QB c_12_0/QB 0.01281f
C6113 VDD rc10/s/wd/A -0.00408f
C6114 c_1_11/QB rc1/WL 0
C6115 c_6_0/Q c_6_1/Q 0
C6116 c_6_9/Q c_5_9/QB 0
C6117 cl3 cs15/n/a_162_47# 0.0022f
C6118 c_0_2/QB cl0 0
C6119 c_6_2/Q blb1 0.00303f
C6120 rc12/WL c_11_2/Q 0
C6121 c_7_8/Q rc8/WL 0
C6122 bl1 c_6_0/Q 0
C6123 blb1 rc4/WL 0.00178f
C6124 c_5_7/Q c_5_6/Q 0
C6125 rc7/s/wd/A rl2 0.00262f
C6126 c_12_15/QB c_12_14/QB 0
C6127 blb3 cl0 0
C6128 pcb c_15_2/QB 0.00493f
C6129 ch1 rl3 0.02782f
C6130 csel7 ch3 0.02926f
C6131 c_7_6/QB rc6/WL 0
C6132 bl10 c_7_9/QB 0.00303f
C6133 c_9_15/Q rc8/WL 0
C6134 c_2_0/Q rc3/WL 0
C6135 c_7_9/QB rc8/WL 0
C6136 bl9 cl2 0
C6137 rh0 rc1/s/wd/A 0.03742f
C6138 c_11_1/QB c_12_1/QB 0.0025f
C6139 c_10_1/QB c_11_1/QB 0.01281f
C6140 cl1 cs11/n/Y 0
C6141 VDD cs11/n/Y 0.01448f
C6142 bl2 c_2_1/Q 0
C6143 c_14_1/Q c_14_0/QB 0.01135f
C6144 c_0_7/Q ch2 0
C6145 rc13/WL c_12_2/QB 0
C6146 VDD c_1_0/Q 0.01304f
C6147 c_14_2/Q c_14_1/QB 0.01135f
C6148 c_9_0/QB c_10_0/Q 0
C6149 c_14_8/QB c_14_9/Q 0.01135f
C6150 c_10_5/QB rc10/WL 0
C6151 c_5_10/Q c_4_10/QB 0
C6152 c_5_10/QB c_4_10/Q 0
C6153 c_13_9/QB c_12_9/Q 0
C6154 c_4_15/Q rc5/WL 0
C6155 c_0_10/Q dlb 0
C6156 c_15_1/Q blb0 0.00303f
C6157 c_4_4/QB rc5/WL 0
C6158 c_13_11/QB c_13_10/Q 0.00377f
C6159 rc12/WL c_11_0/Q 0
C6160 ch2 bl13 0
C6161 bl13 c_15_12/Q 0
C6162 c_13_9/QB bl10 0.00303f
C6163 c_0_2/QB c_0_3/Q 0.01135f
C6164 c_0_2/Q c_0_3/QB 0.00377f
C6165 rc11/WL blb14 0.00159f
C6166 rh1 rl2 0.44835f
C6167 c_6_6/QB c_6_7/QB 0
C6168 c_15_15/QB c_14_15/Q 0
C6169 c_6_4/QB rc7/WL 0
C6170 rc15/WL c_14_0/Q 0
C6171 ch1 c_1_6/Q 0
C6172 c_10_1/QB c_9_1/Q 0
C6173 VDD c_0_5/Q 0.00756f
C6174 bl5 rc1/WL 0.00159f
C6175 blb11 dl 0.02104f
C6176 bl1 rc14/s/wd/A 0
C6177 c_2_3/QB c_3_3/Q 0
C6178 c_2_3/Q c_3_3/QB 0
C6179 c_14_9/QB c_15_9/QB 0.01281f
C6180 rl1 rc2/s/n3/a_302_47# 0.00105f
C6181 ch3 bl4 0
C6182 rc1/s/n3/a_302_47# rl2 0.00105f
C6183 rc5/WL c_6_13/Q 0
C6184 c_13_14/Q c_12_14/QB 0
C6185 c_13_14/QB c_12_14/Q 0
C6186 rc10/WL bl5 0.00159f
C6187 rc5/WL blb8 0.00159f
C6188 c_11_2/QB c_10_2/Q 0
C6189 bl2 c_0_1/Q 0
C6190 rc4/WL c_3_7/Q 0
C6191 c_7_2/QB c_8_2/QB 0.0025f
C6192 c_12_3/QB c_12_4/QB 0
C6193 c_1_10/QB rc0/WL 0
C6194 c_13_0/QB rl1 0
C6195 VDD c_0_0/QB 0.01264f
C6196 ch2 csel10 0.28899f
C6197 rc12/WL blb5 0.00159f
C6198 ch1 bl7 0
C6199 c_0_12/Q rc1/WL 0
C6200 c_5_6/Q c_4_6/Q 0.00654f
C6201 c_4_10/Q rc3/WL 0
C6202 c_11_1/QB blb0 0
C6203 cl0 csel11 0.02918f
C6204 ch2 c_0_13/Q 0
C6205 VDD c_2_15/QB 0.00479f
C6206 c_14_8/Q rc14/WL 0
C6207 c_12_2/Q VDD 0.00756f
C6208 c_5_1/Q c_5_0/QB 0.01135f
C6209 pcb c_14_14/Q 0.00166f
C6210 c_4_15/Q c_4_14/Q 0
C6211 c_7_6/QB c_7_5/QB 0
C6212 csel6 cs6/n/Y 0.07585f
C6213 VDD c_3_9/QB 0.00969f
C6214 rc15/WL blb6 0.00298f
C6215 pcb rc0/s/wd/A 0
C6216 bl1 pcb 0.07118f
C6217 bl2 c_12_1/Q 0
C6218 c_2_14/Q c_3_14/Q 0.00654f
C6219 rc0/WL csel1 0.02369f
C6220 bl9 c_1_8/QB 0.00303f
C6221 c_1_1/QB dl 0.0021f
C6222 cl3 rc0/WL 0
C6223 csel10 csel9 0.02813f
C6224 c_7_1/Q rc6/WL 0
C6225 rc15/WL c_15_9/QB 0
C6226 clkb rc12/s/wd/A 0.09749f
C6227 VDD c_1_15/Q 0.00565f
C6228 bl10 rc1/WL 0.00159f
C6229 VDD c_3_14/QB 0.00969f
C6230 VDD c_7_12/QB 0.00969f
C6231 rc6/WL bl5 0.00159f
C6232 c_7_10/Q c_7_9/Q 0
C6233 c_6_11/Q c_6_12/Q 0
C6234 c_5_15/Q c_6_15/Q 0.00634f
C6235 rc11/WL c_12_14/QB 0
C6236 rl0 c_12_0/Q 0
C6237 c_1_10/Q blb9 0.00303f
C6238 c_2_5/QB VDD 0.00969f
C6239 c_7_3/QB rc7/WL 0
C6240 c_14_8/QB c_14_7/Q 0.00377f
C6241 c_14_13/QB c_13_13/Q 0
C6242 c_14_13/Q c_13_13/QB 0
C6243 bl10 rc10/WL 0.00159f
C6244 rc2/WL bl14 0.00159f
C6245 clkb rc3/s/n3/a_162_47# 0.00107f
C6246 c_0_8/Q rc1/WL 0
C6247 blb11 c_10_12/Q 0.00303f
C6248 bl2 c_5_1/Q 0
C6249 bl9 pcb 0.07118f
C6250 blb5 rc13/WL 0.00159f
C6251 c_9_1/Q blb0 0.00303f
C6252 ch3 cl0 4.54912f
C6253 c_4_12/QB c_4_13/Q 0.01135f
C6254 c_4_12/Q c_4_13/QB 0.00377f
C6255 rc15/WL c_15_0/QB 0.00535f
C6256 bl14 c_13_13/Q 0
C6257 c_8_1/QB rc8/s/wd/A 0
C6258 bl1 c_14_0/QB 0.00303f
C6259 ch2 c_0_11/QB 0
C6260 c_6_10/QB c_7_10/Q 0
C6261 rc8/WL c_8_3/QB 0
C6262 rh0 rc11/s/wd/A 0
C6263 c_11_12/Q c_10_12/QB 0
C6264 rc5/WL c_5_12/QB 0
C6265 c_2_11/QB c_1_11/QB 0.0025f
C6266 blb13 c_1_14/QB 0
C6267 c_7_15/QB VDD 0.00479f
C6268 c_10_13/QB rc10/WL 0
C6269 c_1_10/QB c_2_10/Q 0
C6270 VDD c_0_9/Q 0.00756f
C6271 cl3 cs14/n/Y 0.01311f
C6272 blb0 rc6/s/wd/A 0
C6273 bl10 rc6/WL 0.00159f
C6274 rc15/WL c_14_9/Q 0
C6275 c_8_15/QB VDD 0.00479f
C6276 c_11_7/Q rc10/WL 0
C6277 rh1 rc7/s/wd/A 0.03699f
C6278 c_12_9/Q c_12_10/QB 0.00377f
C6279 c_12_9/QB c_12_10/Q 0.01135f
C6280 c_2_1/Q rc2/WL 0.00103f
C6281 rc8/WL rh2 0.00372f
C6282 rc0/WL bl8 0.00289f
C6283 csel13 csel12 0.03263f
C6284 rh3 blb0 0
C6285 c_1_0/QB dl 0.0021f
C6286 blb6 c_10_7/Q 0.00303f
C6287 bl2 c_4_1/QB 0.00303f
C6288 rc12/WL c_11_5/Q 0
C6289 c_1_5/Q dl 0.00273f
C6290 c_1_5/QB dlb 0
C6291 c_3_9/QB c_3_8/Q 0.00377f
C6292 c_3_9/Q c_3_8/QB 0.01135f
C6293 bl11 c_15_10/QB 0.00303f
C6294 cs15/n/Y dl 0
C6295 c_9_10/QB c_9_9/Q 0.00377f
C6296 ch3 c_0_3/Q 0
C6297 blb3 c_2_4/QB 0
C6298 c_12_8/QB c_11_8/Q 0
C6299 bl8 c_11_7/QB 0.00303f
C6300 blb13 ch3 0
C6301 c_5_12/Q rc6/WL 0
C6302 c_4_13/Q rc4/WL 0
C6303 blb12 c_6_13/QB 0
C6304 cl0 c_0_10/Q 0
C6305 c_2_11/Q VDD 0.00756f
C6306 c_10_1/QB rc10/s/wd/A 0
C6307 rc15/WL c_15_5/Q 0
C6308 c_13_6/Q c_13_5/Q 0
C6309 c_13_14/Q c_14_14/Q 0.00634f
C6310 c_9_13/QB c_10_13/Q 0
C6311 csel14 c_0_14/Q 0.00119f
C6312 c_4_13/Q bl14 0
C6313 rc14/WL c_13_4/QB 0
C6314 c_11_4/QB c_10_4/QB 0.01281f
C6315 c_8_15/QB c_8_14/QB 0
C6316 ch1 bl6 0
C6317 c_14_15/Q blb14 0.00303f
C6318 c_2_8/QB rc3/WL 0
C6319 c_13_14/QB bl15 0.00303f
C6320 c_12_13/Q blb12 0.00303f
C6321 c_12_8/QB c_13_8/QB 0.01281f
C6322 blb2 c_6_3/QB 0
C6323 cs4/n/Y ch3 0
C6324 cs1/n/Y dlb 0
C6325 c_6_13/Q rc7/WL 0
C6326 c_8_15/QB c_7_15/Q 0
C6327 c_15_3/QB bl4 0.00303f
C6328 rc7/WL blb8 0.00159f
C6329 VDD c_2_12/QB 0.00969f
C6330 blb2 c_14_3/Q 0.00303f
C6331 rc12/WL c_12_4/Q 0
C6332 c_6_13/QB c_6_14/Q 0.01135f
C6333 c_6_13/Q c_6_14/QB 0.00377f
C6334 clkb rc15/s/n3/a_162_47# 0.00107f
C6335 c_12_11/QB bl12 0.00303f
C6336 blb10 c_1_11/QB 0
C6337 rc8/WL c_7_5/QB 0
C6338 c_3_10/Q rc4/WL 0
C6339 c_11_15/Q c_12_15/QB 0
C6340 blb10 c_13_11/QB 0
C6341 c_11_15/QB c_12_15/Q 0
C6342 ch0 cs2/n/Y 0.09835f
C6343 c_3_11/Q VDD 0.00756f
C6344 VDD c_7_2/QB 0.00969f
C6345 c_9_7/Q rc8/WL 0
C6346 rc15/WL c_14_7/Q 0
C6347 c_14_3/QB bl4 0.00303f
C6348 bl1 rc11/WL 0.00215f
C6349 blb5 c_0_6/QB 0
C6350 cl3 blb12 0
C6351 c_3_13/Q rc3/WL 0
C6352 c_4_12/Q rc4/WL 0
C6353 rc14/WL blb12 0.00159f
C6354 dl rc1/WL 0.01038f
C6355 c_5_2/QB VDD 0.00969f
C6356 c_14_5/Q c_13_5/QB 0
C6357 c_14_5/QB c_13_5/Q 0
C6358 c_11_4/Q rc12/WL 0
C6359 VDD c_0_4/Q 0.00756f
C6360 ch1 csel12 0.03695f
C6361 rc2/s/n3/a_162_47# rc2/s/wd/A -0.00121f
C6362 VDD c_6_1/QB 0.00969f
C6363 blb14 rc9/WL 0.00159f
C6364 ch2 csel2 0.02936f
C6365 bl1 c_8_0/QB 0.00303f
C6366 c_14_14/QB VDD 0.00969f
C6367 csel1 ch0 0.33875f
C6368 c_5_0/QB rh1 0
C6369 rc5/WL c_5_8/QB 0
C6370 bl9 c_6_8/QB 0.00303f
C6371 cl3 cs7/n/Y 0.06061f
C6372 rc4/s/wd/A c_4_0/QB 0.00246f
C6373 c_14_15/Q c_15_15/Q 0.00654f
C6374 blb0 rc10/s/wd/A 0
C6375 cl3 ch0 0.3447f
C6376 rc11/WL c_11_8/QB 0
C6377 c_0_1/QB c_0_0/QB 0
C6378 c_6_5/QB c_6_4/QB 0
C6379 rc14/WL c_15_13/Q 0
C6380 c_9_0/Q c_9_1/QB 0.00377f
C6381 cl1 cs12/n/Y 0
C6382 VDD cs12/n/Y 0.01448f
C6383 blb3 c_15_4/QB 0
C6384 rc13/WL c_12_4/Q 0
C6385 c_8_13/QB rc7/WL 0
C6386 blb11 cl2 0
C6387 bl9 rc11/WL 0.00159f
C6388 rc2/WL rl2 0.00286f
C6389 c_14_2/Q rc15/WL 0
C6390 blb1 rc7/s/wd/A 0
C6391 pcb rc12/s/wd/A 0
C6392 rc2/WL c_2_14/Q 0
C6393 rl0 rc8/s/wd/A 0.05406f
C6394 blb3 c_8_4/QB 0
C6395 c_1_15/Q c_2_15/Q 0.00634f
C6396 c_4_9/Q c_3_9/Q 0.00634f
C6397 VDD c_9_3/QB 0.00969f
C6398 c_12_2/Q c_12_1/QB 0.01135f
C6399 c_4_0/Q VDD 0.01304f
C6400 rc8/WL c_9_12/Q 0
C6401 c_10_7/Q c_10_8/Q 0
C6402 c_7_13/Q c_7_12/Q 0
C6403 blb15 rc1/WL 0
C6404 c_7_14/QB rc7/WL 0
C6405 c_15_6/Q rc14/WL 0
C6406 c_11_7/QB c_10_7/QB 0.01281f
C6407 rh0 rc0/WL 0.00372f
C6408 rc15/s/wd/A rl1 0.00205f
C6409 rc14/WL c_13_12/Q 0
C6410 rh2 dl 0.04127f
C6411 rc15/WL c_14_13/QB 0
C6412 bl3 c_2_2/QB 0.00303f
C6413 c_2_0/Q rc2/s/wd/A 0
C6414 c_7_14/QB c_6_14/QB 0.01281f
C6415 blb15 rc10/WL 0
C6416 clkb c_1_0/QB 0
C6417 csel3 ch1 0.02951f
C6418 ch2 c_0_6/QB 0
C6419 bl0 rc6/s/wd/A 0.00934f
C6420 c_6_2/QB c_7_2/QB 0.01281f
C6421 rc14/WL rl1 0
C6422 cl3 rl1 0.04111f
C6423 c_9_0/QB rc9/s/wd/A 0.00246f
C6424 c_8_11/Q c_9_11/QB 0
C6425 rc15/WL bl14 0.00298f
C6426 c_15_10/QB c_15_9/Q 0.00377f
C6427 c_1_13/QB dlb 0
C6428 c_1_13/Q dl 0.00273f
C6429 c_6_2/QB c_5_2/QB 0.0025f
C6430 rc10/WL c_10_12/Q 0
C6431 c_9_10/QB c_8_10/QB 0.01281f
C6432 c_14_13/Q bl14 0
C6433 rh3 bl0 0.01321f
C6434 c_6_2/QB c_6_1/QB 0
C6435 c_15_11/Q VDD 0.015f
C6436 rc2/WL csel0 0
C6437 ch0 bl8 0.00109f
C6438 blb2 rc1/WL 0.00159f
C6439 rc5/WL c_6_11/QB 0
C6440 rl3 rc11/s/n3/a_162_47# 0.01123f
C6441 c_10_11/QB rc10/WL 0
C6442 rl0 rc5/WL 0
C6443 c_6_6/Q c_7_6/Q 0.00654f
C6444 c_12_6/Q VDD 0.00756f
C6445 c_0_2/QB VDD 0.00969f
C6446 c_8_1/QB rc7/WL 0
C6447 c_1_6/QB c_0_6/QB 0.01281f
C6448 c_6_12/QB VDD 0.00969f
C6449 VDD c_9_11/Q 0.00756f
C6450 c_9_2/Q c_8_2/Q 0.00654f
C6451 blb2 rc10/WL 0.00159f
C6452 c_1_7/QB dlb 0
C6453 c_1_7/Q dl 0.00273f
C6454 blb14 dlb 0.0282f
C6455 bl1 c_3_0/QB 0.00303f
C6456 blb3 cl1 0
C6457 rc15/WL c_15_3/Q 0
C6458 rh0 rc9/s/wd/A 0
C6459 blb3 VDD -0.00917f
C6460 c_8_9/Q c_9_9/Q 0.00654f
C6461 blb15 rc6/WL 0
C6462 bl2 c_9_1/QB 0.00303f
C6463 c_8_15/Q rc9/WL 0
C6464 c_9_12/QB rc9/WL 0
C6465 ch2 blb8 0
C6466 c_7_3/Q rc8/WL 0
C6467 blb2 c_8_3/QB 0
C6468 rc11/WL c_11_15/Q 0
C6469 c_0_0/Q dlb 0
C6470 ch0 cs0/n/Y 0.09725f
C6471 ch2 csel15 0.03572f
C6472 blb10 bl10 -0.00665f
C6473 c_3_13/QB rc3/WL 0
C6474 blb10 rc8/WL 0.00159f
C6475 c_7_6/Q rc6/WL 0
C6476 c_4_0/QB rc4/WL 0.00535f
C6477 rc5/WL c_4_2/Q 0
C6478 blb3 c_15_4/Q 0.00303f
C6479 c_4_0/Q c_3_0/Q 0.00634f
C6480 c_11_0/QB c_10_0/Q 0
C6481 c_11_0/Q c_10_0/QB 0
C6482 cl2 cs10/n/a_162_47# 0.00134f
C6483 cl3 cs12/n/a_162_47# 0
C6484 csel7 c_1_7/QB 0
C6485 csel9 blb8 0.00103f
C6486 rl3 rc15/s/wd/A 0.05286f
C6487 VDD c_11_15/QB 0.00479f
C6488 bl11 c_3_10/QB 0.00303f
C6489 blb2 rc6/WL 0.00159f
C6490 c_0_4/QB bl5 0.00303f
C6491 csel14 rc2/WL 0
C6492 c_10_10/QB c_11_10/QB 0.01281f
C6493 cs1/n/Y cl0 0.0472f
C6494 rc0/WL c_0_15/Q 0
C6495 bl9 c_3_8/QB 0.00303f
C6496 clkb rc14/s/n3/a_302_47# 0.00768f
C6497 cl3 rl3 0.04111f
C6498 rc2/s/n3/a_162_47# VDD 0
C6499 pcb blb11 0.07118f
C6500 c_15_14/Q bl14 0
C6501 blb1 c_2_2/QB 0
C6502 c_11_3/QB c_11_2/QB 0
C6503 c_11_12/Q c_11_11/QB 0.01135f
C6504 cl2 cs15/n/Y 0.04756f
C6505 rc13/s/n3/a_302_47# rl2 0.00105f
C6506 clkb rc1/WL 0.00509f
C6507 c_11_4/Q c_11_5/QB 0.00377f
C6508 c_11_4/QB c_11_5/Q 0.01135f
C6509 VDD c_3_15/QB 0.00479f
C6510 c_14_15/Q c_14_14/Q 0
C6511 c_9_10/Q rc10/WL 0
C6512 c_2_9/QB blb8 0
C6513 blb14 rc3/WL 0.00159f
C6514 clkb rc10/WL 0.00509f
C6515 rc8/WL bl15 0.00159f
C6516 blb11 c_7_12/Q 0.00303f
C6517 VDD c_13_5/QB 0.00969f
C6518 c_14_6/Q rc15/WL 0
C6519 rc4/s/wd/A c_4_1/Q 0
C6520 pcb rc15/s/n3/a_162_47# 0.00132f
C6521 c_14_15/QB bl15 0
C6522 c_1_10/QB c_1_9/QB 0
C6523 rc15/WL c_14_12/Q 0
C6524 c_13_10/QB c_13_11/Q 0.01135f
C6525 c_12_7/QB bl8 0.00303f
C6526 bl0 rc10/s/wd/A 0.00934f
C6527 c_5_11/Q rc6/WL 0
C6528 bl2 blb1 2.86379f
C6529 clkb rc10/s/n3/a_162_47# 0.00107f
C6530 cl1 csel11 0.02913f
C6531 VDD csel11 0.02187f
C6532 VDD c_1_14/QB 0.00969f
C6533 c_14_13/Q c_14_12/Q 0
C6534 ch1 bl5 0
C6535 c_9_4/Q rc9/WL 0
C6536 bl9 c_4_8/Q 0
C6537 c_12_3/Q c_13_3/QB 0
C6538 c_12_3/QB c_13_3/Q 0
C6539 c_11_0/Q c_12_0/Q 0.00634f
C6540 c_3_9/Q rc3/WL 0
C6541 c_15_0/QB c_15_1/Q 0.01135f
C6542 c_12_4/QB c_12_4/Q 0
C6543 rc12/WL rc11/s/wd/A 0
C6544 rc12/s/wd/A rc11/WL 0
C6545 c_8_10/Q blb9 0.00303f
C6546 c_2_0/Q VDD 0.01304f
C6547 rc11/WL c_12_12/Q 0
C6548 clkb rc6/WL 0.00509f
C6549 c_7_13/QB VDD 0.00969f
C6550 c_2_8/QB c_1_8/Q 0
C6551 c_14_8/Q c_13_8/Q 0.00634f
C6552 rl1 rc5/s/n3/a_162_47# 0.01123f
C6553 c_7_6/Q c_7_5/QB 0.01135f
C6554 clkb rh2 0.4227f
C6555 cs3/n/a_162_47# cl3 0.0022f
C6556 ch1 c_0_12/Q 0
C6557 c_11_7/Q c_11_8/Q 0
C6558 c_11_0/QB rc11/s/wd/A 0.00246f
C6559 c_5_15/Q blb14 0.00303f
C6560 c_3_2/QB c_3_1/QB 0
C6561 bl1 rc9/WL 0.00215f
C6562 c_2_5/Q rc3/WL 0
C6563 c_11_4/Q c_12_4/QB 0
C6564 rc11/WL c_10_9/Q 0
C6565 c_11_4/QB c_12_4/Q 0
C6566 VDD c_12_12/QB 0.00969f
C6567 rc14/WL bl7 0.00159f
C6568 cl3 bl7 0
C6569 c_0_3/QB rc1/WL 0
C6570 rh0 ch0 0.02805f
C6571 rc1/WL c_1_9/Q 0
C6572 c_10_8/QB c_10_9/QB 0
C6573 c_0_12/QB bl13 0.00303f
C6574 c_13_2/QB rc14/WL 0
C6575 cl1 ch3 0.3734f
C6576 c_9_7/Q c_8_7/QB 0
C6577 VDD ch3 0.34209f
C6578 blb14 c_3_15/Q 0.00303f
C6579 c_5_8/Q c_4_8/QB 0
C6580 bl2 c_14_1/QB 0.00303f
C6581 rc5/WL blb9 0.00159f
C6582 VDD c_10_9/QB 0.00969f
C6583 c_10_6/Q c_10_7/QB 0.00377f
C6584 ch1 bl10 0
C6585 c_3_11/Q c_4_11/Q 0.00634f
C6586 c_0_7/Q c_0_8/QB 0.00377f
C6587 c_0_7/QB c_0_8/Q 0.01135f
C6588 pcb c_14_3/Q 0.00166f
C6589 c_8_9/QB blb8 0
C6590 c_0_7/Q rc0/WL 0
C6591 bl3 rc2/WL 0.00159f
C6592 rc2/WL c_3_14/Q 0
C6593 c_6_11/QB rc7/WL 0
C6594 rl0 rc7/WL 0
C6595 c_9_0/QB rl1 0
C6596 clkb c_11_1/Q 0
C6597 c_1_4/QB bl5 0.00303f
C6598 rh3 c_14_0/Q 0
C6599 c_8_9/Q c_8_10/QB 0.00377f
C6600 c_9_8/QB c_8_8/QB 0.01281f
C6601 bl9 rc9/WL 0.00159f
C6602 ch1 c_0_8/Q 0
C6603 c_9_12/Q c_10_12/Q 0.00634f
C6604 rh0 rc3/s/wd/A 0.03707f
C6605 c_4_13/QB c_5_13/Q 0
C6606 c_13_3/QB c_13_4/QB 0
C6607 cl0 blb14 0
C6608 rc2/WL c_2_2/QB 0
C6609 c_15_5/Q blb4 0.00303f
C6610 c_6_15/Q VDD 0.00565f
C6611 c_14_0/Q c_13_0/Q 0.00634f
C6612 blb10 dl 0.02104f
C6613 c_0_13/Q c_0_12/QB 0.01135f
C6614 rc0/WL bl13 0.00289f
C6615 c_13_6/QB rc14/WL 0
C6616 rc6/s/wd/A rc5/s/n3/a_302_47# 0
C6617 c_0_0/Q cl0 0
C6618 c_2_3/Q rc1/WL 0
C6619 c_4_10/Q VDD 0.00756f
C6620 c_2_0/Q c_3_0/Q 0.00654f
C6621 c_14_1/Q c_13_1/Q 0.00634f
C6622 rc1/s/wd/A rc1/s/n3/a_162_47# -0.00121f
C6623 rh0 rl1 0.42031f
C6624 c_6_11/QB c_7_11/QB 0.01281f
C6625 rc15/WL c_15_10/QB 0
C6626 cl2 rh2 0.02782f
C6627 c_0_2/QB c_0_1/QB 0
C6628 rc2/WL c_3_10/QB 0
C6629 c_4_1/Q rc4/WL 0.00103f
C6630 c_11_9/Q c_12_9/QB 0
C6631 c_11_9/QB c_12_9/Q 0
C6632 rc2/WL c_1_3/QB 0
C6633 rc2/WL bl12 0.00159f
C6634 c_4_15/QB c_5_15/QB 0.01281f
C6635 rc5/WL c_4_14/Q 0
C6636 c_6_0/Q rc6/WL 0.01507f
C6637 blb2 c_15_2/Q 0
C6638 c_9_11/QB rc9/WL 0
C6639 bl2 rc2/WL 0.00175f
C6640 bl11 rc2/WL 0.00159f
C6641 dlb csel5 0.10216f
C6642 VDD c_0_10/Q 0.00756f
C6643 csel13 dl 0.08427f
C6644 c_6_1/QB blb0 0
C6645 rc14/s/n3/a_302_47# rc14/s/wd/A -0
C6646 cs3/n/Y ch2 0
C6647 c_1_12/QB rc2/WL 0
C6648 c_14_6/QB rc14/WL 0
C6649 c_10_10/Q c_10_9/Q 0
C6650 bl10 c_11_9/QB 0.00303f
C6651 bl1 dlb 0
C6652 pcb c_14_11/QB 0.00169f
C6653 blb11 rc11/WL 0.00159f
C6654 rc0/s/wd/A dlb 0
C6655 ch0 c_0_15/Q 0
C6656 c_7_0/Q rc7/s/wd/A 0
C6657 c_13_10/QB c_13_9/Q 0.00377f
C6658 rc0/WL csel10 0.02369f
C6659 rc0/WL c_0_13/Q 0
C6660 c_1_8/QB rc1/WL 0
C6661 bl15 dl 0.04919f
C6662 bl8 c_2_7/Q 0
C6663 rc0/WL c_1_4/Q 0
C6664 c_0_12/QB c_0_11/QB 0
C6665 c_1_2/Q VDD 0.00756f
C6666 csel4 rc2/WL 0
C6667 c_15_3/QB c_15_4/QB 0
C6668 rh3 c_15_0/QB 0
C6669 c_14_4/Q rc14/WL 0
C6670 rc2/WL blb1 0.00178f
C6671 c_0_4/QB dl 0.0049f
C6672 c_6_15/Q c_7_15/Q 0.00654f
C6673 rc12/WL c_12_9/QB 0
C6674 c_2_0/Q c_2_1/QB 0.00377f
C6675 c_2_0/QB c_2_1/Q 0.01135f
C6676 bl9 dlb 0
C6677 c_3_12/QB rc3/WL 0
C6678 c_4_3/QB c_3_3/Q 0
C6679 c_4_3/Q c_3_3/QB 0
C6680 blb2 c_7_3/Q 0.00303f
C6681 blb10 c_10_11/QB 0
C6682 c_4_0/QB c_4_1/QB 0
C6683 rc15/WL c_15_7/Q 0
C6684 rc8/s/wd/A rc7/WL 0
C6685 c_15_8/Q blb8 0
C6686 blb12 c_10_13/Q 0.00303f
C6687 c_3_15/QB c_2_15/Q 0
C6688 cl3 bl6 0
C6689 rh0 rl3 3.86035f
C6690 c_4_10/QB rc4/WL 0
C6691 rc7/s/n3/a_162_47# rc7/s/wd/A -0.00121f
C6692 bl6 rc14/WL 0.00159f
C6693 c_8_10/Q rc7/WL 0
C6694 rh1 c_7_0/Q 0
C6695 c_12_3/QB c_12_2/QB 0
C6696 rc0/WL c_0_11/QB 0
C6697 c_7_8/Q c_6_8/QB 0
C6698 bl9 c_7_8/QB 0.00303f
C6699 blb15 bl15 -0.00665f
C6700 rh2 rc14/s/wd/A 0
C6701 rc4/WL blb4 0.00159f
C6702 rc0/s/n3/a_162_47# dl 0.00149f
C6703 bl1 rc3/WL 0.00215f
C6704 c_0_2/Q dlb 0
C6705 c_0_7/QB dl 0.0049f
C6706 clkb rc6/s/n3/a_302_47# 0.00768f
C6707 rc15/WL c_14_4/QB 0
C6708 rc13/WL c_12_9/QB 0
C6709 rl0 ch2 0.02795f
C6710 c_2_10/QB c_2_11/Q 0.01135f
C6711 c_15_11/QB c_15_10/QB 0
C6712 rc4/WL c_5_13/Q 0
C6713 ch1 dl 0.04249f
C6714 blb13 c_12_14/QB 0
C6715 c_5_11/Q blb10 0.00303f
C6716 cs2/n/Y cs2/n/a_162_47# -0
C6717 c_15_10/Q VDD 0.015f
C6718 rc12/WL c_11_7/QB 0
C6719 pcb rh2 0.00348f
C6720 rc4/s/wd/A rh3 0
C6721 c_5_13/Q bl14 0
C6722 blb9 rc7/WL 0.00159f
C6723 c_15_3/QB VDD 0.01187f
C6724 c_14_8/Q rc13/WL 0
C6725 c_9_2/Q c_10_2/QB 0
C6726 c_8_13/QB c_9_13/QB 0.01281f
C6727 cl3 csel12 0.06159f
C6728 c_2_13/Q rc3/WL 0
C6729 rc5/WL c_6_14/QB 0
C6730 rc7/s/n3/a_162_47# rh1 0.01096f
C6731 blb3 c_13_4/Q 0.00303f
C6732 rc1/s/wd/A c_1_1/Q 0
C6733 c_1_8/Q c_1_7/QB 0.01135f
C6734 c_1_8/QB c_1_7/Q 0.00377f
C6735 bl9 rc3/WL 0.00159f
C6736 rc2/WL c_3_7/Q 0
C6737 c_2_8/QB VDD 0.00969f
C6738 c_7_10/Q VDD 0.00756f
C6739 c_3_3/QB rc3/WL 0
C6740 c_12_3/Q rc12/WL 0
C6741 cl3 cs2/n/a_162_47# 0
C6742 c_0_7/Q ch0 0
C6743 c_9_15/QB VDD 0.00479f
C6744 rc6/WL c_7_12/Q 0
C6745 blb2 c_3_3/Q 0.00303f
C6746 VDD c_14_3/QB 0.00969f
C6747 rc13/s/wd/A rl1 0.05346f
C6748 csel6 ch3 0.02926f
C6749 c_6_5/Q c_7_5/Q 0.00654f
C6750 c_15_4/Q c_15_3/QB 0.01135f
C6751 c_0_1/QB ch3 0
C6752 bl13 blb12 2.86379f
C6753 c_3_12/Q c_2_12/QB 0
C6754 c_13_14/QB rc14/WL 0
C6755 bl10 c_9_9/Q 0
C6756 rc8/WL c_9_9/Q 0
C6757 VDD c_1_5/QB 0.00969f
C6758 ch1 blb15 0
C6759 c_3_3/QB bl4 0.00303f
C6760 bl11 c_3_10/Q 0
C6761 c_12_13/QB rc11/WL 0
C6762 c_10_9/Q rc9/WL 0
C6763 ch0 bl13 0.00109f
C6764 c_5_15/Q c_5_14/Q 0
C6765 csel3 cs2/n/Y 0
C6766 rc5/WL c_6_4/Q 0
C6767 c_3_11/Q c_3_12/Q 0
C6768 bl13 c_15_13/Q 0
C6769 c_5_7/QB c_5_8/QB 0
C6770 c_10_11/Q c_9_11/QB 0
C6771 c_1_4/QB dl 0.0021f
C6772 c_3_13/Q VDD 0.00756f
C6773 c_15_15/QB VDD 0.00697f
C6774 c_5_1/Q c_4_1/Q 0.00654f
C6775 bl3 rc15/WL 0.00298f
C6776 bl13 c_11_12/Q 0
C6777 c_12_3/Q rc13/WL 0
C6778 cl0 csel5 0.07259f
C6779 c_2_0/QB rl2 0
C6780 rc5/WL blb5 0.00159f
C6781 csel3 cl3 0.04036f
C6782 c_0_6/Q c_0_5/Q 0
C6783 rc0/s/wd/A cl0 0
C6784 ch1 blb2 0
C6785 bl1 cl0 0
C6786 c_0_13/Q blb12 0.00303f
C6787 rc4/WL c_5_0/Q 0
C6788 c_2_5/Q c_2_6/QB 0.00377f
C6789 c_14_2/QB c_14_3/QB 0
C6790 c_4_0/QB rh1 0
C6791 c_13_4/Q c_13_5/QB 0.00377f
C6792 rc12/WL c_13_4/QB 0
C6793 csel10 ch0 0.03716f
C6794 blb14 c_12_15/Q 0.00303f
C6795 bl13 c_13_12/Q 0
C6796 ch2 c_0_13/QB 0
C6797 clkb rc5/s/wd/A 0.09749f
C6798 c_0_13/Q ch0 0
C6799 c_1_10/QB c_1_11/QB 0
C6800 VDD c_11_2/QB 0.00969f
C6801 cs14/n/Y cs14/n/a_162_47# -0
C6802 rc4/WL c_5_3/Q 0
C6803 c_12_5/Q c_13_5/Q 0.00654f
C6804 c_11_2/Q c_12_2/QB 0
C6805 cs1/n/Y cl1 0.04813f
C6806 cs1/n/Y VDD 0.01448f
C6807 rc15/WL bl12 0.00298f
C6808 rc0/WL csel2 0.02369f
C6809 blb10 cl2 0.00107f
C6810 rl3 rc13/s/wd/A 0.00121f
C6811 c_9_4/Q c_9_5/QB 0.00377f
C6812 c_2_5/QB c_2_4/Q 0.00377f
C6813 c_2_5/Q c_2_4/QB 0.01135f
C6814 c_2_8/QB c_3_8/Q 0
C6815 rc12/WL c_12_0/QB 0.00535f
C6816 bl9 cl0 0
C6817 pcb c_14_10/QB 0.00169f
C6818 rc15/WL bl11 0.00298f
C6819 bl2 rc15/WL 0.00314f
C6820 c_14_11/Q c_13_11/QB 0
C6821 c_14_11/QB c_13_11/Q 0
C6822 c_11_13/Q bl14 0
C6823 rc14/WL c_13_11/QB 0
C6824 c_4_10/Q c_4_11/Q 0
C6825 bl6 c_7_5/Q 0
C6826 c_11_0/QB c_12_0/QB 0.0025f
C6827 rc11/WL rc10/WL 0.07019f
C6828 pcb c_15_13/QB 0.00493f
C6829 ch3 blb0 0
C6830 c_8_1/QB c_8_2/Q 0.01135f
C6831 cl2 csel13 0.02844f
C6832 c_10_13/QB c_10_12/QB 0
C6833 rc2/WL c_1_15/QB 0
C6834 c_14_14/Q blb13 0.00303f
C6835 rc13/WL c_13_4/QB 0
C6836 clkb rc0/s/n3/a_162_47# 0.00107f
C6837 blb11 rc9/WL 0.00159f
C6838 c_8_5/QB c_7_5/QB 0.0025f
C6839 c_4_0/QB c_5_0/QB 0.01281f
C6840 rc12/WL blb12 0.00159f
C6841 blb9 ch2 0
C6842 c_2_1/Q c_2_2/Q 0
C6843 c_1_11/Q rc1/WL 0
C6844 c_13_3/QB c_13_2/QB 0
C6845 ch0 c_0_11/QB 0
C6846 c_6_8/QB rc6/WL 0
C6847 c_6_9/Q c_5_9/Q 0.00634f
C6848 rc15/WL blb1 0.00317f
C6849 ch1 clkb 0.03886f
C6850 c_0_2/Q cl0 0
C6851 cl2 bl15 0
C6852 rl0 rc12/s/n3/a_302_47# 0.00707f
C6853 c_5_6/Q VDD 0.00756f
C6854 c_7_4/Q rc6/WL 0
C6855 rc13/WL c_12_0/QB 0
C6856 blb13 c_5_14/Q 0.00303f
C6857 rc0/WL c_0_6/QB 0
C6858 blb9 csel9 0.00807f
C6859 c_12_15/QB c_12_14/Q 0.00377f
C6860 c_12_15/Q c_12_14/QB 0.01135f
C6861 c_0_4/QB c_0_3/QB 0
C6862 c_5_6/Q c_5_5/QB 0.01135f
C6863 pcb c_15_2/Q 0.00484f
C6864 c_12_9/QB blb8 0
C6865 csel4 cs5/n/Y 0.00301f
C6866 cs4/n/Y csel5 0
C6867 rc12/WL c_11_12/Q 0
C6868 rc8/s/n3/a_302_47# rh2 0.0045f
C6869 rc11/WL rh2 0.00372f
C6870 rl0 rc1/s/wd/A 0.00388f
C6871 c_11_1/QB c_12_1/Q 0
C6872 cs8/n/Y cs7/n/a_162_47# 0
C6873 c_6_14/QB rc7/WL 0
C6874 c_3_13/QB VDD 0.00969f
C6875 c_8_0/QB rh2 0
C6876 ch2 cs10/n/Y 0.09866f
C6877 c_5_7/Q rc6/WL 0
C6878 rc13/WL blb12 0.00159f
C6879 c_10_5/Q rc10/WL 0
C6880 c_5_10/Q c_4_10/Q 0.00654f
C6881 rc11/WL c_12_10/QB 0
C6882 c_9_15/QB c_9_14/QB 0
C6883 rc12/WL c_13_12/Q 0
C6884 cl3 bl5 0
C6885 rc14/WL bl5 0.00159f
C6886 rc8/WL c_8_10/QB 0
C6887 rc2/WL c_3_10/Q 0
C6888 c_7_11/QB rc7/WL 0
C6889 c_14_1/QB rc15/WL 0
C6890 csel9 cs10/n/Y 0.00301f
C6891 rc0/WL blb8 0.00289f
C6892 c_4_4/Q rc5/WL 0
C6893 c_13_11/Q c_13_10/Q 0
C6894 VDD c_1_13/QB 0.00969f
C6895 c_15_11/QB bl12 0.00303f
C6896 rc2/s/n3/a_162_47# bl0 0
C6897 rc12/WL rl1 0
C6898 c_0_2/Q c_0_3/Q 0
C6899 rc11/WL c_11_1/Q 0.00103f
C6900 c_10_10/Q rc10/WL 0
C6901 rc0/WL csel15 0.02369f
C6902 blb3 c_3_4/Q 0.00303f
C6903 ch3 csel8 0.02926f
C6904 c_6_4/Q rc7/WL 0
C6905 pcb blb10 0.07118f
C6906 ch1 c_0_3/QB 0
C6907 c_12_6/QB c_11_6/QB 0.0025f
C6908 c_11_15/QB c_10_15/Q 0
C6909 blb11 dlb 0.0282f
C6910 cl1 blb14 0
C6911 c_2_3/Q c_3_3/Q 0.00654f
C6912 c_6_5/QB rc5/WL 0
C6913 ch1 cl2 0.34542f
C6914 VDD c_1_7/QB 0.00969f
C6915 VDD blb14 -0.00917f
C6916 c_14_9/QB c_15_9/Q 0
C6917 c_9_15/Q rc9/WL 0
C6918 c_8_10/Q c_8_9/QB 0.01135f
C6919 c_13_14/Q c_12_14/Q 0.00654f
C6920 blb5 rc7/WL 0.00159f
C6921 c_7_1/QB c_8_1/QB 0.0025f
C6922 rc13/WL c_13_12/Q 0
C6923 c_12_3/Q c_12_4/QB 0.00377f
C6924 c_12_3/QB c_12_4/Q 0.01135f
C6925 c_7_2/Q c_8_2/QB 0
C6926 c_13_0/QB c_13_1/QB 0
C6927 VDD c_0_0/Q 0.01304f
C6928 c_1_10/Q rc0/WL 0
C6929 c_5_13/QB blb12 0
C6930 c_7_4/Q c_7_5/QB 0.00377f
C6931 bl10 rc14/WL 0.00159f
C6932 cl3 bl10 0
C6933 blb5 c_10_6/QB 0
C6934 c_5_1/Q c_5_0/Q 0
C6935 c_15_6/QB blb5 0
C6936 rc12/WL c_12_7/QB 0
C6937 rc9/s/n3/a_302_47# rc9/s/wd/A -0
C6938 c_7_6/QB c_7_5/Q 0.00377f
C6939 rc13/WL rl1 0.00292f
C6940 VDD c_3_9/Q 0.00756f
C6941 c_11_15/QB c_10_15/QB 0.01281f
C6942 c_15_12/QB blb12 0
C6943 bl9 c_1_8/Q 0
C6944 c_1_1/QB dlb 0
C6945 csel15 c_0_15/QB 0
C6946 c_7_8/Q c_7_9/Q 0
C6947 pcb bl15 0.07118f
C6948 rc15/WL c_15_9/Q 0
C6949 cs14/n/Y csel15 0
C6950 c_12_11/QB c_12_11/Q 0
C6951 rc5/WL c_5_7/QB 0
C6952 ch0 csel2 0.3441f
C6953 c_15_12/QB c_15_13/Q 0.01135f
C6954 rc11/WL c_12_14/Q 0
C6955 c_2_5/Q VDD 0.00756f
C6956 rc5/s/wd/A pcb 0
C6957 c_14_13/Q c_13_13/Q 0.00634f
C6958 rc10/WL c_10_2/Q 0
C6959 c_0_14/QB c_1_14/QB 0.01281f
C6960 VDD c_15_15/Q 0.01309f
C6961 clkb rc2/s/n3/a_302_47# 0.00768f
C6962 c_3_4/QB rc3/WL 0
C6963 c_4_12/Q c_4_13/Q 0
C6964 rc6/s/wd/A rl2 0.05309f
C6965 blb11 rc3/WL 0.00159f
C6966 c_14_9/QB c_14_8/QB 0
C6967 rc15/WL c_15_0/Q 0.01507f
C6968 c_12_7/QB rc13/WL 0
C6969 bl0 ch3 0
C6970 c_8_1/Q rc8/s/wd/A 0
C6971 VDD c_12_14/QB 0.00969f
C6972 blb14 c_7_15/Q 0.00303f
C6973 rl0 rc11/s/wd/A 0.00281f
C6974 rl3 c_11_0/QB 0
C6975 ch2 c_0_11/Q 0
C6976 bl1 rc2/s/wd/A 0
C6977 c_2_13/QB c_2_12/QB 0
C6978 rc8/WL c_8_3/Q 0
C6979 clkb c_13_0/QB 0
C6980 rh3 rl2 0.44077f
C6981 c_12_4/QB c_13_4/QB 0.01281f
C6982 c_2_11/QB c_1_11/Q 0
C6983 blb13 c_1_14/Q 0.00303f
C6984 c_1_10/Q c_2_10/Q 0.00634f
C6985 rc8/WL bl8 0.00159f
C6986 rl0 rc7/s/n3/a_302_47# 0.00105f
C6987 c_14_1/Q VDD 0.00756f
C6988 rc0/WL c_1_1/Q 0
C6989 c_10_11/QB c_10_12/QB 0
C6990 c_8_15/Q VDD 0.00565f
C6991 c_14_8/Q c_15_8/QB 0
C6992 VDD c_9_12/QB 0.00969f
C6993 c_12_9/Q c_12_10/Q 0
C6994 c_0_14/QB ch3 0
C6995 ch0 c_0_6/QB 0
C6996 c_3_2/QB rc3/WL 0
C6997 c_3_9/QB rc4/WL 0
C6998 c_14_8/QB rc15/WL 0
C6999 c_13_9/Q c_13_10/Q 0
C7000 c_10_3/QB c_9_3/QB 0.0025f
C7001 c_1_0/QB dlb 0
C7002 bl2 c_4_1/Q 0
C7003 ch1 pcb 0.02782f
C7004 c_3_9/Q c_3_8/Q 0
C7005 VDD c_15_2/QB 0.01187f
C7006 ch1 cs9/n/Y 0
C7007 cs15/n/Y dlb 0
C7008 c_7_9/QB c_7_8/QB 0
C7009 rc9/WL rc10/WL 0.88789f
C7010 c_9_4/Q c_8_4/QB 0
C7011 c_3_14/QB rc4/WL 0
C7012 c_5_5/Q blb4 0.00303f
C7013 c_8_11/QB bl12 0.00303f
C7014 c_9_10/Q c_9_9/Q 0
C7015 blb3 c_2_4/Q 0.00303f
C7016 bl8 c_4_7/QB 0.00303f
C7017 bl8 c_11_7/Q 0
C7018 blb4 c_9_5/Q 0.00303f
C7019 blb12 c_6_13/Q 0.00303f
C7020 c_7_3/Q c_7_4/Q 0
C7021 rc9/WL c_8_3/QB 0
C7022 rc12/WL bl7 0.00159f
C7023 ch2 blb5 0
C7024 rc12/WL c_13_2/QB 0
C7025 c_11_4/Q c_10_4/QB 0
C7026 c_11_4/QB c_10_4/Q 0
C7027 c_14_2/QB c_14_1/Q 0.00377f
C7028 c_8_15/QB c_8_14/Q 0.00377f
C7029 c_8_15/Q c_8_14/QB 0.01135f
C7030 c_1_10/QB dl 0.0021f
C7031 rc4/s/n3/a_302_47# rc3/s/wd/A 0
C7032 c_8_11/QB c_8_12/QB 0
C7033 ch0 blb8 0.00109f
C7034 ch3 blb7 0
C7035 VDD rc8/s/n3/a_162_47# 0
C7036 csel14 cs13/n/Y 0
C7037 cs2/n/Y dl 0
C7038 blb10 c_8_11/Q 0.00303f
C7039 c_6_4/QB c_5_4/QB 0.0025f
C7040 blb10 rc11/WL 0.00159f
C7041 c_13_14/Q bl15 0
C7042 ch0 csel15 0.03608f
C7043 c_12_8/QB c_13_8/Q 0
C7044 blb11 cl0 0
C7045 c_6_5/QB rc7/WL 0
C7046 rh2 rc9/WL 0.00372f
C7047 cs1/n/a_162_47# cl1 0.00134f
C7048 csel1 dl 0.08427f
C7049 c_1_6/QB blb5 0
C7050 c_8_15/Q c_7_15/Q 0.00634f
C7051 cl3 dl 0.0435f
C7052 c_4_10/QB c_3_10/QB 0.0025f
C7053 c_14_2/QB c_15_2/QB 0.01281f
C7054 c_3_12/QB VDD 0.00969f
C7055 c_6_3/QB bl4 0.00303f
C7056 rc10/s/wd/A rl2 0.05309f
C7057 c_5_12/Q c_6_12/Q 0.00634f
C7058 c_6_13/Q c_6_14/Q 0
C7059 rc13/WL bl7 0.00159f
C7060 c_9_6/QB rc10/WL 0
C7061 VDD c_9_4/Q 0.00756f
C7062 bl3 c_1_2/QB 0.00303f
C7063 bl11 c_4_10/QB 0.00303f
C7064 rc6/s/wd/A rc7/s/wd/A 0.02158f
C7065 c_12_11/Q bl12 0
C7066 rc8/WL c_7_5/Q 0
C7067 c_13_6/QB rc12/WL 0
C7068 blb10 c_1_11/Q 0.00303f
C7069 blb10 c_13_11/Q 0.00303f
C7070 rc13/WL c_13_2/QB 0
C7071 c_8_13/QB blb12 0
C7072 rc1/s/n3/a_162_47# rl1 0.01123f
C7073 VDD c_7_2/Q 0.00756f
C7074 rc7/s/n3/a_302_47# rc8/s/wd/A 0
C7075 c_11_15/Q c_12_15/Q 0.00634f
C7076 c_14_3/Q bl4 0
C7077 c_1_2/QB c_2_2/QB 0.0025f
C7078 blb14 c_2_15/Q 0.00303f
C7079 dlb rc1/WL 0
C7080 rh3 rc7/s/wd/A 0
C7081 c_5_2/Q VDD 0.00756f
C7082 c_14_5/Q c_13_5/Q 0.00634f
C7083 cl1 csel5 0.03035f
C7084 VDD csel5 0.02187f
C7085 VDD c_6_1/Q 0.00756f
C7086 rc15/s/n3/a_302_47# rc15/s/wd/A -0
C7087 rc11/WL bl15 0.00159f
C7088 bl11 c_0_10/QB 0.00303f
C7089 c_9_0/QB rc8/WL 0
C7090 rc9/s/n3/a_302_47# rl1 0.00707f
C7091 bl1 c_8_0/Q 0
C7092 c_14_14/Q VDD 0.00756f
C7093 c_8_9/QB rc7/WL 0
C7094 c_5_0/Q rh1 0
C7095 rc5/WL c_5_8/Q 0
C7096 bl9 c_6_8/Q 0
C7097 c_14_9/QB rc15/WL 0
C7098 bl2 c_15_1/Q 0
C7099 bl1 cl1 0
C7100 rc4/s/wd/A c_4_0/Q 0
C7101 rc11/WL c_11_8/Q 0
C7102 rc0/s/wd/A cl1 0
C7103 bl1 VDD -0.00929f
C7104 rc0/s/wd/A VDD -0.00413f
C7105 c_0_1/QB c_0_0/Q 0.00377f
C7106 c_0_1/Q c_0_0/QB 0.01135f
C7107 bl13 csel12 0.00103f
C7108 c_7_9/Q rc6/WL 0
C7109 c_6_5/Q c_6_4/QB 0.01135f
C7110 c_6_5/QB c_6_4/Q 0.00377f
C7111 c_9_0/Q c_9_1/Q 0
C7112 c_11_8/QB c_10_8/QB 0.01281f
C7113 c_1_2/QB c_1_3/QB 0
C7114 cl3 blb15 0
C7115 blb15 rc14/WL 0
C7116 ch2 csel9 0.28364f
C7117 rc5/WL c_5_6/QB 0
C7118 rc11/WL c_11_14/QB 0
C7119 csel4 blb4 0.00807f
C7120 VDD c_5_14/Q 0.00756f
C7121 VDD c_11_8/QB 0.00969f
C7122 c_13_6/QB rc13/WL 0
C7123 csel7 rc1/WL 0
C7124 bl9 c_10_8/QB 0.00303f
C7125 rh1 rc6/s/wd/A 0.03734f
C7126 blb3 c_8_4/Q 0.00303f
C7127 c_6_10/QB rc6/WL 0
C7128 bl8 dl 0.04919f
C7129 VDD c_2_13/Q 0.00756f
C7130 c_12_2/Q c_12_1/Q 0
C7131 bl9 cl1 0
C7132 bl9 VDD -0.00929f
C7133 blb1 c_15_1/Q 0
C7134 rl3 rc4/s/n3/a_302_47# 0.00105f
C7135 c_7_14/Q rc7/WL 0
C7136 c_3_3/QB VDD 0.00969f
C7137 rh3 rh1 0.18659f
C7138 c_11_7/Q c_10_7/QB 0
C7139 rl0 rc0/WL 0.0029f
C7140 rh2 dlb 0.02782f
C7141 cl3 blb2 0
C7142 rc15/WL c_14_13/Q 0
C7143 blb2 rc14/WL 0.00159f
C7144 c_9_7/Q rc9/WL 0
C7145 bl2 c_11_1/QB 0.00303f
C7146 bl3 c_2_2/Q 0
C7147 c_7_14/Q c_6_14/QB 0
C7148 c_7_14/QB c_6_14/Q 0
C7149 c_2_0/QB rc2/WL 0.00535f
C7150 c_5_10/QB rc6/WL 0
C7151 c_14_6/QB rc13/WL 0
C7152 c_13_1/QB rc14/WL 0
C7153 clkb rc11/s/n3/a_162_47# 0.00107f
C7154 c_6_2/QB c_7_2/Q 0
C7155 c_6_2/Q c_7_2/QB 0
C7156 ch0 c_1_1/Q 0
C7157 rc12/WL bl6 0.00159f
C7158 csel0 c_1_0/Q 0
C7159 c_1_2/QB blb1 0
C7160 c_3_11/Q rc4/WL 0
C7161 c_6_2/QB c_5_2/Q 0
C7162 c_6_2/Q c_5_2/QB 0
C7163 c_7_8/Q c_7_7/QB 0.01135f
C7164 cs0/n/Y dl 0
C7165 c_9_4/QB c_9_3/QB 0
C7166 c_9_10/Q c_8_10/QB 0
C7167 c_6_2/QB c_6_1/Q 0.00377f
C7168 c_6_2/Q c_6_1/QB 0.01135f
C7169 c_5_2/QB rc4/WL 0
C7170 rc6/WL c_7_8/QB 0
C7171 rc5/WL c_6_11/Q 0
C7172 c_10_11/Q rc10/WL 0
C7173 c_0_6/Q ch3 0
C7174 blb6 ch3 0
C7175 cl0 cs15/n/Y 0
C7176 c_0_2/Q VDD 0.00756f
C7177 c_8_1/Q rc7/WL 0
C7178 c_14_14/QB c_14_13/QB 0
C7179 c_9_15/QB c_10_15/Q 0
C7180 c_1_6/Q c_0_6/QB 0
C7181 c_3_13/Q c_3_12/Q 0
C7182 c_6_3/Q rc6/WL 0
C7183 c_14_4/Q rc13/WL 0
C7184 VDD c_9_11/QB 0.00969f
C7185 bl1 c_3_0/Q 0
C7186 c_2_14/Q c_2_15/QB 0.00377f
C7187 rc1/WL bl4 0.00159f
C7188 rl0 rc9/s/wd/A 0.00388f
C7189 c_12_0/Q c_12_0/QB 0
C7190 c_14_1/QB c_15_1/Q 0
C7191 bl2 c_9_1/Q 0
C7192 cs7/n/Y cs6/n/a_162_47# 0
C7193 c_9_12/Q rc9/WL 0
C7194 blb2 c_8_3/Q 0.00303f
C7195 rc10/WL bl4 0.00159f
C7196 c_0_13/QB c_0_12/QB 0
C7197 rc2/WL c_2_6/Q 0
C7198 c_4_4/QB c_5_4/QB 0.01281f
C7199 c_13_0/QB c_14_0/QB 0.0025f
C7200 c_5_11/QB c_5_12/QB 0
C7201 clkb rc15/s/wd/A 0.09679f
C7202 rc12/WL c_12_8/QB 0
C7203 c_0_6/QB bl7 0.00303f
C7204 c_2_14/Q c_3_14/QB 0
C7205 rc6/WL c_7_4/QB 0
C7206 bl6 rc13/WL 0.00159f
C7207 c_9_6/QB c_9_7/Q 0.01135f
C7208 rc15/WL c_15_14/Q 0
C7209 c_9_15/QB c_10_15/QB 0.0025f
C7210 c_4_0/Q rc4/WL 0.01507f
C7211 bl11 c_7_10/QB 0.00303f
C7212 c_11_0/Q c_10_0/Q 0.00654f
C7213 c_8_3/QB bl4 0.00303f
C7214 rc0/s/n3/a_302_47# rc0/s/wd/A -0
C7215 cl3 clkb 0.052f
C7216 c_1_3/QB c_1_3/Q -0
C7217 clkb rc14/WL 0.00509f
C7218 bl8 c_8_7/QB 0.00303f
C7219 csel7 c_1_7/Q 0
C7220 VDD c_11_15/Q 0.00565f
C7221 c_0_0/QB csel0 0
C7222 bl9 c_3_8/Q 0
C7223 blb3 c_9_4/QB 0
C7224 c_2_8/QB blb7 0
C7225 blb8 c_1_9/QB 0
C7226 blb1 c_2_2/Q 0.00303f
C7227 c_11_3/Q c_11_2/QB 0.01135f
C7228 cs3/n/Y ch0 0.09759f
C7229 c_11_12/Q c_11_11/Q 0
C7230 rc11/WL c_11_9/QB 0
C7231 c_2_4/QB c_3_4/QB 0.01281f
C7232 rc6/WL bl4 0.00159f
C7233 c_15_11/QB rc15/WL 0
C7234 rc12/WL c_13_14/QB 0
C7235 c_11_4/Q c_11_5/Q 0
C7236 c_8_8/QB rc7/WL 0
C7237 rc10/s/wd/A rh1 0
C7238 rc0/WL c_0_13/QB 0
C7239 c_12_8/Q c_12_9/QB 0.00377f
C7240 c_1_12/QB c_1_12/Q -0
C7241 rc2/WL blb4 0.00159f
C7242 c_12_8/QB rc13/WL 0
C7243 VDD c_13_10/QB 0.00969f
C7244 c_2_9/Q blb8 0.00303f
C7245 c_10_11/QB c_11_11/QB 0.01281f
C7246 rc11/WL c_11_10/Q 0
C7247 blb1 rc6/s/wd/A 0
C7248 VDD c_13_5/Q 0.00756f
C7249 c_5_15/Q rc6/WL 0
C7250 c_1_10/QB c_1_9/Q 0.00377f
C7251 c_1_10/Q c_1_9/QB 0.01135f
C7252 blb3 rc4/WL 0.00159f
C7253 c_8_2/Q rc7/WL 0
C7254 c_12_7/Q bl8 0
C7255 rl0 c_12_0/QB 0
C7256 blb10 rc9/WL 0.00159f
C7257 cs2/n/Y cl2 0.04836f
C7258 VDD c_1_14/Q 0.00756f
C7259 rh0 dl 0.10711f
C7260 c_1_2/QB rc2/WL 0
C7261 c_0_5/QB blb4 0
C7262 c_14_1/Q blb0 0.00303f
C7263 c_11_3/QB rc10/WL 0
C7264 c_12_3/Q c_13_3/Q 0.00654f
C7265 rc8/s/wd/A rc9/s/wd/A 0.02158f
C7266 c_15_0/Q c_15_1/Q 0
C7267 c_13_14/QB rc13/WL 0
C7268 csel1 cl2 0.02844f
C7269 csel6 csel5 0.02364f
C7270 c_7_4/QB c_7_5/QB 0
C7271 cl3 cl2 4.32628f
C7272 c_7_13/Q VDD 0.00756f
C7273 blb9 rc0/WL 0.00289f
C7274 c_7_6/Q c_7_5/Q 0
C7275 c_13_8/QB c_13_9/Q 0.01135f
C7276 c_3_13/QB c_3_12/Q 0.00377f
C7277 VDD c_5_1/QB 0.00969f
C7278 c_0_1/QB rc0/s/wd/A 0
C7279 c_11_0/Q rc11/s/wd/A 0
C7280 rc12/s/wd/A VDD -0.00408f
C7281 c_3_2/QB c_3_1/Q 0.00377f
C7282 c_3_2/Q c_3_1/QB 0.01135f
C7283 c_11_4/Q c_12_4/Q 0.00634f
C7284 c_1_11/QB c_0_11/QB 0.01281f
C7285 blb10 c_4_11/QB 0
C7286 blb3 c_15_3/Q 0
C7287 VDD c_12_12/Q 0.00756f
C7288 cl0 rh2 0.02782f
C7289 c_4_3/QB c_4_2/QB 0
C7290 bl6 c_11_5/QB 0.00303f
C7291 c_0_3/Q rc1/WL 0
C7292 rl0 ch0 0.02802f
C7293 c_0_12/Q bl13 0
C7294 blb13 rc1/WL 0.00159f
C7295 c_10_8/QB c_10_9/Q 0.01135f
C7296 c_10_8/Q c_10_9/QB 0.00377f
C7297 bl15 rc9/WL 0.00159f
C7298 c_5_15/Q c_5_14/QB 0.01135f
C7299 c_13_2/Q rc14/WL 0
C7300 rc12/WL c_13_11/QB 0
C7301 c_9_7/Q c_8_7/Q 0.00654f
C7302 c_2_11/QB rc3/WL 0
C7303 rc3/s/n3/a_162_47# VDD 0
C7304 rc10/WL c_9_5/QB 0
C7305 c_3_15/QB rc4/WL 0
C7306 VDD c_10_9/Q 0.00756f
C7307 blb13 rc10/WL 0.00159f
C7308 c_0_7/Q c_0_8/Q 0
C7309 c_4_4/QB c_4_5/QB 0
C7310 c_8_9/Q blb8 0.00303f
C7311 rc6/WL c_7_7/QB 0
C7312 c_6_11/Q rc7/WL 0
C7313 c_12_3/QB c_12_3/Q 0
C7314 c_10_0/QB c_10_1/Q 0.01135f
C7315 c_10_10/Q c_11_10/Q 0.00654f
C7316 c_9_8/Q c_8_8/QB 0
C7317 c_9_8/QB c_8_8/Q 0
C7318 c_1_4/Q bl5 0
C7319 c_5_1/Q c_5_2/QB 0.00377f
C7320 rc8/WL bl13 0.00159f
C7321 rl0 rc3/s/wd/A 0.00281f
C7322 c_5_1/Q c_6_1/QB 0
C7323 c_9_8/QB c_9_9/QB 0
C7324 rc2/WL c_2_2/Q 0
C7325 c_4_13/Q c_5_13/Q 0.00654f
C7326 c_13_3/Q c_13_4/QB 0.00377f
C7327 c_5_6/QB blb5 0
C7328 c_9_2/Q rc8/WL 0
C7329 c_15_10/Q c_15_9/QB 0.01135f
C7330 clkb rc5/s/n3/a_162_47# 0.00107f
C7331 cl2 bl8 0
C7332 blb10 dlb 0.0282f
C7333 c_0_13/Q c_0_12/Q 0
C7334 c_0_15/Q dl 0.00931f
C7335 rc15/s/wd/A rc14/s/wd/A 0.02158f
C7336 c_13_6/Q rc14/WL 0
C7337 rc13/WL c_13_11/QB 0
C7338 c_6_11/Q c_7_11/QB 0
C7339 c_6_11/QB c_7_11/Q 0
C7340 blb13 rc6/WL 0.00159f
C7341 rl0 rl1 3.59808f
C7342 blb9 c_2_10/Q 0.00303f
C7343 c_4_10/QB c_3_10/Q 0
C7344 c_4_15/Q c_5_15/QB 0
C7345 blb1 rc10/s/wd/A 0
C7346 c_0_2/QB c_0_1/Q 0.00377f
C7347 c_0_2/Q c_0_1/QB 0.01135f
C7348 c_5_12/Q bl13 0
C7349 rc14/WL rc14/s/wd/A -0.00118f
C7350 c_11_9/Q c_12_9/Q 0.00634f
C7351 rc2/WL c_1_3/Q 0
C7352 c_0_9/QB c_0_10/QB 0
C7353 c_7_1/QB rc7/WL 0
C7354 csel10 bl10 0.00807f
C7355 blb14 c_10_15/Q 0.00303f
C7356 csel13 dlb 0.10216f
C7357 c_7_13/QB bl14 0.00303f
C7358 c_6_1/Q blb0 0.00303f
C7359 c_7_3/Q c_6_3/Q 0.00654f
C7360 csel3 csel2 0.01915f
C7361 pcb rc15/s/wd/A 0.00605f
C7362 bl3 c_12_2/Q 0
C7363 cl2 cs0/n/Y 0
C7364 c_1_12/Q rc2/WL 0
C7365 bl10 c_11_9/Q 0
C7366 rc0/s/wd/A blb0 0
C7367 bl1 blb0 2.86379f
C7368 pcb c_14_11/Q 0.00166f
C7369 rc12/WL bl5 0.00159f
C7370 clkb c_9_0/QB 0
C7371 c_6_11/QB c_5_11/QB 0.0025f
C7372 c_0_13/QB blb12 0
C7373 c_1_8/Q rc1/WL 0
C7374 bl15 dlb 0
C7375 cl3 pcb 0.04111f
C7376 ch2 cs8/n/a_162_47# 0.00134f
C7377 pcb rc14/WL 0.00479f
C7378 c_0_12/Q c_0_11/QB 0.01135f
C7379 c_0_12/QB c_0_11/Q 0.00377f
C7380 c_3_4/QB VDD 0.00969f
C7381 c_7_3/Q c_7_4/QB 0.00377f
C7382 blb14 c_10_15/QB 0
C7383 cl3 cs9/n/Y 0.01311f
C7384 blb11 cl1 0
C7385 ch3 bl14 0
C7386 c_2_6/QB rc1/WL 0
C7387 blb11 VDD -0.00917f
C7388 c_0_13/QB ch0 0
C7389 rh3 c_15_0/Q 0
C7390 c_14_5/QB rc14/WL 0
C7391 c_0_4/QB dlb 0.004f
C7392 c_5_14/QB blb13 0
C7393 rc11/WL c_10_12/QB 0
C7394 rc12/WL c_12_9/Q 0
C7395 c_2_0/Q c_2_1/Q 0
C7396 rc12/s/n3/a_162_47# rh3 0.01096f
C7397 clkb rh0 0.43343f
C7398 c_4_3/Q c_3_3/Q 0.00634f
C7399 blb10 rc3/WL 0.00159f
C7400 blb10 c_10_11/Q 0.00303f
C7401 cs3/n/Y cs3/n/a_162_47# -0
C7402 c_4_0/Q c_4_1/QB 0.00377f
C7403 c_4_0/QB c_4_1/Q 0.01135f
C7404 c_6_4/QB bl5 0.00303f
C7405 c_3_10/QB c_3_9/QB 0
C7406 c_3_13/Q c_2_13/QB 0
C7407 c_2_4/QB rc1/WL 0
C7408 rc13/WL bl5 0.00159f
C7409 c_4_10/Q rc4/WL 0
C7410 rc15/WL c_15_14/QB 0
C7411 rc12/WL bl10 0.00159f
C7412 rl0 rl3 0.25185f
C7413 c_7_3/Q bl4 0
C7414 rc5/WL blb12 0.00159f
C7415 c_14_0/QB rc14/WL 0.00535f
C7416 c_10_3/Q c_10_4/QB 0.00377f
C7417 blb9 c_10_10/QB 0
C7418 VDD c_3_2/QB 0.00969f
C7419 c_12_3/Q c_12_2/QB 0.01135f
C7420 VDD c_1_1/QB 0.00969f
C7421 rc0/WL c_0_11/Q 0
C7422 c_7_8/Q c_6_8/Q 0.00654f
C7423 rc15/WL blb4 0.00298f
C7424 blb2 c_13_3/QB 0
C7425 rc15/WL c_15_1/Q 0.00103f
C7426 c_8_2/QB c_8_3/QB 0
C7427 rc8/s/wd/A rl1 0.00312f
C7428 c_0_7/Q dl 0.00931f
C7429 c_0_7/QB dlb 0.004f
C7430 blb9 ch0 0.00109f
C7431 rc13/WL c_12_9/Q 0
C7432 c_15_11/Q c_15_10/QB 0.01135f
C7433 bl15 rc3/WL 0.00159f
C7434 pcb bl8 0.07118f
C7435 c_10_13/Q c_10_12/Q 0
C7436 rc2/s/wd/A rc1/WL 0
C7437 c_12_2/Q blb1 0.00303f
C7438 blb8 c_9_9/QB 0
C7439 ch1 dlb 0.06313f
C7440 c_8_12/QB c_7_12/QB 0.0025f
C7441 blb13 c_12_14/Q 0.00303f
C7442 rc12/WL c_11_7/Q 0
C7443 rc13/s/n3/a_162_47# rl1 0.01123f
C7444 bl10 rc13/WL 0.00159f
C7445 c_3_13/Q c_4_13/QB 0
C7446 c_7_8/Q VDD 0.00756f
C7447 bl13 dl 0.04919f
C7448 rc2/s/n3/a_162_47# rl2 0.01123f
C7449 rc5/WL c_6_14/Q 0
C7450 blb13 c_15_13/QB 0
C7451 c_1_8/Q c_1_7/Q 0
C7452 VDD c_6_3/QB 0.00969f
C7453 c_10_5/QB c_11_5/QB 0.01281f
C7454 c_7_9/QB c_6_9/QB 0.01281f
C7455 cs4/n/a_162_47# ch1 0.00134f
C7456 c_0_7/QB csel7 0
C7457 c_3_3/Q rc3/WL 0
C7458 bl0 rc8/s/n3/a_162_47# 0
C7459 c_14_15/QB rc13/WL 0
C7460 rh0 cl2 0.02787f
C7461 c_9_15/Q VDD 0.00565f
C7462 rh3 rc13/s/n3/a_302_47# 0.0045f
C7463 c_8_9/QB c_8_8/QB 0
C7464 ch0 cs10/n/Y 0
C7465 c_7_9/QB VDD 0.00969f
C7466 VDD c_14_3/Q 0.00756f
C7467 rc13/s/wd/A c_13_1/QB 0
C7468 bl9 csel8 0.00103f
C7469 rc5/WL rl1 0.00292f
C7470 ch1 csel7 0.32185f
C7471 c_8_11/Q c_8_10/QB 0.01135f
C7472 c_0_1/Q ch3 0
C7473 VDD c_5_4/Q 0.00756f
C7474 rc0/WL blb5 0.00289f
C7475 blb10 cl0 0
C7476 rc12/s/wd/A c_12_1/QB 0
C7477 c_13_14/Q rc14/WL 0
C7478 rc2/WL c_1_0/Q 0
C7479 VDD c_1_0/QB 0.01264f
C7480 c_5_4/Q c_5_5/QB 0.00377f
C7481 c_4_8/QB c_4_7/QB 0
C7482 VDD c_1_5/Q 0.00756f
C7483 c_3_3/Q bl4 0
C7484 c_12_13/Q rc11/WL 0
C7485 cl1 cs15/n/Y 0
C7486 csel10 dl 0.08427f
C7487 rc2/s/wd/A rh2 0
C7488 c_8_10/Q c_9_10/QB 0
C7489 VDD cs15/n/Y -0
C7490 rc8/WL c_9_8/QB 0
C7491 c_0_13/Q dl 0.00931f
C7492 ch2 c_0_12/QB 0
C7493 c_5_7/QB c_5_8/Q 0.01135f
C7494 c_1_4/QB dlb 0
C7495 c_1_4/Q dl 0.00273f
C7496 c_2_14/Q c_1_14/QB 0
C7497 rl3 rc8/s/wd/A 0.00121f
C7498 c_2_11/Q bl12 0
C7499 rc5/WL c_5_11/QB 0
C7500 c_12_13/QB VDD 0.00969f
C7501 c_13_9/QB VDD 0.00969f
C7502 csel13 cl0 0.07259f
C7503 c_2_0/Q rl2 0
C7504 c_7_3/QB rc8/WL 0
C7505 c_10_2/QB c_11_2/Q 0
C7506 c_12_8/Q c_12_7/QB 0.01135f
C7507 c_5_7/QB c_5_6/QB 0
C7508 c_4_9/QB c_4_8/QB 0
C7509 bl13 c_10_12/Q 0
C7510 blb6 c_1_7/QB 0
C7511 c_3_13/QB c_2_13/QB 0.01281f
C7512 bl3 c_7_2/QB 0.00303f
C7513 c_7_12/Q c_6_12/Q 0.00654f
C7514 rc0/s/wd/A bl0 0.00934f
C7515 c_14_2/QB c_14_3/Q 0.01135f
C7516 c_14_2/Q c_14_3/QB 0.00377f
C7517 c_13_4/Q c_13_5/Q 0
C7518 c_4_0/Q rh1 0
C7519 bl15 cl0 0
C7520 bl3 c_5_2/QB 0.00303f
C7521 c_6_2/QB c_6_3/QB 0
C7522 c_2_12/Q rc3/WL 0
C7523 clkb rc13/s/wd/A 0.09749f
C7524 rc12/s/n3/a_302_47# rc11/s/wd/A 0
C7525 ch1 bl4 0
C7526 c_1_10/QB c_1_11/Q 0.01135f
C7527 c_1_10/Q c_1_11/QB 0.00377f
C7528 c_8_4/QB c_8_3/QB 0
C7529 c_14_11/QB VDD 0.00969f
C7530 ch2 c_0_8/QB 0
C7531 c_5_13/QB c_5_12/Q 0.00377f
C7532 c_8_2/Q c_9_2/QB 0
C7533 blb9 c_9_10/QB 0
C7534 ch3 rl2 0.02782f
C7535 ch2 rc0/WL 0.00348f
C7536 c_2_13/QB c_1_13/QB 0.0025f
C7537 rh0 rc14/s/wd/A 0
C7538 c_0_4/QB cl0 0
C7539 c_0_11/QB dl 0.0049f
C7540 c_4_4/QB bl5 0.00303f
C7541 c_9_9/Q rc9/WL 0
C7542 c_2_5/Q c_2_4/Q 0
C7543 blb0 c_5_1/QB 0
C7544 blb3 c_14_4/QB 0
C7545 c_14_11/Q c_13_11/Q 0.00634f
C7546 c_2_1/QB c_1_1/QB 0.0025f
C7547 pcb c_14_10/Q 0.00166f
C7548 rc15/WL rh3 0.00372f
C7549 c_5_2/QB c_5_3/QB 0
C7550 rc12/s/wd/A blb0 0
C7551 c_3_10/QB c_3_11/Q 0.01135f
C7552 rc2/WL c_3_9/QB 0
C7553 rc14/s/n3/a_302_47# VDD -0
C7554 c_3_11/Q bl12 0
C7555 rc14/WL c_13_11/Q 0
C7556 rc0/WL csel9 0.02369f
C7557 c_1_12/QB c_2_12/QB 0.0025f
C7558 c_13_8/QB c_13_7/QB 0
C7559 c_11_0/Q c_12_0/QB 0
C7560 c_8_1/Q c_8_2/Q 0
C7561 rc0/WL c_1_6/QB 0
C7562 blb12 rc7/WL 0.00159f
C7563 c_12_4/QB bl5 0.00303f
C7564 blb13 csel13 0.00807f
C7565 rc2/WL c_1_15/Q 0
C7566 VDD rc1/WL 0.05867f
C7567 c_3_13/QB c_4_13/QB 0.0025f
C7568 blb11 c_14_12/QB 0
C7569 c_10_8/QB rc10/WL 0
C7570 rc2/WL c_3_14/QB 0
C7571 c_8_5/Q c_7_5/QB 0
C7572 c_8_5/QB c_7_5/Q 0
C7573 rh0 pcb 0.00205f
C7574 c_14_1/Q c_14_0/Q 0
C7575 c_4_0/QB c_5_0/Q 0
C7576 c_4_0/Q c_5_0/QB 0
C7577 bl2 c_6_1/QB 0.00303f
C7578 c_3_13/Q rc4/WL 0
C7579 c_4_5/QB c_3_5/QB 0.0025f
C7580 VDD rc10/WL 0.05907f
C7581 ch0 c_0_11/Q 0
C7582 c_2_5/QB rc2/WL 0
C7583 c_13_3/Q c_13_2/QB 0.01135f
C7584 c_13_3/QB c_13_2/Q 0.00377f
C7585 rc12/WL c_12_5/QB 0
C7586 c_6_8/Q rc6/WL 0
C7587 VDD c_6_6/Q 0.00756f
C7588 c_0_7/QB cl0 0
C7589 c_15_3/Q c_14_3/QB 0
C7590 csel0 ch3 0.03056f
C7591 c_11_4/QB bl5 0.00303f
C7592 c_3_13/Q bl14 0
C7593 ch2 c_0_15/QB 0
C7594 rc11/WL bl8 0.00159f
C7595 cs3/n/Y cs2/n/a_162_47# 0
C7596 ch2 cs14/n/Y 0
C7597 csel14 c_1_14/QB 0
C7598 VDD rc10/s/n3/a_162_47# 0
C7599 VDD c_8_3/QB 0.00969f
C7600 cs6/n/Y cs5/n/Y 0.02812f
C7601 c_12_15/Q c_12_14/Q 0
C7602 ch1 cl0 0.39554f
C7603 bl6 c_3_5/QB 0.00303f
C7604 csel4 c_0_4/Q 0.00119f
C7605 c_0_4/QB c_0_3/Q 0.00377f
C7606 c_3_3/QB c_3_4/Q 0.01135f
C7607 blb1 c_7_2/QB 0
C7608 c_12_9/Q blb8 0.00303f
C7609 rc9/WL c_10_12/QB 0
C7610 rc5/WL c_5_4/QB 0
C7611 rc12/WL blb15 0
C7612 c_0_1/QB c_1_1/QB 0.01281f
C7613 c_0_2/QB bl3 0.00303f
C7614 blb1 c_5_2/QB 0
C7615 c_9_7/QB rc10/WL 0
C7616 c_5_7/Q bl8 0
C7617 rc6/WL c_6_9/QB 0
C7618 blb13 c_11_14/QB 0
C7619 c_6_14/Q rc7/WL 0
C7620 c_11_8/QB blb7 0
C7621 rc5/WL c_6_0/QB 0
C7622 c_8_0/Q rh2 0
C7623 VDD rc6/WL 0.05907f
C7624 cl1 rh2 0.02782f
C7625 rc5/WL bl7 0.00159f
C7626 blb3 bl3 -0.00665f
C7627 rc8/WL blb8 0.00159f
C7628 c_2_15/QB c_1_15/QB 0.0025f
C7629 VDD rh2 0.54656f
C7630 VDD c_13_10/Q 0.00756f
C7631 rc13/WL c_12_5/QB 0
C7632 rc11/WL c_12_10/Q 0
C7633 c_9_15/QB c_9_14/Q 0.00377f
C7634 c_9_15/Q c_9_14/QB 0.01135f
C7635 rc6/WL c_5_5/QB 0
C7636 blb2 rc12/WL 0.00159f
C7637 rl1 rc7/WL 0
C7638 c_7_11/Q rc7/WL 0
C7639 cs3/n/Y csel3 0.07585f
C7640 csel14 ch3 0.26154f
C7641 VDD c_1_13/Q 0.00756f
C7642 c_15_11/Q bl12 0
C7643 c_12_11/QB c_12_12/QB 0
C7644 rc12/WL c_13_1/QB 0
C7645 VDD c_12_10/QB 0.00969f
C7646 rc11/WL c_11_11/QB 0
C7647 ch0 blb5 0.00109f
C7648 c_15_11/Q bl11 0
C7649 rc13/WL blb15 0
C7650 bl12 c_9_11/Q 0
C7651 ch1 c_0_3/Q 0
C7652 c_12_6/QB c_11_6/Q 0
C7653 c_12_6/Q c_11_6/QB 0
C7654 c_2_11/Q rc2/WL 0
C7655 c_11_15/Q c_10_15/Q 0.00654f
C7656 VDD c_1_7/Q 0.00756f
C7657 ch1 blb13 0
C7658 c_6_5/Q rc5/WL 0
C7659 rc11/WL c_11_10/QB 0
C7660 c_8_10/Q c_8_9/Q 0
C7661 VDD c_11_1/Q 0.00756f
C7662 c_2_9/QB c_2_10/Q 0.01135f
C7663 c_5_6/Q rc4/WL 0
C7664 csel2 dl 0.08427f
C7665 c_5_10/QB c_6_10/Q 0
C7666 c_7_1/QB c_8_1/Q 0
C7667 c_7_1/Q c_8_1/QB 0
C7668 c_12_3/Q c_12_4/Q 0
C7669 c_13_0/QB c_13_1/Q 0.01135f
C7670 rc8/WL c_8_13/QB 0
C7671 cl2 bl13 0
C7672 c_5_14/QB VDD 0.00969f
C7673 blb2 rc13/WL 0.00159f
C7674 c_3_15/QB c_3_14/Q 0.00377f
C7675 c_7_4/Q c_7_5/Q 0
C7676 blb5 c_10_6/Q 0.00303f
C7677 c_15_6/Q blb5 0.00303f
C7678 rc13/s/wd/A rc14/s/wd/A 0.02007f
C7679 rc12/WL c_12_7/Q 0
C7680 c_4_9/QB blb8 0
C7681 rc14/WL c_13_9/Q 0
C7682 rc13/WL c_13_1/QB 0
C7683 c_6_2/QB rc6/WL 0
C7684 rc6/WL c_7_15/Q 0
C7685 bl1 c_14_0/Q 0
C7686 c_11_15/Q c_10_15/QB 0
C7687 c_0_2/QB blb1 0
C7688 c_14_15/Q rc14/WL 0
C7689 rc9/WL c_8_10/QB 0
C7690 cs4/n/Y ch1 0.09738f
C7691 csel4 blb3 0.00103f
C7692 ch2 blb12 0
C7693 c_3_13/QB rc4/WL 0
C7694 c_7_14/QB rc8/WL 0
C7695 c_15_12/Q blb12 0
C7696 c_1_1/QB blb0 0
C7697 c_3_10/Q c_3_9/QB 0.01135f
C7698 rc2/WL c_2_12/QB 0
C7699 clkb rc12/WL 0.00509f
C7700 ch3 rh1 0.02782f
C7701 ch2 cs7/n/Y 0.0011f
C7702 c_2_1/QB rc1/WL 0
C7703 VDD c_7_5/QB 0.00969f
C7704 c_3_13/QB bl14 0.00303f
C7705 rl3 rc7/WL 0.00286f
C7706 ch2 ch0 0.1493f
C7707 rc11/WL c_10_7/QB 0
C7708 c_9_7/Q VDD 0.00756f
C7709 csel10 cl2 0.03033f
C7710 c_15_12/Q c_15_13/Q 0
C7711 rc2/WL c_3_11/Q 0
C7712 c_9_0/QB c_8_0/QB 0.01281f
C7713 rc12/s/wd/A bl0 0.00934f
C7714 pcb rc13/s/wd/A 0
C7715 clkb c_11_0/QB 0
C7716 c_0_14/QB c_1_14/Q 0
C7717 c_0_14/Q c_1_14/QB 0
C7718 rc0/WL rc1/s/wd/A 0
C7719 c_2_14/QB rc3/WL 0
C7720 rc12/s/wd/A rc11/s/n3/a_302_47# 0
C7721 c_0_6/QB dl 0.0049f
C7722 VDD c_14_10/QB 0.00969f
C7723 ch0 csel9 0.03716f
C7724 c_14_11/QB c_14_12/QB 0
C7725 c_12_7/Q rc13/WL 0
C7726 c_2_11/QB VDD 0.00969f
C7727 rc5/WL c_4_5/QB 0
C7728 c_8_1/QB rc8/WL 0
C7729 VDD c_12_14/Q 0.00756f
C7730 c_12_5/QB c_11_5/QB 0.0025f
C7731 c_11_12/QB c_10_12/Q 0
C7732 c_1_13/QB bl14 0.00303f
C7733 blb2 c_7_3/QB 0
C7734 rl3 c_11_0/Q 0
C7735 rc3/s/n3/a_162_47# bl0 0
C7736 c_4_4/QB c_4_3/QB 0
C7737 rc4/WL blb14 0.00159f
C7738 c_12_4/Q c_13_4/QB 0
C7739 VDD c_15_13/QB 0.01187f
C7740 bl12 csel11 0.00103f
C7741 c_10_10/Q c_11_10/QB 0
C7742 c_9_14/QB rc10/WL 0
C7743 clkb rc13/WL 0.00509f
C7744 c_13_2/QB c_12_2/QB 0.01281f
C7745 blb2 csel2 0.00807f
C7746 bl3 ch3 0
C7747 rc5/WL bl6 0.00159f
C7748 c_0_5/QB c_0_4/Q 0.00377f
C7749 bl11 csel11 0.00807f
C7750 blb14 bl14 -0.00665f
C7751 c_10_11/Q c_10_12/QB 0.00377f
C7752 c_14_8/Q c_15_8/Q 0.00654f
C7753 csel6 rc1/WL 0
C7754 c_2_15/Q rc1/WL 0
C7755 VDD c_9_12/Q 0.00756f
C7756 ch2 rl1 0.02782f
C7757 c_0_14/Q ch3 0
C7758 c_0_1/QB rc1/WL 0
C7759 c_3_2/Q rc3/WL 0
C7760 bl1 c_15_0/QB 0.00303f
C7761 c_3_9/Q rc4/WL 0
C7762 dl blb8 0.02104f
C7763 csel15 dl 0.08425f
C7764 c_6_0/QB rc7/WL 0
C7765 VDD c_15_2/Q 0.015f
C7766 c_9_4/Q c_8_4/Q 0.00654f
C7767 bl8 c_4_7/Q 0
C7768 bl7 rc7/WL 0.00159f
C7769 pcb bl13 0.07118f
C7770 ch3 bl12 0
C7771 rc6/s/n3/a_302_47# VDD -0
C7772 c_12_8/Q c_12_8/QB 0
C7773 c_9_12/QB c_9_13/Q 0.01135f
C7774 rc9/WL c_8_3/Q 0
C7775 c_12_5/QB c_12_4/QB 0
C7776 bl7 c_10_6/QB 0.00303f
C7777 c_10_1/QB rc10/WL 0
C7778 bl2 ch3 0
C7779 bl11 ch3 0
C7780 c_15_6/QB bl7 0.00303f
C7781 rc12/WL c_13_2/Q 0
C7782 c_4_15/QB rc3/WL 0
C7783 c_14_2/Q c_14_1/Q 0
C7784 c_11_4/Q c_10_4/Q 0.00654f
C7785 c_8_15/Q c_8_14/Q 0
C7786 c_1_10/QB dlb 0
C7787 c_1_10/Q dl 0.00273f
C7788 c_8_11/QB c_8_12/Q 0.01135f
C7789 cs13/n/Y cs13/n/a_162_47# -0
C7790 bl8 rc9/WL 0.00159f
C7791 cs2/n/Y dlb 0
C7792 bl13 c_7_12/Q 0
C7793 c_6_4/Q c_5_4/QB 0
C7794 blb3 rc2/WL 0.00159f
C7795 blb11 c_3_12/Q 0.00303f
C7796 csel4 ch3 0.02926f
C7797 c_7_3/Q VDD 0.00756f
C7798 c_6_5/Q rc7/WL 0
C7799 c_1_6/Q blb5 0.00303f
C7800 csel1 dlb 0.10216f
C7801 c_2_8/Q bl9 0
C7802 blb10 cl1 0
C7803 blb15 csel15 0.00807f
C7804 rh0 c_3_0/QB 0
C7805 c_4_10/Q c_3_10/QB 0
C7806 csel10 cs9/n/Y 0
C7807 cl3 dlb 0.04283f
C7808 blb10 VDD -0.00917f
C7809 c_14_2/QB c_15_2/Q 0
C7810 c_14_2/Q c_15_2/QB 0
C7811 blb1 ch3 0
C7812 rl3 ch2 0.02782f
C7813 cs14/n/a_162_47# cl2 0.00134f
C7814 bl1 rc4/s/wd/A 0
C7815 c_9_6/Q rc10/WL 0
C7816 bl3 c_1_2/Q 0
C7817 bl11 c_4_10/Q 0
C7818 c_13_6/Q rc12/WL 0
C7819 c_10_2/QB c_9_2/QB 0.0025f
C7820 c_10_14/QB rc10/WL 0
C7821 c_2_4/QB c_1_4/QB 0.0025f
C7822 rc13/WL c_13_2/Q 0
C7823 cs1/n/Y csel0 0.00301f
C7824 c_3_12/QB c_4_12/QB 0.0025f
C7825 c_4_15/QB c_5_15/Q 0
C7826 cs4/n/a_162_47# cl3 0
C7827 c_1_2/QB c_2_2/Q 0
C7828 c_1_2/Q c_2_2/QB 0
C7829 blb0 rc1/WL 0.00236f
C7830 bl0 rc15/s/n3/a_162_47# 0
C7831 cl1 csel13 0.03035f
C7832 c_3_10/Q c_3_11/Q 0
C7833 VDD csel13 0.02187f
C7834 bl11 c_0_10/Q 0
C7835 rc9/s/wd/A rc10/s/n3/a_302_47# 0
C7836 c_14_4/QB c_14_3/QB 0
C7837 c_8_9/Q rc7/WL 0
C7838 cl3 csel7 0.04036f
C7839 blb0 rc10/WL 0.00236f
C7840 c_4_15/QB c_3_15/Q 0
C7841 rc11/WL c_10_13/Q 0
C7842 c_0_1/Q c_0_0/Q 0
C7843 c_6_5/Q c_6_4/Q 0
C7844 c_2_14/QB blb13 0
C7845 c_11_8/Q c_10_8/QB 0
C7846 c_11_8/QB c_10_8/Q 0
C7847 cl1 bl15 0
C7848 rc2/WL c_3_15/QB 0
C7849 c_14_6/QB c_15_6/QB 0.01281f
C7850 c_11_1/Q c_12_1/QB 0
C7851 VDD bl15 -0.00929f
C7852 c_13_11/QB c_13_12/QB 0
C7853 c_10_1/QB c_11_1/Q 0
C7854 c_1_2/QB c_1_3/Q 0.01135f
C7855 c_1_2/Q c_1_3/QB 0.00377f
C7856 rc11/WL c_11_14/Q 0
C7857 c_1_1/Q dl 0.00273f
C7858 VDD c_11_8/Q 0.00756f
C7859 c_13_6/Q rc13/WL 0
C7860 clkb rc4/s/n3/a_302_47# 0.00768f
C7861 bl9 c_10_8/Q 0
C7862 bl1 c_7_0/QB 0.00303f
C7863 rl0 rc8/WL 0.0029f
C7864 rc5/s/wd/A VDD -0.00408f
C7865 cl2 csel2 0.03033f
C7866 c_0_4/QB VDD 0.00969f
C7867 bl8 dlb 0
C7868 c_15_3/Q c_15_2/QB 0.01135f
C7869 rc2/WL csel11 0
C7870 c_13_6/QB blb5 0
C7871 rc13/WL rc14/s/wd/A 0
C7872 rc2/WL c_1_14/QB 0
C7873 VDD c_11_14/QB 0.00969f
C7874 c_2_0/QB c_1_0/Q 0
C7875 clkb rc1/s/n3/a_162_47# 0.00107f
C7876 c_3_3/Q VDD 0.00756f
C7877 rc6/WL blb0 0.00236f
C7878 c_3_12/QB rc4/WL 0
C7879 rh2 blb0 0
C7880 ch2 bl7 0
C7881 csel9 c_1_9/QB 0
C7882 bl6 rc7/WL 0.00159f
C7883 c_1_6/QB c_1_6/Q -0
C7884 c_2_0/Q rc2/WL 0.01507f
C7885 c_7_14/Q c_6_14/Q 0.00654f
C7886 c_5_10/Q rc6/WL 0
C7887 VDD c_13_8/QB 0.00969f
C7888 c_6_2/Q c_7_2/Q 0.00654f
C7889 c_13_1/Q rc14/WL 0
C7890 c_9_0/QB rc9/WL 0.00535f
C7891 clkb rc9/s/n3/a_302_47# 0.00768f
C7892 c_1_2/Q blb1 0.00303f
C7893 cl3 bl4 0
C7894 rc14/WL bl4 0.00159f
C7895 c_8_14/QB bl15 0.00303f
C7896 c_6_2/Q c_5_2/Q 0.00634f
C7897 rc9/WL c_10_7/QB 0
C7898 cs0/n/Y dlb 0
C7899 c_14_6/QB blb5 0
C7900 bl8 csel7 0.00103f
C7901 c_6_2/Q c_6_1/Q 0
C7902 rc15/WL c_14_14/QB 0
C7903 c_5_2/Q rc4/WL 0
C7904 c_9_13/QB blb12 0
C7905 c_0_7/QB VDD 0.00969f
C7906 csel8 rc1/WL 0
C7907 c_14_14/Q c_14_13/QB 0.01135f
C7908 c_14_14/QB c_14_13/Q 0.00377f
C7909 c_9_15/Q c_10_15/Q 0.00634f
C7910 c_1_6/QB bl7 0.00303f
C7911 rc1/s/wd/A rl1 0.05346f
C7912 c_2_9/QB c_1_9/QB 0.0025f
C7913 bl1 rc4/WL 0.00215f
C7914 c_14_5/QB rc13/WL 0
C7915 rc11/WL bl13 0.00159f
C7916 ch1 cl1 0.37012f
C7917 c_11_1/Q blb0 0.00303f
C7918 ch1 VDD 0.342f
C7919 rc2/s/wd/A rc2/s/n3/a_302_47# -0
C7920 cs3/n/Y dl 0
C7921 c_4_4/Q c_5_4/QB 0
C7922 bl11 c_15_10/Q 0
C7923 c_0_13/QB c_0_12/Q 0.00377f
C7924 c_5_11/Q c_5_12/QB 0.00377f
C7925 c_5_14/Q rc4/WL 0
C7926 c_3_13/Q c_3_14/Q 0
C7927 bl8 rc3/WL 0.00159f
C7928 c_9_6/Q c_9_7/Q 0
C7929 c_9_15/Q c_10_15/QB 0
C7930 cs2/n/Y cl0 0
C7931 c_2_12/Q VDD 0.00756f
C7932 ch3 c_0_5/QB 0
C7933 rc0/WL c_0_12/QB 0
C7934 rc13/WL c_14_0/QB 0
C7935 c_1_15/QB c_1_14/QB 0
C7936 c_7_8/Q blb7 0.00303f
C7937 bl11 c_7_10/Q 0
C7938 rc13/WL c_12_15/QB 0
C7939 c_8_3/Q bl4 0
C7940 bl9 rc4/WL 0.00159f
C7941 blb5 bl6 2.86379f
C7942 bl8 c_8_7/Q 0
C7943 c_3_3/QB rc4/WL 0
C7944 rc5/WL c_4_6/QB 0
C7945 rc5/WL bl5 0.00159f
C7946 c_0_0/Q csel0 0.00119f
C7947 ch1 cs5/n/a_162_47# 0.00134f
C7948 csel1 cl0 0.07259f
C7949 c_2_13/Q bl14 0
C7950 rh3 rc6/s/wd/A 0
C7951 rc8/s/wd/A rc8/WL -0.00118f
C7952 rc14/WL c_13_7/QB 0
C7953 cl3 cl0 0.18881f
C7954 blb8 c_1_9/Q 0.00303f
C7955 cl2 blb8 0
C7956 c_8_10/Q rc8/WL 0
C7957 rc11/WL c_11_9/Q 0
C7958 rl3 rc12/s/n3/a_302_47# 0.00105f
C7959 cl2 csel15 0.05854f
C7960 c_2_4/Q c_3_4/QB 0
C7961 c_14_14/QB c_15_14/Q 0
C7962 c_15_11/Q rc15/WL 0
C7963 rc12/WL c_13_14/Q 0
C7964 c_2_10/QB rc1/WL 0
C7965 bl3 c_11_2/QB 0.00303f
C7966 c_8_8/Q rc7/WL 0
C7967 pcb c_15_12/QB 0.00493f
C7968 c_12_8/Q c_12_9/Q 0
C7969 rc14/s/n3/a_302_47# bl0 0.00159f
C7970 c_3_6/Q GND 0
C7971 c_3_6/QB GND 0
C7972 c_1_3/Q GND 0
C7973 c_1_3/QB GND 0
C7974 c_6_13/Q GND 0
C7975 c_6_13/QB GND 0
C7976 c_13_4/Q GND 0
C7977 c_13_4/QB GND 0
C7978 c_15_7/Q GND 0
C7979 c_15_7/QB GND 0
C7980 c_0_14/Q GND 0
C7981 c_0_14/QB GND 0
C7982 c_5_9/Q GND 0
C7983 c_5_9/QB GND 0
C7984 c_9_12/Q GND 0
C7985 c_9_12/QB GND 0
C7986 c_3_13/Q GND 0
C7987 c_3_13/QB GND 0
C7988 blb11 GND -2.90164f
C7989 bl11 GND -2.89985f
C7990 c_1_2/Q GND 0
C7991 c_1_2/QB GND 0
C7992 c_6_12/Q GND 0
C7993 c_6_12/QB GND 0
C7994 c_11_0/Q GND 0
C7995 c_11_0/QB GND 0
C7996 c_13_3/Q GND 0
C7997 c_13_3/QB GND 0
C7998 c_3_5/Q GND 0
C7999 c_3_5/QB GND 0
C8000 c_15_6/Q GND 0
C8001 c_15_6/QB GND 0
C8002 c_0_13/Q GND 0
C8003 c_0_13/QB GND 0
C8004 c_5_8/Q GND 0
C8005 c_5_8/QB GND 0
C8006 c_9_11/Q GND 0
C8007 c_9_11/QB GND 0
C8008 c_3_12/Q GND 0
C8009 c_3_12/QB GND 0
C8010 blb10 GND -2.90183f
C8011 bl10 GND -2.89985f
C8012 rc15/WL GND -1.71193f
C8013 rc15/s/wd/A GND -0.29754f
C8014 rc15/s/n3/a_162_47# GND 0
C8015 c_1_1/Q GND 0
C8016 c_1_1/QB GND 0
C8017 c_6_11/Q GND 0
C8018 c_6_11/QB GND 0
C8019 c_13_2/Q GND 0
C8020 c_13_2/QB GND 0
C8021 c_3_4/Q GND 0
C8022 c_3_4/QB GND 0
C8023 c_0_12/Q GND 0
C8024 c_0_12/QB GND 0
C8025 c_5_7/Q GND 0
C8026 c_5_7/QB GND 0
C8027 c_9_10/Q GND 0
C8028 c_9_10/QB GND 0
C8029 c_15_5/Q GND 0
C8030 c_15_5/QB GND 0
C8031 c_3_11/Q GND 0
C8032 c_3_11/QB GND 0
C8033 c_1_0/Q GND 0
C8034 c_1_0/QB GND 0
C8035 c_6_10/Q GND 0
C8036 c_6_10/QB GND 0
C8037 rc14/WL GND -2.39734f
C8038 rc14/s/wd/A GND -0.29772f
C8039 rc14/s/n3/a_162_47# GND 0
C8040 c_13_1/Q GND 0
C8041 c_13_1/QB GND 0
C8042 c_3_3/Q GND 0
C8043 c_3_3/QB GND 0
C8044 c_15_4/Q GND 0
C8045 c_15_4/QB GND 0
C8046 c_0_11/Q GND 0
C8047 c_0_11/QB GND 0
C8048 c_5_6/Q GND 0
C8049 c_5_6/QB GND 0
C8050 c_7_9/Q GND 0
C8051 c_7_9/QB GND 0
C8052 c_3_10/Q GND 0
C8053 c_3_10/QB GND 0
C8054 rc13/WL GND -2.39734f
C8055 rc13/s/wd/A GND -0.29772f
C8056 rc13/s/n3/a_162_47# GND 0
C8057 c_13_0/Q GND 0
C8058 c_13_0/QB GND 0
C8059 c_3_2/Q GND 0
C8060 c_3_2/QB GND 0
C8061 c_0_10/Q GND 0
C8062 c_0_10/QB GND 0
C8063 c_5_5/Q GND 0
C8064 c_5_5/QB GND 0
C8065 c_15_3/Q GND 0
C8066 c_15_3/QB GND 0
C8067 c_7_8/Q GND 0
C8068 c_7_8/QB GND 0
C8069 rc12/WL GND -2.39734f
C8070 rc12/s/wd/A GND -0.29772f
C8071 rh3 GND 1.67611f
C8072 rc12/s/n3/a_162_47# GND 0
C8073 c_3_1/Q GND 0
C8074 c_3_1/QB GND 0
C8075 c_13_15/Q GND 0
C8076 c_13_15/QB GND 0
C8077 c_15_2/Q GND 0
C8078 c_15_2/QB GND 0
C8079 c_5_4/Q GND 0
C8080 c_5_4/QB GND 0
C8081 c_7_7/Q GND 0
C8082 c_7_7/QB GND 0
C8083 c_10_15/Q GND 0
C8084 c_10_15/QB GND 0
C8085 rc11/WL GND -2.39734f
C8086 rc11/s/wd/A GND -0.29772f
C8087 rc11/s/n3/a_162_47# GND 0
C8088 c_13_14/Q GND 0
C8089 c_13_14/QB GND 0
C8090 c_3_0/Q GND 0
C8091 c_3_0/QB GND 0
C8092 c_5_3/Q GND 0
C8093 c_5_3/QB GND 0
C8094 c_15_1/Q GND 0
C8095 c_15_1/QB GND 0
C8096 c_7_6/Q GND 0
C8097 c_7_6/QB GND 0
C8098 c_10_14/Q GND 0
C8099 c_10_14/QB GND 0
C8100 rc10/WL GND -2.39734f
C8101 rc10/s/wd/A GND -0.29772f
C8102 rc10/s/n3/a_162_47# GND 0
C8103 c_9_9/Q GND 0
C8104 c_9_9/QB GND 0
C8105 rc9/WL GND -2.39734f
C8106 rc9/s/wd/A GND -0.29772f
C8107 rc9/s/n3/a_162_47# GND 0
C8108 c_13_13/Q GND 0
C8109 c_13_13/QB GND 0
C8110 c_15_0/Q GND 0
C8111 c_15_0/QB GND 0
C8112 c_5_2/Q GND 0
C8113 c_5_2/QB GND 0
C8114 c_7_5/Q GND 0
C8115 c_7_5/QB GND 0
C8116 c_9_8/Q GND 0
C8117 c_9_8/QB GND 0
C8118 c_10_13/Q GND 0
C8119 c_10_13/QB GND 0
C8120 c_13_12/Q GND 0
C8121 c_13_12/QB GND 0
C8122 rc8/WL GND -2.39734f
C8123 rc8/s/wd/A GND -0.29772f
C8124 rh2 GND 1.46059f
C8125 rc8/s/n3/a_162_47# GND 0
C8126 c_10_9/Q GND 0
C8127 c_10_9/QB GND 0
C8128 c_5_1/Q GND 0
C8129 c_5_1/QB GND 0
C8130 c_7_4/Q GND 0
C8131 c_7_4/QB GND 0
C8132 c_9_7/Q GND 0
C8133 c_9_7/QB GND 0
C8134 c_10_12/Q GND 0
C8135 c_10_12/QB GND 0
C8136 rc7/WL GND -2.39734f
C8137 rc7/s/wd/A GND -0.29772f
C8138 rc7/s/n3/a_162_47# GND 0
C8139 c_13_11/Q GND 0
C8140 c_13_11/QB GND 0
C8141 c_5_0/Q GND 0
C8142 c_5_0/QB GND 0
C8143 c_10_8/Q GND 0
C8144 c_10_8/QB GND 0
C8145 c_7_3/Q GND 0
C8146 c_7_3/QB GND 0
C8147 c_9_6/Q GND 0
C8148 c_9_6/QB GND 0
C8149 c_10_11/Q GND 0
C8150 c_10_11/QB GND 0
C8151 c_8_15/Q GND 0
C8152 c_8_15/QB GND 0
C8153 c_13_10/Q GND 0
C8154 c_13_10/QB GND 0
C8155 c_5_15/Q GND 0
C8156 c_5_15/QB GND 0
C8157 rc6/WL GND -2.39734f
C8158 rc6/s/wd/A GND -0.29772f
C8159 rc6/s/n3/a_162_47# GND 0
C8160 c_10_7/Q GND 0
C8161 c_10_7/QB GND 0
C8162 c_0_9/Q GND 0
C8163 c_0_9/QB GND 0
C8164 c_7_2/Q GND 0
C8165 c_7_2/QB GND 0
C8166 c_8_14/Q GND 0
C8167 c_8_14/QB GND 0
C8168 c_9_5/Q GND 0
C8169 c_9_5/QB GND 0
C8170 c_10_10/Q GND 0
C8171 c_10_10/QB GND 0
C8172 c_2_15/Q GND 0
C8173 c_2_15/QB GND 0
C8174 rc5/WL GND -2.39734f
C8175 rc5/s/wd/A GND -0.29772f
C8176 rc5/s/n3/a_162_47# GND 0
C8177 c_0_8/Q GND 0
C8178 c_0_8/QB GND 0
C8179 c_5_14/Q GND 0
C8180 c_5_14/QB GND 0
C8181 c_10_6/Q GND 0
C8182 c_10_6/QB GND 0
C8183 c_12_9/Q GND 0
C8184 c_12_9/QB GND 0
C8185 c_7_1/Q GND 0
C8186 c_7_1/QB GND 0
C8187 c_8_13/Q GND 0
C8188 c_8_13/QB GND 0
C8189 c_2_14/Q GND 0
C8190 c_2_14/QB GND 0
C8191 c_9_4/Q GND 0
C8192 c_9_4/QB GND 0
C8193 rc4/WL GND -2.39734f
C8194 rc4/s/wd/A GND -0.29772f
C8195 rh1 GND 1.3169f
C8196 rc4/s/n3/a_162_47# GND 0
C8197 c_5_13/Q GND 0
C8198 c_5_13/QB GND 0
C8199 c_10_5/Q GND 0
C8200 c_10_5/QB GND 0
C8201 c_0_7/Q GND 0
C8202 c_0_7/QB GND 0
C8203 c_7_0/Q GND 0
C8204 c_7_0/QB GND 0
C8205 c_8_12/Q GND 0
C8206 c_8_12/QB GND 0
C8207 c_12_8/Q GND 0
C8208 c_12_8/QB GND 0
C8209 c_9_3/Q GND 0
C8210 c_9_3/QB GND 0
C8211 c_2_13/Q GND 0
C8212 c_2_13/QB GND 0
C8213 rc3/WL GND -2.38695f
C8214 rc3/s/wd/A GND -0.29772f
C8215 rl3 GND 1.25466f
C8216 rc3/s/n3/a_162_47# GND 0
C8217 c_5_12/Q GND 0
C8218 c_5_12/QB GND 0
C8219 c_10_4/Q GND 0
C8220 c_10_4/QB GND 0
C8221 c_12_7/Q GND 0
C8222 c_12_7/QB GND 0
C8223 c_2_9/Q GND 0
C8224 c_2_9/QB GND 0
C8225 c_0_6/Q GND 0
C8226 c_0_6/QB GND 0
C8227 c_8_11/Q GND 0
C8228 c_8_11/QB GND 0
C8229 c_2_12/Q GND 0
C8230 c_2_12/QB GND 0
C8231 c_9_2/Q GND 0
C8232 c_9_2/QB GND 0
C8233 rc2/WL GND -2.39734f
C8234 rc2/s/wd/A GND -0.29772f
C8235 rl2 GND 1.20515f
C8236 rc2/s/n3/a_162_47# GND 0
C8237 c_5_11/Q GND 0
C8238 c_5_11/QB GND 0
C8239 c_10_3/Q GND 0
C8240 c_10_3/QB GND 0
C8241 blb9 GND -2.90206f
C8242 bl9 GND -2.89985f
C8243 c_0_5/Q GND 0
C8244 c_0_5/QB GND 0
C8245 c_12_6/Q GND 0
C8246 c_12_6/QB GND 0
C8247 c_2_8/Q GND 0
C8248 c_2_8/QB GND 0
C8249 c_9_1/Q GND 0
C8250 c_9_1/QB GND 0
C8251 c_8_10/Q GND 0
C8252 c_8_10/QB GND 0
C8253 c_14_9/Q GND 0
C8254 c_14_9/QB GND 0
C8255 c_2_11/Q GND 0
C8256 c_2_11/QB GND 0
C8257 rc1/WL GND -2.39579f
C8258 rc1/s/wd/A GND -0.29772f
C8259 rl1 GND 1.1839f
C8260 rc1/s/n3/a_162_47# GND 0
C8261 c_5_10/Q GND 0
C8262 c_5_10/QB GND 0
C8263 c_10_2/Q GND 0
C8264 c_10_2/QB GND 0
C8265 c_2_7/Q GND 0
C8266 c_2_7/QB GND 0
C8267 blb8 GND -2.90235f
C8268 bl8 GND -2.89985f
C8269 c_0_4/Q GND 0
C8270 c_0_4/QB GND 0
C8271 c_12_5/Q GND 0
C8272 c_12_5/QB GND 0
C8273 c_14_8/Q GND 0
C8274 c_14_8/QB GND 0
C8275 c_2_10/Q GND 0
C8276 c_2_10/QB GND 0
C8277 c_9_0/Q GND 0
C8278 c_9_0/QB GND 0
C8279 rc0/WL GND -1.62391f
C8280 rc0/s/wd/A GND -0.29754f
C8281 clkb GND 1.83012f
C8282 rl0 GND 1.18547f
C8283 rh0 GND 1.21585f
C8284 rc0/s/n3/a_162_47# GND 0
C8285 c_10_1/Q GND 0
C8286 c_10_1/QB GND 0
C8287 blb7 GND -2.90164f
C8288 bl7 GND -2.89985f
C8289 c_0_3/Q GND 0
C8290 c_0_3/QB GND 0
C8291 c_12_4/Q GND 0
C8292 c_12_4/QB GND 0
C8293 c_2_6/Q GND 0
C8294 c_2_6/QB GND 0
C8295 c_4_9/Q GND 0
C8296 c_4_9/QB GND 0
C8297 c_14_7/Q GND 0
C8298 c_14_7/QB GND 0
C8299 c_15_15/Q GND 0
C8300 c_15_15/QB GND 0
C8301 pcb GND 9.14984f
C8302 csel9 GND 0.19728f
C8303 cs9/n/Y GND -0.10407f
C8304 cs9/n/a_162_47# GND 0
C8305 c_10_0/Q GND 0
C8306 c_10_0/QB GND 0
C8307 c_12_15/Q GND 0
C8308 c_12_15/QB GND 0
C8309 c_2_5/Q GND 0
C8310 c_2_5/QB GND 0
C8311 blb6 GND -2.90183f
C8312 bl6 GND -2.89985f
C8313 c_0_2/Q GND 0
C8314 c_0_2/QB GND 0
C8315 c_12_3/Q GND 0
C8316 c_12_3/QB GND 0
C8317 c_14_6/Q GND 0
C8318 c_14_6/QB GND 0
C8319 c_15_14/Q GND 0
C8320 c_15_14/QB GND 0
C8321 c_4_8/Q GND 0
C8322 c_4_8/QB GND 0
C8323 csel8 GND 0.20258f
C8324 cs8/n/Y GND -0.10407f
C8325 ch2 GND 0.95547f
C8326 cs8/n/a_162_47# GND 0
C8327 blb5 GND -2.90206f
C8328 bl5 GND -2.89985f
C8329 c_0_1/Q GND 0
C8330 c_0_1/QB GND 0
C8331 c_12_2/Q GND 0
C8332 c_12_2/QB GND 0
C8333 c_12_14/Q GND 0
C8334 c_12_14/QB GND 0
C8335 c_2_4/Q GND 0
C8336 c_2_4/QB GND 0
C8337 c_14_5/Q GND 0
C8338 c_14_5/QB GND 0
C8339 c_15_13/Q GND 0
C8340 c_15_13/QB GND 0
C8341 c_4_7/Q GND 0
C8342 c_4_7/QB GND 0
C8343 csel7 GND 0.18952f
C8344 cs7/n/Y GND -0.10407f
C8345 cs7/n/a_162_47# GND 0
C8346 c_12_13/Q GND 0
C8347 c_12_13/QB GND 0
C8348 c_2_3/Q GND 0
C8349 c_2_3/QB GND 0
C8350 blb4 GND -2.90235f
C8351 bl4 GND -2.89985f
C8352 c_0_0/Q GND 0
C8353 c_0_0/QB GND 0
C8354 c_12_1/Q GND 0
C8355 c_12_1/QB GND 0
C8356 c_14_4/Q GND 0
C8357 c_14_4/QB GND 0
C8358 c_15_12/Q GND 0
C8359 c_15_12/QB GND 0
C8360 c_4_6/Q GND 0
C8361 c_4_6/QB GND 0
C8362 c_6_9/Q GND 0
C8363 c_6_9/QB GND 0
C8364 blb3 GND -2.90164f
C8365 bl3 GND -2.89985f
C8366 csel6 GND 0.18726f
C8367 cs6/n/Y GND -0.10407f
C8368 cs6/n/a_162_47# GND 0
C8369 c_12_0/Q GND 0
C8370 c_12_0/QB GND 0
C8371 c_12_12/Q GND 0
C8372 c_12_12/QB GND 0
C8373 c_2_2/Q GND 0
C8374 c_2_2/QB GND 0
C8375 c_14_3/Q GND 0
C8376 c_14_3/QB GND 0
C8377 c_15_11/Q GND 0
C8378 c_15_11/QB GND 0
C8379 c_4_5/Q GND 0
C8380 c_4_5/QB GND 0
C8381 c_6_8/Q GND 0
C8382 c_6_8/QB GND 0
C8383 csel5 GND 0.185f
C8384 cs5/n/Y GND -0.10407f
C8385 cs5/n/a_162_47# GND 0
C8386 c_12_11/Q GND 0
C8387 c_12_11/QB GND 0
C8388 blb2 GND -2.67665f
C8389 bl2 GND -2.89985f
C8390 c_15_10/Q GND 0
C8391 c_15_10/QB GND 0
C8392 c_2_1/Q GND 0
C8393 c_2_1/QB GND 0
C8394 c_4_4/Q GND 0
C8395 c_4_4/QB GND 0
C8396 c_7_15/Q GND 0
C8397 c_7_15/QB GND 0
C8398 c_14_2/Q GND 0
C8399 c_14_2/QB GND 0
C8400 c_6_7/Q GND 0
C8401 c_6_7/QB GND 0
C8402 blb1 GND -2.90206f
C8403 bl1 GND -2.89985f
C8404 csel4 GND 0.19031f
C8405 cs4/n/Y GND -0.10407f
C8406 ch1 GND 1.01068f
C8407 cs4/n/a_162_47# GND 0
C8408 c_12_10/Q GND 0
C8409 c_12_10/QB GND 0
C8410 c_2_0/Q GND 0
C8411 c_2_0/QB GND 0
C8412 c_4_15/Q GND 0
C8413 c_4_15/QB GND 0
C8414 c_14_1/Q GND 0
C8415 c_14_1/QB GND 0
C8416 c_4_3/Q GND 0
C8417 c_4_3/QB GND 0
C8418 c_6_6/Q GND 0
C8419 c_6_6/QB GND 0
C8420 c_7_14/Q GND 0
C8421 c_7_14/QB GND 0
C8422 csel3 GND 0.17725f
C8423 cs3/n/Y GND -0.10407f
C8424 cl3 GND 3.34376f
C8425 cs3/n/a_162_47# GND 0
C8426 c_1_15/Q GND 0
C8427 c_1_15/QB GND 0
C8428 c_8_9/Q GND 0
C8429 c_8_9/QB GND 0
C8430 blb0 GND -2.90235f
C8431 dlb GND 1.3634f
C8432 dl GND 2.6256f
C8433 bl0 GND -2.02862f
C8434 c_4_14/Q GND 0
C8435 c_4_14/QB GND 0
C8436 c_4_2/Q GND 0
C8437 c_4_2/QB GND 0
C8438 c_7_13/Q GND 0
C8439 c_7_13/QB GND 0
C8440 c_14_0/Q GND 0
C8441 c_14_0/QB GND 0
C8442 c_6_5/Q GND 0
C8443 c_6_5/QB GND 0
C8444 csel2 GND 0.17499f
C8445 cs2/n/Y GND -0.10407f
C8446 cl2 GND 1.17161f
C8447 cs2/n/a_162_47# GND 0
C8448 c_1_14/Q GND 0
C8449 c_1_14/QB GND 0
C8450 c_8_8/Q GND 0
C8451 c_8_8/QB GND 0
C8452 c_4_13/Q GND 0
C8453 c_4_13/QB GND 0
C8454 c_4_1/Q GND 0
C8455 c_4_1/QB GND 0
C8456 c_7_12/Q GND 0
C8457 c_7_12/QB GND 0
C8458 c_1_13/Q GND 0
C8459 c_1_13/QB GND 0
C8460 csel1 GND 0.17273f
C8461 cs1/n/Y GND -0.10407f
C8462 cl1 GND 1.17886f
C8463 cs1/n/a_162_47# GND 0
C8464 c_6_4/Q GND 0
C8465 c_6_4/QB GND 0
C8466 c_8_7/Q GND 0
C8467 c_8_7/QB GND 0
C8468 c_4_12/Q GND 0
C8469 c_4_12/QB GND 0
C8470 c_4_0/Q GND 0
C8471 c_4_0/QB GND 0
C8472 c_7_11/Q GND 0
C8473 c_7_11/QB GND 0
C8474 c_6_3/Q GND 0
C8475 c_6_3/QB GND 0
C8476 c_1_12/Q GND 0
C8477 c_1_12/QB GND 0
C8478 csel0 GND 0.36918f
C8479 cs0/n/Y GND -0.10763f
C8480 VDD GND -0.10857p
C8481 cl0 GND 1.21145f
C8482 ch0 GND 1.09471f
C8483 cs0/n/a_162_47# GND 0
C8484 c_8_6/Q GND 0
C8485 c_8_6/QB GND 0
C8486 c_4_11/Q GND 0
C8487 c_4_11/QB GND 0
C8488 c_7_10/Q GND 0
C8489 c_7_10/QB GND 0
C8490 c_1_11/Q GND 0
C8491 c_1_11/QB GND 0
C8492 c_6_2/Q GND 0
C8493 c_6_2/QB GND 0
C8494 c_8_5/Q GND 0
C8495 c_8_5/QB GND 0
C8496 c_4_10/Q GND 0
C8497 c_4_10/QB GND 0
C8498 c_6_1/Q GND 0
C8499 c_6_1/QB GND 0
C8500 c_11_9/Q GND 0
C8501 c_11_9/QB GND 0
C8502 c_1_10/Q GND 0
C8503 c_1_10/QB GND 0
C8504 c_8_4/Q GND 0
C8505 c_8_4/QB GND 0
C8506 c_11_8/Q GND 0
C8507 c_11_8/QB GND 0
C8508 c_14_15/Q GND 0
C8509 c_14_15/QB GND 0
C8510 c_6_0/Q GND 0
C8511 c_6_0/QB GND 0
C8512 c_8_3/Q GND 0
C8513 c_8_3/QB GND 0
C8514 c_11_15/Q GND 0
C8515 c_11_15/QB GND 0
C8516 c_11_7/Q GND 0
C8517 c_11_7/QB GND 0
C8518 c_14_14/Q GND 0
C8519 c_14_14/QB GND 0
C8520 c_1_9/Q GND 0
C8521 c_1_9/QB GND 0
C8522 c_8_2/Q GND 0
C8523 c_8_2/QB GND 0
C8524 c_11_14/Q GND 0
C8525 c_11_14/QB GND 0
C8526 csel15 GND 0.29806f
C8527 cs15/n/Y GND -0.10425f
C8528 cs15/n/a_162_47# GND 0
C8529 c_11_6/Q GND 0
C8530 c_11_6/QB GND 0
C8531 c_14_13/Q GND 0
C8532 c_14_13/QB GND 0
C8533 c_1_8/Q GND 0
C8534 c_1_8/QB GND 0
C8535 c_13_9/Q GND 0
C8536 c_13_9/QB GND 0
C8537 c_8_1/Q GND 0
C8538 c_8_1/QB GND 0
C8539 csel14 GND 0.21181f
C8540 cs14/n/Y GND -0.10407f
C8541 cs14/n/a_162_47# GND 0
C8542 c_11_13/Q GND 0
C8543 c_11_13/QB GND 0
C8544 c_11_5/Q GND 0
C8545 c_11_5/QB GND 0
C8546 c_14_12/Q GND 0
C8547 c_14_12/QB GND 0
C8548 c_1_7/Q GND 0
C8549 c_1_7/QB GND 0
C8550 c_8_0/Q GND 0
C8551 c_8_0/QB GND 0
C8552 c_13_8/Q GND 0
C8553 c_13_8/QB GND 0
C8554 c_11_12/Q GND 0
C8555 c_11_12/QB GND 0
C8556 blb15 GND -0.43822f
C8557 bl15 GND -2.89985f
C8558 csel13 GND 0.20955f
C8559 cs13/n/Y GND -0.10407f
C8560 cs13/n/a_162_47# GND 0
C8561 c_11_4/Q GND 0
C8562 c_11_4/QB GND 0
C8563 c_14_11/Q GND 0
C8564 c_14_11/QB GND 0
C8565 c_1_6/Q GND 0
C8566 c_1_6/QB GND 0
C8567 c_13_7/Q GND 0
C8568 c_13_7/QB GND 0
C8569 c_3_9/Q GND 0
C8570 c_3_9/QB GND 0
C8571 c_9_15/Q GND 0
C8572 c_9_15/QB GND 0
C8573 blb14 GND -2.90183f
C8574 bl14 GND -2.89985f
C8575 c_11_11/Q GND 0
C8576 c_11_11/QB GND 0
C8577 csel12 GND 0.21485f
C8578 cs12/n/Y GND -0.10407f
C8579 ch3 GND 0.87015f
C8580 cs12/n/a_162_47# GND 0
C8581 c_11_3/Q GND 0
C8582 c_11_3/QB GND 0
C8583 c_14_10/Q GND 0
C8584 c_14_10/QB GND 0
C8585 c_3_8/Q GND 0
C8586 c_3_8/QB GND 0
C8587 c_1_5/Q GND 0
C8588 c_1_5/QB GND 0
C8589 c_6_15/Q GND 0
C8590 c_6_15/QB GND 0
C8591 c_13_6/Q GND 0
C8592 c_13_6/QB GND 0
C8593 c_15_9/Q GND 0
C8594 c_15_9/QB GND 0
C8595 c_9_14/Q GND 0
C8596 c_9_14/QB GND 0
C8597 c_11_10/Q GND 0
C8598 c_11_10/QB GND 0
C8599 blb13 GND -2.90206f
C8600 bl13 GND -2.89985f
C8601 csel11 GND 0.2018f
C8602 cs11/n/Y GND -0.10407f
C8603 cs11/n/a_162_47# GND 0
C8604 c_3_15/Q GND 0
C8605 c_3_15/QB GND 0
C8606 c_1_4/Q GND 0
C8607 c_1_4/QB GND 0
C8608 c_6_14/Q GND 0
C8609 c_6_14/QB GND 0
C8610 c_11_2/Q GND 0
C8611 c_11_2/QB GND 0
C8612 c_13_5/Q GND 0
C8613 c_13_5/QB GND 0
C8614 c_3_7/Q GND 0
C8615 c_3_7/QB GND 0
C8616 c_9_13/Q GND 0
C8617 c_9_13/QB GND 0
C8618 c_15_8/Q GND 0
C8619 c_15_8/QB GND 0
C8620 c_0_15/Q GND 0
C8621 c_0_15/QB GND 0
C8622 blb12 GND -2.90235f
C8623 bl12 GND -2.89985f
C8624 csel10 GND 0.19954f
C8625 cs10/n/Y GND -0.10407f
C8626 cs10/n/a_162_47# GND 0
C8627 c_3_14/Q GND 0
C8628 c_3_14/QB GND 0
C8629 c_11_1/Q GND 0
C8630 c_11_1/QB GND 0
.ends
