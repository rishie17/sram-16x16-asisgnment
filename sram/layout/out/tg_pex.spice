* NGSPICE file created from tg.ext - technology: sky130A

.subckt tg A B GN GP VDD GND
X0 B GN A VSUBS sky130_fd_pr__nfet_01v8 ad=0.4578 pd=3.02 as=0.2394 ps=1.98 w=0.42 l=0.15
X1 B GP A w_0_481# sky130_fd_pr__pfet_01v8 ad=0.2394 pd=1.98 as=0.4578 ps=3.02 w=0.42 l=0.15
C0 VDD GP 0.00717f
C1 VDD w_0_481# 0.03231f
C2 A GND 0.01491f
C3 GP A 0.00829f
C4 GN GND 0.00745f
C5 B VDD 0.01491f
C6 w_0_481# A 0.0123f
C7 GN w_0_481# 0.00258f
C8 B A 0.03146f
C9 GP GND 0.00202f
C10 w_0_481# GND 0.0031f
C11 B GN 0.00669f
C12 GP w_0_481# 0.03758f
C13 B GND 0.01781f
C14 B GP 0.0201f
C15 VDD A 0.01781f
C16 B w_0_481# 0.01217f
C17 VDD GN 0.00121f
C18 VDD GND 0.01581f
C19 GN A 0.01569f
C20 GND VSUBS 0.17277f
C21 VDD VSUBS 0.14358f
C22 B VSUBS 0.29365f
C23 A VSUBS 0.29383f
C24 w_0_481# VSUBS 0.30915f
.ends
