* NGSPICE file created from colmux.ext - technology: sky130A

.subckt colmux BL DL BLB DLB CSEL
X0 DL CSEL BL VSUBS sky130_fd_pr__nfet_01v8 ad=0.3696 pd=2.56 as=0.3696 ps=2.56 w=0.84 l=0.15
X1 BLB CSEL DLB VSUBS sky130_fd_pr__nfet_01v8 ad=0.3696 pd=2.56 as=0.3696 ps=2.56 w=0.84 l=0.15
C0 CSEL BLB 0.01148f
C1 DLB BLB 0.03023f
C2 DL BLB 0.00206f
C3 BL BLB 0.01491f
C4 DLB CSEL 0.00742f
C5 CSEL DL 0.00742f
C6 BL CSEL 0.01148f
C7 DLB DL 0.00952f
C8 BL DLB 0.00206f
C9 BL DL 0.03023f
C10 BLB VSUBS 0.1624f
C11 DLB VSUBS 0.04371f
C12 DL VSUBS 0.2436f
C13 BL VSUBS 0.36229f
.ends
