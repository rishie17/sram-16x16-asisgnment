* NGSPICE file created from bondpad.ext - technology: sky130A

.subckt bondpad PAD
C0 PAD VSUBS 32.076f
.ends
