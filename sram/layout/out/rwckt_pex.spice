* NGSPICE file created from rwckt.ext - technology: sky130A

.subckt rw_pre PCB DL DLB VDD GND PCB_uq0 w_0_313# VSUBS
X0 DLB PCB_uq0 VDD w_0_313# sky130_fd_pr__pfet_01v8 ad=0.693 pd=3.62 as=0.4851 ps=2.03 w=1.26 l=0.15
X1 VDD PCB DL w_0_313# sky130_fd_pr__pfet_01v8 ad=0.4851 pd=2.03 as=0.693 ps=3.62 w=1.26 l=0.15
C0 GND DLB 0.00413f
C1 GND w_0_313# 0.00729f
C2 PCB_uq0 GND 0.00322f
C3 DL w_0_313# 0.00582f
C4 VDD DLB 0.02627f
C5 w_0_313# VDD 0.06011f
C6 PCB_uq0 VDD 0.01345f
C7 PCB GND 0.00322f
C8 w_0_313# DLB 0.00582f
C9 PCB_uq0 DLB 0.00242f
C10 PCB_uq0 w_0_313# 0.04071f
C11 PCB DL 0.00242f
C12 PCB VDD 0.01345f
C13 GND DL 0.00413f
C14 GND VDD 0.02398f
C15 PCB w_0_313# 0.04071f
C16 PCB PCB_uq0 0.01263f
C17 DL VDD 0.02627f
C18 GND VSUBS 0.19932f
C19 DLB VSUBS 0.06607f
C20 VDD VSUBS 0.28325f
C21 DL VSUBS 0.06607f
C22 w_0_313# VSUBS 0.6217f
.ends

.subckt rw_sa A Y VDD GND w_0_313# VSUBS
X0 Y A GND VSUBS sky130_fd_pr__nfet_01v8 ad=0.231 pd=1.94 as=0.231 ps=1.94 w=0.42 l=0.15
X1 Y A VDD w_0_313# sky130_fd_pr__pfet_01v8 ad=0.693 pd=3.62 as=0.693 ps=3.62 w=1.26 l=0.15
C0 VDD GND 0.01672f
C1 A VDD 0.0124f
C2 Y GND 0.02835f
C3 A Y 0.03f
C4 A GND 0.01238f
C5 w_0_313# VDD 0.04241f
C6 w_0_313# Y 0.01763f
C7 w_0_313# GND 0.00599f
C8 w_0_313# A 0.03709f
C9 VDD Y 0.04423f
C10 GND VSUBS 0.27922f
C11 Y VSUBS 0.27449f
C12 VDD VSUBS 0.15048f
C13 w_0_313# VSUBS 0.40256f
.ends

.subckt rw_wr WE DINB DIN DL DLB VDD GND WE_uq0 a_552_47# a_184_47# VSUBS
X0 GND DINB a_184_47# VSUBS sky130_fd_pr__nfet_01v8 ad=0.6468 pd=2.45 as=0.6468 ps=2.45 w=1.68 l=0.15
X1 a_184_47# WE DL VSUBS sky130_fd_pr__nfet_01v8 ad=0.6468 pd=2.45 as=0.924 ps=4.46 w=1.68 l=0.15
X2 a_552_47# DIN GND VSUBS sky130_fd_pr__nfet_01v8 ad=0.6468 pd=2.45 as=0.6468 ps=2.45 w=1.68 l=0.15
X3 DLB WE_uq0 a_552_47# VSUBS sky130_fd_pr__nfet_01v8 ad=0.924 pd=4.46 as=0.6468 ps=2.45 w=1.68 l=0.15
C0 GND VDD 0.04012f
C1 VDD DIN 0.00534f
C2 a_552_47# VDD 0.00909f
C3 WE_uq0 GND 0.00878f
C4 WE_uq0 DIN 0.01263f
C5 DL VDD 0.00648f
C6 a_552_47# WE_uq0 0
C7 WE GND 0.00878f
C8 GND DINB 0.01497f
C9 DINB DIN 0.01263f
C10 WE DL 0.00245f
C11 DL DINB 0
C12 VDD DLB 0.00648f
C13 WE_uq0 DLB 0.00245f
C14 a_184_47# VDD 0.00909f
C15 GND DIN 0.01497f
C16 a_552_47# GND 0.03091f
C17 a_552_47# DIN 0
C18 DL GND 0.02013f
C19 a_184_47# WE 0
C20 a_184_47# DINB 0
C21 WE_uq0 VDD 0.00534f
C22 WE VDD 0.00534f
C23 VDD DINB 0.00534f
C24 GND DLB 0.02013f
C25 DLB DIN 0
C26 a_552_47# DLB 0.00465f
C27 a_184_47# GND 0.03091f
C28 a_184_47# DL 0.00465f
C29 WE DINB 0.01263f
C30 VDD VSUBS 0.31272f
C31 DLB VSUBS 0.08832f
C32 GND VSUBS 0.45031f
C33 DL VSUBS 0.08832f
C34 a_552_47# VSUBS 0.11864f
C35 a_184_47# VSUBS 0.11864f
.ends

.subckt rw_eq PCB DL DLB VDD GND w_0_468# VSUBS
X0 DLB PCB DL w_0_468# sky130_fd_pr__pfet_01v8 ad=0.231 pd=1.94 as=0.231 ps=1.94 w=0.42 l=0.15
C0 DLB GND 0.00102f
C1 GND w_0_468# 0.00316f
C2 PCB DLB 0.00309f
C3 PCB w_0_468# 0.04842f
C4 DL GND 0.00102f
C5 PCB DL 0.00309f
C6 GND VDD 0.01188f
C7 PCB VDD 0.00719f
C8 DLB w_0_468# 0.0077f
C9 DL DLB 0.01138f
C10 DL w_0_468# 0.0077f
C11 PCB GND 0.00124f
C12 DLB VDD 0.00958f
C13 VDD w_0_468# 0.02605f
C14 DL VDD 0.00958f
C15 GND VSUBS 0.14962f
C16 VDD VSUBS 0.12119f
C17 DLB VSUBS 0.07969f
C18 DL VSUBS 0.07969f
C19 w_0_468# VSUBS 0.24539f
.ends

.subckt rwckt DIN DINB RD DL DLB WE PCB VDD GND
Xp PCB DL DLB VDD GND PCB VDD GND rw_pre
Xs DL RD VDD GND VDD GND rw_sa
Xw WE DINB DIN DL DLB VDD GND WE w/a_552_47# w/a_184_47# GND rw_wr
Xe PCB DL DLB VDD GND VDD GND rw_eq
C0 PCB w/a_552_47# 0.00169f
C1 w/a_184_47# DL 0.01527f
C2 PCB DLB 0.29867f
C3 DIN DLB 0.00127f
C4 w/a_184_47# VDD -0.001f
C5 PCB DIN 0
C6 RD WE 0
C7 DL RD 0.01803f
C8 DL WE 0.23722f
C9 DLB w/a_184_47# 0.0024f
C10 RD VDD 0.02243f
C11 WE VDD 0.03128f
C12 PCB w/a_184_47# 0
C13 DINB WE 0.01284f
C14 w/a_552_47# RD 0
C15 w/a_552_47# WE 0.02466f
C16 DL VDD 0.10028f
C17 DL DINB 0.00364f
C18 DLB RD 0.01469f
C19 DLB WE 0.08057f
C20 w/a_552_47# DL 0.01187f
C21 PCB RD 0.00653f
C22 PCB WE 0.00708f
C23 DIN WE 0.01284f
C24 w/a_552_47# VDD -0.001f
C25 DLB DL 0.27915f
C26 DIN DL 0.00316f
C27 PCB DL 0.34591f
C28 DLB VDD 0.15662f
C29 PCB VDD 0.06233f
C30 DLB DINB 0
C31 PCB DINB 0
C32 w/a_184_47# WE 0.02466f
C33 DLB w/a_552_47# 0.00545f
C34 DLB GND 0.34424f
C35 PCB GND 0.14841f
C36 DIN GND 0
C37 DINB GND 0
C38 WE GND 0.29255f
C39 w/a_552_47# GND 0
C40 VDD GND -0.33274f
C41 RD GND -0.04109f
C42 DL GND 1.03643f
.ends
