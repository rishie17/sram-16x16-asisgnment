* NGSPICE file created from rw_pre.ext - technology: sky130A

.subckt rw_pre PCB DL DLB VDD GND PCB_uq0
X0 DLB PCB_uq0 VDD w_0_313# sky130_fd_pr__pfet_01v8 ad=0.693 pd=3.62 as=0.4851 ps=2.03 w=1.26 l=0.15
X1 VDD PCB DL w_0_313# sky130_fd_pr__pfet_01v8 ad=0.4851 pd=2.03 as=0.693 ps=3.62 w=1.26 l=0.15
C0 PCB PCB_uq0 0.01263f
C1 DLB VDD 0.02627f
C2 VDD DL 0.02627f
C3 PCB GND 0.00322f
C4 PCB_uq0 w_0_313# 0.04071f
C5 PCB VDD 0.01345f
C6 PCB DL 0.00242f
C7 GND w_0_313# 0.00729f
C8 w_0_313# VDD 0.06011f
C9 PCB_uq0 GND 0.00322f
C10 w_0_313# DLB 0.00582f
C11 w_0_313# DL 0.00582f
C12 PCB_uq0 VDD 0.01345f
C13 PCB_uq0 DLB 0.00242f
C14 PCB w_0_313# 0.04071f
C15 GND VDD 0.02398f
C16 GND DLB 0.00413f
C17 GND DL 0.00413f
C18 GND VSUBS 0.19932f
C19 DLB VSUBS 0.06607f
C20 VDD VSUBS 0.28325f
C21 DL VSUBS 0.06607f
C22 w_0_313# VSUBS 0.6217f
.ends
