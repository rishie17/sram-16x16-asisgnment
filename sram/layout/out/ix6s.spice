* NGSPICE file created from ix6s.ext - technology: sky130A

.subckt ix6s A Y VDD GND
X0 VDD A Y w_0_397# sky130_fd_pr__pfet_01v8 ad=0.231 pd=1.39 as=0.231 ps=1.39 w=0.84 l=0.15
X1 GND A Y VSUBS sky130_fd_pr__nfet_01v8 ad=0.1848 pd=1.72 as=0.1155 ps=0.97 w=0.42 l=0.15
X2 GND A Y VSUBS sky130_fd_pr__nfet_01v8 ad=0.1155 pd=0.97 as=0.1155 ps=0.97 w=0.42 l=0.15
X3 GND A Y VSUBS sky130_fd_pr__nfet_01v8 ad=0.1155 pd=0.97 as=0.1155 ps=0.97 w=0.42 l=0.15
X4 Y A VDD w_0_397# sky130_fd_pr__pfet_01v8 ad=0.231 pd=1.39 as=0.231 ps=1.39 w=0.84 l=0.15
X5 VDD A Y w_0_397# sky130_fd_pr__pfet_01v8 ad=0.231 pd=1.39 as=0.231 ps=1.39 w=0.84 l=0.15
X6 VDD A Y w_0_397# sky130_fd_pr__pfet_01v8 ad=0.3696 pd=2.56 as=0.231 ps=1.39 w=0.84 l=0.15
X7 Y A GND VSUBS sky130_fd_pr__nfet_01v8 ad=0.1155 pd=0.97 as=0.1155 ps=0.97 w=0.42 l=0.15
X8 Y A VDD w_0_397# sky130_fd_pr__pfet_01v8 ad=0.231 pd=1.39 as=0.231 ps=1.39 w=0.84 l=0.15
X9 Y A VDD w_0_397# sky130_fd_pr__pfet_01v8 ad=0.231 pd=1.39 as=0.3696 ps=2.56 w=0.84 l=0.15
X10 Y A GND VSUBS sky130_fd_pr__nfet_01v8 ad=0.1155 pd=0.97 as=0.1155 ps=0.97 w=0.42 l=0.15
X11 Y A GND VSUBS sky130_fd_pr__nfet_01v8 ad=0.1155 pd=0.97 as=0.1848 ps=1.72 w=0.42 l=0.15
.ends
