* NGSPICE file created from lv_sdff.ext - technology: sky130A

.subckt tg A B GN GP VDD GND w_0_481# VSUBS
X0 B GN A VSUBS sky130_fd_pr__nfet_01v8 ad=0.4578 pd=3.02 as=0.2394 ps=1.98 w=0.42 l=0.15
X1 B GP A w_0_481# sky130_fd_pr__pfet_01v8 ad=0.2394 pd=1.98 as=0.4578 ps=3.02 w=0.42 l=0.15
C0 VDD GND 0.01581f
C1 GN GND 0.00745f
C2 GN VDD 0.00121f
C3 GND B 0.01781f
C4 VDD B 0.01491f
C5 GND A 0.01491f
C6 VDD A 0.01781f
C7 GN B 0.00669f
C8 GND GP 0.00202f
C9 VDD GP 0.00717f
C10 GN A 0.01569f
C11 GND w_0_481# 0.0031f
C12 VDD w_0_481# 0.03231f
C13 GN w_0_481# 0.00258f
C14 A B 0.03146f
C15 GP B 0.0201f
C16 GP A 0.00829f
C17 w_0_481# B 0.01217f
C18 w_0_481# A 0.0123f
C19 w_0_481# GP 0.03758f
C20 GND VSUBS 0.17277f
C21 VDD VSUBS 0.14358f
C22 B VSUBS 0.29365f
C23 A VSUBS 0.29383f
C24 w_0_481# VSUBS 0.30915f
.ends

.subckt inv_s1 A Y VDD GND w_0_313# VSUBS
X0 Y A GND VSUBS sky130_fd_pr__nfet_01v8 ad=0.3465 pd=2.36 as=0.3465 ps=2.36 w=0.63 l=0.15
X1 Y A VDD w_0_313# sky130_fd_pr__pfet_01v8 ad=0.693 pd=3.62 as=0.693 ps=3.62 w=1.26 l=0.15
C0 Y GND 0.03184f
C1 GND VDD 0.01759f
C2 GND A 0.01221f
C3 Y VDD 0.0445f
C4 GND w_0_313# 0.00599f
C5 Y A 0.02936f
C6 Y w_0_313# 0.01763f
C7 A VDD 0.01248f
C8 w_0_313# VDD 0.04241f
C9 w_0_313# A 0.0382f
C10 GND VSUBS 0.26227f
C11 Y VSUBS 0.25552f
C12 VDD VSUBS 0.14929f
C13 w_0_313# VSUBS 0.40256f
.ends

.subckt inv_ff A Y VDD GND w_0_397# VSUBS
X0 Y A GND VSUBS sky130_fd_pr__nfet_01v8 ad=0.231 pd=1.94 as=0.231 ps=1.94 w=0.42 l=0.15
X1 Y A VDD w_0_397# sky130_fd_pr__pfet_01v8 ad=0.462 pd=2.78 as=0.462 ps=2.78 w=0.84 l=0.15
C0 Y GND 0.02713f
C1 GND VDD 0.01425f
C2 Y VDD 0.03866f
C3 GND A 0.01196f
C4 Y A 0.03133f
C5 GND w_0_397# 0.00415f
C6 Y w_0_397# 0.01488f
C7 A VDD 0.01246f
C8 w_0_397# VDD 0.04107f
C9 w_0_397# A 0.03521f
C10 GND VSUBS 0.31212f
C11 Y VSUBS 0.31548f
C12 VDD VSUBS 0.15626f
C13 w_0_397# VSUBS 0.31738f
.ends

.subckt inv_s2 A Y VDD GND w_0_397# VSUBS
X0 Y A GND VSUBS sky130_fd_pr__nfet_01v8 ad=0.2688 pd=2.12 as=0.2688 ps=2.12 w=0.42 l=0.15
X1 Y A VDD w_0_397# sky130_fd_pr__pfet_01v8 ad=0.5376 pd=2.96 as=0.5376 ps=2.96 w=0.84 l=0.15
C0 Y GND 0.02796f
C1 GND VDD 0.01608f
C2 GND A 0.0115f
C3 Y VDD 0.03977f
C4 GND w_0_397# 0.00441f
C5 Y A 0.02658f
C6 Y w_0_397# 0.01549f
C7 A VDD 0.01186f
C8 w_0_397# VDD 0.04447f
C9 w_0_397# A 0.03626f
C10 GND VSUBS 0.32328f
C11 Y VSUBS 0.31422f
C12 VDD VSUBS 0.16419f
C13 w_0_397# VSUBS 0.35119f
.ends

.subckt sdff D CLK Q QB VDD GND t2/A ci/Y t3/A t2/B t4/GP t4/B t4/w_0_481# VSUBS
Xt1 D t2/B ci/Y t4/GP VDD GND t4/w_0_481# VSUBS tg
Xs1 t4/B Q VDD GND t4/w_0_481# VSUBS inv_s1
Xt2 t2/A t2/B t4/GP ci/Y VDD GND t4/w_0_481# VSUBS tg
Xci CLK ci/Y VDD GND t4/w_0_481# VSUBS inv_ff
Xs2 Q QB VDD GND t4/w_0_481# VSUBS inv_s2
Xt3 t3/A t4/B t4/GP ci/Y VDD GND t4/w_0_481# VSUBS tg
Xt4 QB t4/B ci/Y t4/GP VDD GND t4/w_0_481# VSUBS tg
Xm1 t2/B t3/A VDD GND t4/w_0_481# VSUBS inv_ff
Xm2 t3/A t2/A VDD GND t4/w_0_481# VSUBS inv_ff
Xci2 ci/Y t4/GP VDD GND t4/w_0_481# VSUBS inv_ff
C0 t4/GP GND 0.0766f
C1 t3/A t2/B 0.43417f
C2 t2/B VDD 0.04746f
C3 t4/GP ci/Y 1.1467f
C4 t4/GP t4/B 0.44337f
C5 t2/B CLK 0
C6 t2/B t4/w_0_481# 0.02293f
C7 t4/GP t2/A 0.02302f
C8 t3/A D 0.00277f
C9 D VDD 0.00199f
C10 Q QB 0.07273f
C11 D t4/w_0_481# 0.00492f
C12 t4/GP t3/A 0.10169f
C13 t4/GP VDD 0.05068f
C14 t4/GP CLK 0
C15 t2/B D 0.00132f
C16 Q GND 0.02098f
C17 t4/GP t4/w_0_481# 0.05017f
C18 GND QB 0.00478f
C19 Q ci/Y 0.02462f
C20 Q t4/B 0.08298f
C21 ci/Y QB 0.03505f
C22 QB t4/B 0.13468f
C23 t4/GP t2/B 0.44783f
C24 ci/Y GND 0.37141f
C25 Q t2/A 0.00186f
C26 GND t4/B 0.0356f
C27 t2/A QB 0
C28 ci/Y t4/B 0.10363f
C29 t2/A GND 0.00513f
C30 t2/A ci/Y 0.02764f
C31 t2/A t4/B 0
C32 t4/GP D 0.07483f
C33 t3/A Q 0.00441f
C34 Q VDD 0.09077f
C35 t3/A QB 0.00626f
C36 VDD QB 0.03157f
C37 Q t4/w_0_481# 0.03837f
C38 t4/w_0_481# QB 0.03183f
C39 t2/B Q 0
C40 t3/A GND 0.02131f
C41 VDD GND -0.0601f
C42 t2/B QB 0
C43 t3/A ci/Y 0.08054f
C44 CLK GND 0
C45 VDD ci/Y 0.06848f
C46 t3/A t4/B 0.01039f
C47 VDD t4/B 0.07493f
C48 CLK ci/Y 0.01684f
C49 t4/w_0_481# GND -0.0075f
C50 t4/w_0_481# ci/Y 0.05475f
C51 t4/w_0_481# t4/B 0.03404f
C52 t2/B GND 0.03114f
C53 t2/B ci/Y 0.1398f
C54 t3/A t2/A 0.07388f
C55 t2/B t4/B 0.00575f
C56 VDD t2/A 0.02877f
C57 t4/w_0_481# t2/A 0.02174f
C58 t2/B t2/A 0.01509f
C59 t4/GP Q 0.02398f
C60 t3/A VDD 0.10931f
C61 t4/GP QB 0.04899f
C62 D GND -0
C63 t3/A CLK 0
C64 CLK VDD 0
C65 D ci/Y 0.02359f
C66 t3/A t4/w_0_481# 0.06077f
C67 t4/w_0_481# VDD 0.05195f
C68 t4/w_0_481# CLK 0.00275f
C69 t4/GP VSUBS 0.31478f
C70 t2/A VSUBS -0.20785f
C71 t3/A VSUBS 0.0681f
C72 t4/B VSUBS 0.24318f
C73 QB VSUBS -0.06744f
C74 GND VSUBS -0.40661f
C75 ci/Y VSUBS 0.99901f
C76 VDD VSUBS -0.51915f
C77 CLK VSUBS -0.02159f
C78 t4/w_0_481# VSUBS 0
C79 Q VSUBS -0.10104f
C80 t2/B VSUBS -0
C81 D VSUBS -0.08626f
.ends

.subckt lv_sdff D CLK Q QB VDD GND
Xu D CLK Q QB VDD GND u/t2/A u/ci/Y u/t3/A u/t2/B u/t4/GP u/t4/B VDD GND sdff
C0 VDD u/t2/B 0
C1 VDD u/ci/Y 0.00849f
C2 u/t2/A VDD 0
C3 u/t3/A VDD 0
C4 u/t4/GP VDD 0
C5 VDD CLK 0.00212f
C6 VDD u/t4/B 0
C7 D VDD -0
C8 u/t4/GP GND -0.5516f
C9 u/t2/A GND -0.34867f
C10 u/t3/A GND -0.52434f
C11 u/t4/B GND -0.35527f
C12 QB GND -0.36764f
C13 u/ci/Y GND -0.75824f
C14 VDD GND -0.72723f
C15 CLK GND -0.04866f
C16 Q GND -0.35448f
C17 u/t2/B GND -0.39628f
C18 D GND -0.10819f
.ends
