* NGSPICE file created from rw_eq.ext - technology: sky130A

.subckt rw_eq PCB DL DLB VDD GND
X0 DLB PCB DL w_0_468# sky130_fd_pr__pfet_01v8 ad=0.231 pd=1.94 as=0.231 ps=1.94 w=0.42 l=0.15
C0 w_0_468# GND 0.00316f
C1 w_0_468# DLB 0.0077f
C2 PCB w_0_468# 0.04842f
C3 w_0_468# DL 0.0077f
C4 GND DLB 0.00102f
C5 PCB GND 0.00124f
C6 GND DL 0.00102f
C7 w_0_468# VDD 0.02605f
C8 PCB DLB 0.00309f
C9 DLB DL 0.01138f
C10 PCB DL 0.00309f
C11 GND VDD 0.01188f
C12 DLB VDD 0.00958f
C13 PCB VDD 0.00719f
C14 DL VDD 0.00958f
C15 GND VSUBS 0.14962f
C16 VDD VSUBS 0.12119f
C17 DLB VSUBS 0.07969f
C18 DL VSUBS 0.07969f
C19 w_0_468# VSUBS 0.24539f
.ends
