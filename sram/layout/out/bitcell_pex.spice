* NGSPICE file created from bitcell.ext - technology: sky130A

.subckt bitcell BL BLB WL VDD GND Q QB
X0 QB Q VDD VDD sky130_fd_pr__pfet_01v8 ad=0.1848 pd=1.72 as=0.1155 ps=0.97 w=0.42 l=0.15
X1 VDD QB Q VDD sky130_fd_pr__pfet_01v8 ad=0.1155 pd=0.97 as=0.1848 ps=1.72 w=0.42 l=0.15
X2 GND QB Q GND sky130_fd_pr__nfet_01v8 ad=0.17325 pd=1.18 as=0.14437 ps=1.18 w=0.63 l=0.15
X3 Q WL BL GND sky130_fd_pr__nfet_01v8 ad=0.14437 pd=1.18 as=0.1848 ps=1.72 w=0.42 l=0.15
X4 QB Q GND GND sky130_fd_pr__nfet_01v8 ad=0.14437 pd=1.18 as=0.17325 ps=1.18 w=0.63 l=0.15
X5 BLB WL QB GND sky130_fd_pr__nfet_01v8 ad=0.1848 pd=1.72 as=0.14437 ps=1.18 w=0.42 l=0.15
C0 Q QB 0.14815f
C1 QB BLB 0.0343f
C2 Q BLB 0.01314f
C3 VDD QB 0.1111f
C4 BL QB 0.01314f
C5 Q VDD 0.08548f
C6 BL Q 0.0343f
C7 VDD BLB 0.06361f
C8 BL BLB 0.03241f
C9 QB WL 0.01626f
C10 Q WL 0.01804f
C11 BL VDD 0.06361f
C12 WL BLB 0.01664f
C13 VDD WL 0.01593f
C14 BL WL 0.01664f
C15 BLB GND 0.26233f
C16 BL GND 0.54984f
C17 QB GND 0.246f
C18 VDD GND 1.10678f
.ends
