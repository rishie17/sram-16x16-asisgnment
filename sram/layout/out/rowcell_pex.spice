* NGSPICE file created from rowcell.ext - technology: sky130A

.subckt nand3 A B C Y VDD GND a_162_47# w_0_397# a_302_47# VSUBS
X0 a_302_47# B a_162_47# VSUBS sky130_fd_pr__nfet_01v8 ad=0.3465 pd=1.81 as=0.3465 ps=1.81 w=1.26 l=0.15
X1 VDD C Y w_0_397# sky130_fd_pr__pfet_01v8 ad=0.3696 pd=2.56 as=0.231 ps=1.39 w=0.84 l=0.15
X2 Y B VDD w_0_397# sky130_fd_pr__pfet_01v8 ad=0.231 pd=1.39 as=0.231 ps=1.39 w=0.84 l=0.15
X3 VDD A Y w_0_397# sky130_fd_pr__pfet_01v8 ad=0.231 pd=1.39 as=0.3696 ps=2.56 w=0.84 l=0.15
X4 GND C a_302_47# VSUBS sky130_fd_pr__nfet_01v8 ad=0.5544 pd=3.4 as=0.3465 ps=1.81 w=1.26 l=0.15
X5 a_162_47# A Y VSUBS sky130_fd_pr__nfet_01v8 ad=0.3465 pd=1.81 as=0.5544 ps=3.4 w=1.26 l=0.15
C0 A Y 0.04495f
C1 B C 0.02319f
C2 B GND 0.00842f
C3 B w_0_397# 0.03593f
C4 B A 0.02319f
C5 GND C 0.01221f
C6 C w_0_397# 0.0369f
C7 GND w_0_397# 0.00518f
C8 A GND 0.00781f
C9 A w_0_397# 0.0369f
C10 Y a_162_47# 0.02045f
C11 B a_162_47# 0
C12 VDD Y 0.1587f
C13 Y a_302_47# 0.01336f
C14 GND a_162_47# 0.01252f
C15 B VDD 0.00947f
C16 B a_302_47# 0
C17 A a_162_47# 0
C18 VDD C 0.01435f
C19 VDD GND 0.01702f
C20 C a_302_47# 0
C21 VDD w_0_397# 0.06869f
C22 GND a_302_47# 0.0149f
C23 A VDD 0.00885f
C24 VDD a_162_47# 0.00174f
C25 B Y 0.01759f
C26 VDD a_302_47# 0
C27 Y C 0.00565f
C28 Y GND 0.03698f
C29 Y w_0_397# 0.02347f
C30 GND VSUBS 0.23601f
C31 VDD VSUBS 0.31826f
C32 Y VSUBS 0.28163f
C33 a_302_47# VSUBS 0.04262f
C34 a_162_47# VSUBS 0.04262f
C35 w_0_397# VSUBS 0.53899f
.ends

.subckt wldrv A Y VDD GND w_0_397# VSUBS
X0 GND A Y VSUBS sky130_fd_pr__nfet_01v8 ad=0.1848 pd=1.72 as=0.1155 ps=0.97 w=0.42 l=0.15
X1 VDD A Y w_0_397# sky130_fd_pr__pfet_01v8 ad=0.3696 pd=2.56 as=0.231 ps=1.39 w=0.84 l=0.15
X2 Y A VDD w_0_397# sky130_fd_pr__pfet_01v8 ad=0.231 pd=1.39 as=0.3696 ps=2.56 w=0.84 l=0.15
X3 Y A GND VSUBS sky130_fd_pr__nfet_01v8 ad=0.1155 pd=0.97 as=0.1848 ps=1.72 w=0.42 l=0.15
C0 w_0_397# Y 0.01491f
C1 A VDD 0.02761f
C2 A w_0_397# 0.06983f
C3 w_0_397# VDD 0.05909f
C4 GND Y 0.0384f
C5 A GND 0.02569f
C6 GND VDD 0.02086f
C7 w_0_397# GND 0.00487f
C8 A Y 0.0755f
C9 Y VDD 0.05869f
C10 GND VSUBS 0.45666f
C11 Y VSUBS 0.35858f
C12 VDD VSUBS 0.20319f
C13 w_0_397# VSUBS 0.40753f
.ends

.subckt rowslice A B C WL VDD wd/A n3/a_162_47# n3/a_302_47# GND
Xn3 A B C wd/A VDD GND n3/a_162_47# VDD n3/a_302_47# GND nand3
Xwd wd/A WL VDD GND VDD GND wldrv
C0 A VDD 0.00264f
C1 VDD C 0.00228f
C2 n3/a_162_47# WL 0
C3 n3/a_162_47# wd/A 0.00239f
C4 VDD WL 0.00661f
C5 A WL 0
C6 C WL 0.00383f
C7 VDD wd/A 0.07387f
C8 A wd/A 0.00356f
C9 C wd/A 0.03002f
C10 n3/a_302_47# VDD -0
C11 B WL 0
C12 wd/A WL 0.01639f
C13 B wd/A 0.01097f
C14 n3/a_302_47# WL 0.00166f
C15 n3/a_302_47# wd/A 0.00778f
C16 WL GND -0.03926f
C17 wd/A GND 0.07188f
C18 C GND -0.02255f
C19 B GND 0
C20 A GND -0.00172f
C21 n3/a_302_47# GND -0
C22 VDD GND -0.24458f
.ends

.subckt rowcell A B C WL VDD GND
Xs A B C WL VDD s/wd/A s/n3/a_162_47# s/n3/a_302_47# GND rowslice
C0 WL s/n3/a_302_47# 0.00115f
C1 WL A 0
C2 WL B 0
C3 WL s/n3/a_162_47# 0
C4 WL C 0
C5 s/wd/A VDD -0.00139f
C6 WL VDD 0.10856f
C7 WL s/wd/A 0.02538f
C8 WL GND 0.24854f
C9 s/wd/A GND -0.29371f
C10 C GND -0.04429f
C11 B GND -0.0182f
C12 A GND -0.02565f
C13 VDD GND -0.10247f
.ends
