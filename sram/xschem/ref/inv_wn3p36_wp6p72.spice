.subckt inv_wn3p36_wp6p72 a y vdd vss
XXP y a vdd vdd sky130_fd_pr__pfet_01v8 L=0.15 W=6.72 nf=1 m=1
XXN y a vss vss sky130_fd_pr__nfet_01v8 L=0.15 W=3.36 nf=1 m=1
.ends
