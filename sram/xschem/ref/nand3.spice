.subckt nand3 a b c y vdd vss
XXP1 y a vdd vdd sky130_fd_pr__pfet_01v8 L=0.15 W=0.84 nf=1 m=1
XXP2 y b vdd vdd sky130_fd_pr__pfet_01v8 L=0.15 W=0.84 nf=1 m=1
XXP3 y c vdd vdd sky130_fd_pr__pfet_01v8 L=0.15 W=0.84 nf=1 m=1
XXN1 y a n1 vss sky130_fd_pr__nfet_01v8 L=0.15 W=1.26 nf=1 m=1
XXN2 n1 b n2 vss sky130_fd_pr__nfet_01v8 L=0.15 W=1.26 nf=1 m=1
XXN3 n2 c vss vss sky130_fd_pr__nfet_01v8 L=0.15 W=1.26 nf=1 m=1
.ends
