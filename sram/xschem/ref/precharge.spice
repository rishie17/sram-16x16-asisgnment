.subckt precharge bl blb pcb vdd
XXP1 bl pcb vdd vdd sky130_fd_pr__pfet_01v8 L=0.15 W=0.84 nf=1 m=1
XXP2 blb pcb vdd vdd sky130_fd_pr__pfet_01v8 L=0.15 W=0.84 nf=1 m=1
XXP3 bl pcb blb vdd sky130_fd_pr__pfet_01v8 L=0.15 W=0.42 nf=1 m=1
.ends
