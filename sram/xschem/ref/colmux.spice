.subckt colmux bl blb dl dlb csel vss
XXN1 bl csel dl vss sky130_fd_pr__nfet_01v8 L=0.15 W=0.84 nf=1 m=1
XXN2 blb csel dlb vss sky130_fd_pr__nfet_01v8 L=0.15 W=0.84 nf=1 m=1
.ends
