.subckt sram256 CLK ADDR RW DIN DOUT vdd vddio vss
RXpad_CLK_Rbw CLK Xpad_CLK.n1 0.2
LXpad_CLK_Lbw Xpad_CLK.n1 clk_pad 2n
CXpad_CLK_Cpad clk_pad vss 1p
DXpad_CLK_D1 clk_pad vddio desd area=1
DXpad_CLK_D2 vss clk_pad desd area=1
XXib_CLK_X1_XP Xib_CLK.n1 clk_pad vdd vdd sky130_fd_pr__pfet_01v8 L=0.15 W=1.68 nf=1 m=1
XXib_CLK_X1_XN Xib_CLK.n1 clk_pad vss vss sky130_fd_pr__nfet_01v8 L=0.15 W=0.84 nf=1 m=1
XXib_CLK_X2_XP clk_in Xib_CLK.n1 vdd vdd sky130_fd_pr__pfet_01v8 L=0.15 W=3.36 nf=1 m=1
XXib_CLK_X2_XN clk_in Xib_CLK.n1 vss vss sky130_fd_pr__nfet_01v8 L=0.15 W=1.68 nf=1 m=1
RXpad_ADDR_Rbw ADDR Xpad_ADDR.n1 0.2
LXpad_ADDR_Lbw Xpad_ADDR.n1 addr_pad 2n
CXpad_ADDR_Cpad addr_pad vss 1p
DXpad_ADDR_D1 addr_pad vddio desd area=1
DXpad_ADDR_D2 vss addr_pad desd area=1
XXib_ADDR_X1_XP Xib_ADDR.n1 addr_pad vdd vdd sky130_fd_pr__pfet_01v8 L=0.15 W=1.68 nf=1 m=1
XXib_ADDR_X1_XN Xib_ADDR.n1 addr_pad vss vss sky130_fd_pr__nfet_01v8 L=0.15 W=0.84 nf=1 m=1
XXib_ADDR_X2_XP addr_in Xib_ADDR.n1 vdd vdd sky130_fd_pr__pfet_01v8 L=0.15 W=3.36 nf=1 m=1
XXib_ADDR_X2_XN addr_in Xib_ADDR.n1 vss vss sky130_fd_pr__nfet_01v8 L=0.15 W=1.68 nf=1 m=1
RXpad_RW_Rbw RW Xpad_RW.n1 0.2
LXpad_RW_Lbw Xpad_RW.n1 rw_pad 2n
CXpad_RW_Cpad rw_pad vss 1p
DXpad_RW_D1 rw_pad vddio desd area=1
DXpad_RW_D2 vss rw_pad desd area=1
XXib_RW_X1_XP Xib_RW.n1 rw_pad vdd vdd sky130_fd_pr__pfet_01v8 L=0.15 W=1.68 nf=1 m=1
XXib_RW_X1_XN Xib_RW.n1 rw_pad vss vss sky130_fd_pr__nfet_01v8 L=0.15 W=0.84 nf=1 m=1
XXib_RW_X2_XP rw_in Xib_RW.n1 vdd vdd sky130_fd_pr__pfet_01v8 L=0.15 W=3.36 nf=1 m=1
XXib_RW_X2_XN rw_in Xib_RW.n1 vss vss sky130_fd_pr__nfet_01v8 L=0.15 W=1.68 nf=1 m=1
RXpad_DIN_Rbw DIN Xpad_DIN.n1 0.2
LXpad_DIN_Lbw Xpad_DIN.n1 din_pad 2n
CXpad_DIN_Cpad din_pad vss 1p
DXpad_DIN_D1 din_pad vddio desd area=1
DXpad_DIN_D2 vss din_pad desd area=1
XXib_DIN_X1_XP Xib_DIN.n1 din_pad vdd vdd sky130_fd_pr__pfet_01v8 L=0.15 W=1.68 nf=1 m=1
XXib_DIN_X1_XN Xib_DIN.n1 din_pad vss vss sky130_fd_pr__nfet_01v8 L=0.15 W=0.84 nf=1 m=1
XXib_DIN_X2_XP din_in Xib_DIN.n1 vdd vdd sky130_fd_pr__pfet_01v8 L=0.15 W=3.36 nf=1 m=1
XXib_DIN_X2_XN din_in Xib_DIN.n1 vss vss sky130_fd_pr__nfet_01v8 L=0.15 W=1.68 nf=1 m=1
RXpad_DOUT_Rbw DOUT Xpad_DOUT.n1 0.2
LXpad_DOUT_Lbw Xpad_DOUT.n1 dout_pad 2n
CXpad_DOUT_Cpad dout_pad vss 1p
DXpad_DOUT_D1 dout_pad vddio desd area=1
DXpad_DOUT_D2 vss dout_pad desd area=1
XXck_r1_XP ckr_b clk_in vdd vdd sky130_fd_pr__pfet_01v8 L=0.15 W=3.36 nf=1 m=1
XXck_r1_XN ckr_b clk_in vss vss sky130_fd_pr__nfet_01v8 L=0.15 W=1.68 nf=1 m=1
XXck_r2_XP ckr ckr_b vdd vdd sky130_fd_pr__pfet_01v8 L=0.15 W=6.72 nf=1 m=1
XXck_r2_XN ckr ckr_b vss vss sky130_fd_pr__nfet_01v8 L=0.15 W=3.36 nf=1 m=1
XXck_a1_XP cka_b ckr vdd vdd sky130_fd_pr__pfet_01v8 L=0.15 W=1.68 nf=1 m=1
XXck_a1_XN cka_b ckr vss vss sky130_fd_pr__nfet_01v8 L=0.15 W=0.84 nf=1 m=1
XXck_a2_XP clk_ff cka_b vdd vdd sky130_fd_pr__pfet_01v8 L=0.15 W=3.36 nf=1 m=1
XXck_a2_XN clk_ff cka_b vss vss sky130_fd_pr__nfet_01v8 L=0.15 W=1.68 nf=1 m=1
XXck_b1_XP ckb1 ckr vdd vdd sky130_fd_pr__pfet_01v8 L=0.15 W=1.68 nf=1 m=1
XXck_b1_XN ckb1 ckr vss vss sky130_fd_pr__nfet_01v8 L=0.15 W=0.84 nf=1 m=1
XXck_b2_XP ckb2 ckb1 vdd vdd sky130_fd_pr__pfet_01v8 L=0.15 W=2.52 nf=1 m=1
XXck_b2_XN ckb2 ckb1 vss vss sky130_fd_pr__nfet_01v8 L=0.15 W=1.26 nf=1 m=1
XXck_b3_XP clkb ckb2 vdd vdd sky130_fd_pr__pfet_01v8 L=0.15 W=5.04 nf=1 m=1
XXck_b3_XN clkb ckb2 vss vss sky130_fd_pr__nfet_01v8 L=0.15 W=2.52 nf=1 m=1
XXck_d1_XP d1 ckr vdd vdd sky130_fd_pr__pfet_01v8 L=0.15 W=0.84 nf=1 m=1
XXck_d1_XN d1 ckr vss vss sky130_fd_pr__nfet_01v8 L=0.15 W=0.42 nf=1 m=1
XXck_d2_XP d2 d1 vdd vdd sky130_fd_pr__pfet_01v8 L=0.15 W=0.84 nf=1 m=1
XXck_d2_XN d2 d1 vss vss sky130_fd_pr__nfet_01v8 L=0.15 W=0.42 nf=1 m=1
XXck_d3_XP d3 d2 vdd vdd sky130_fd_pr__pfet_01v8 L=0.15 W=0.84 nf=1 m=1
XXck_d3_XN d3 d2 vss vss sky130_fd_pr__nfet_01v8 L=0.15 W=0.42 nf=1 m=1
XXck_d4_XP d4 d3 vdd vdd sky130_fd_pr__pfet_01v8 L=0.15 W=0.84 nf=1 m=1
XXck_d4_XN d4 d3 vss vss sky130_fd_pr__nfet_01v8 L=0.15 W=0.42 nf=1 m=1
XXck_d5_XP d5 d4 vdd vdd sky130_fd_pr__pfet_01v8 L=0.15 W=0.84 nf=1 m=1
XXck_d5_XN d5 d4 vss vss sky130_fd_pr__nfet_01v8 L=0.15 W=0.42 nf=1 m=1
XXck_d6_XP d6 d5 vdd vdd sky130_fd_pr__pfet_01v8 L=0.15 W=0.84 nf=1 m=1
XXck_d6_XN d6 d5 vss vss sky130_fd_pr__nfet_01v8 L=0.15 W=0.42 nf=1 m=1
XXck_d7_XP d7 d6 vdd vdd sky130_fd_pr__pfet_01v8 L=0.15 W=0.84 nf=1 m=1
XXck_d7_XN d7 d6 vss vss sky130_fd_pr__nfet_01v8 L=0.15 W=0.42 nf=1 m=1
XXck_d8_XP ckd d7 vdd vdd sky130_fd_pr__pfet_01v8 L=0.15 W=0.84 nf=1 m=1
XXck_d8_XN ckd d7 vss vss sky130_fd_pr__nfet_01v8 L=0.15 W=0.42 nf=1 m=1
XXck_c1_XP1 pc0 ckr vdd vdd sky130_fd_pr__pfet_01v8 L=0.15 W=1.68 nf=1 m=1
XXck_c1_XP2 pc0 ckd vdd vdd sky130_fd_pr__pfet_01v8 L=0.15 W=1.68 nf=1 m=1
XXck_c1_XN1 pc0 ckr Xck_c1.n1 vss sky130_fd_pr__nfet_01v8 L=0.15 W=1.68 nf=1 m=1
XXck_c1_XN2 Xck_c1.n1 ckd vss vss sky130_fd_pr__nfet_01v8 L=0.15 W=1.68 nf=1 m=1
XXck_c2_XP pc1 pc0 vdd vdd sky130_fd_pr__pfet_01v8 L=0.15 W=1.68 nf=1 m=1
XXck_c2_XN pc1 pc0 vss vss sky130_fd_pr__nfet_01v8 L=0.15 W=0.84 nf=1 m=1
XXck_c3_XP pcb pc1 vdd vdd sky130_fd_pr__pfet_01v8 L=0.15 W=5.04 nf=1 m=1
XXck_c3_XN pcb pc1 vss vss sky130_fd_pr__nfet_01v8 L=0.15 W=2.52 nf=1 m=1
XXff_a0_XCI_XP Xff_a0.ckb clk_ff vdd vdd sky130_fd_pr__pfet_01v8 L=0.15 W=0.84 nf=1 m=1
XXff_a0_XCI_XN Xff_a0.ckb clk_ff vss vss sky130_fd_pr__nfet_01v8 L=0.15 W=0.42 nf=1 m=1
XXff_a0_XCI2_XP Xff_a0.ck Xff_a0.ckb vdd vdd sky130_fd_pr__pfet_01v8 L=0.15 W=0.84 nf=1 m=1
XXff_a0_XCI2_XN Xff_a0.ck Xff_a0.ckb vss vss sky130_fd_pr__nfet_01v8 L=0.15 W=0.42 nf=1 m=1
XXff_a0_XT1N addr_in Xff_a0.ckb Xff_a0.m1 vss sky130_fd_pr__nfet_01v8 L=0.15 W=0.42 nf=1 m=1
XXff_a0_XT1P addr_in Xff_a0.ck Xff_a0.m1 vdd sky130_fd_pr__pfet_01v8 L=0.15 W=0.42 nf=1 m=1
XXff_a0_XM1_XP Xff_a0.m2 Xff_a0.m1 vdd vdd sky130_fd_pr__pfet_01v8 L=0.15 W=0.84 nf=1 m=1
XXff_a0_XM1_XN Xff_a0.m2 Xff_a0.m1 vss vss sky130_fd_pr__nfet_01v8 L=0.15 W=0.42 nf=1 m=1
XXff_a0_XM2_XP Xff_a0.m3 Xff_a0.m2 vdd vdd sky130_fd_pr__pfet_01v8 L=0.15 W=0.84 nf=1 m=1
XXff_a0_XM2_XN Xff_a0.m3 Xff_a0.m2 vss vss sky130_fd_pr__nfet_01v8 L=0.15 W=0.42 nf=1 m=1
XXff_a0_XT2N Xff_a0.m3 Xff_a0.ck Xff_a0.m1 vss sky130_fd_pr__nfet_01v8 L=0.15 W=0.42 nf=1 m=1
XXff_a0_XT2P Xff_a0.m3 Xff_a0.ckb Xff_a0.m1 vdd sky130_fd_pr__pfet_01v8 L=0.15 W=0.42 nf=1 m=1
XXff_a0_XT3N Xff_a0.m2 Xff_a0.ck Xff_a0.s1 vss sky130_fd_pr__nfet_01v8 L=0.15 W=0.42 nf=1 m=1
XXff_a0_XT3P Xff_a0.m2 Xff_a0.ckb Xff_a0.s1 vdd sky130_fd_pr__pfet_01v8 L=0.15 W=0.42 nf=1 m=1
XXff_a0_XS1_XP a0 Xff_a0.s1 vdd vdd sky130_fd_pr__pfet_01v8 L=0.15 W=1.26 nf=1 m=1
XXff_a0_XS1_XN a0 Xff_a0.s1 vss vss sky130_fd_pr__nfet_01v8 L=0.15 W=0.63 nf=1 m=1
XXff_a0_XS2_XP ab0 a0 vdd vdd sky130_fd_pr__pfet_01v8 L=0.15 W=0.84 nf=1 m=1
XXff_a0_XS2_XN ab0 a0 vss vss sky130_fd_pr__nfet_01v8 L=0.15 W=0.42 nf=1 m=1
XXff_a0_XT4N ab0 Xff_a0.ckb Xff_a0.s1 vss sky130_fd_pr__nfet_01v8 L=0.15 W=0.42 nf=1 m=1
XXff_a0_XT4P ab0 Xff_a0.ck Xff_a0.s1 vdd sky130_fd_pr__pfet_01v8 L=0.15 W=0.42 nf=1 m=1
XXff_a1_XCI_XP Xff_a1.ckb clk_ff vdd vdd sky130_fd_pr__pfet_01v8 L=0.15 W=0.84 nf=1 m=1
XXff_a1_XCI_XN Xff_a1.ckb clk_ff vss vss sky130_fd_pr__nfet_01v8 L=0.15 W=0.42 nf=1 m=1
XXff_a1_XCI2_XP Xff_a1.ck Xff_a1.ckb vdd vdd sky130_fd_pr__pfet_01v8 L=0.15 W=0.84 nf=1 m=1
XXff_a1_XCI2_XN Xff_a1.ck Xff_a1.ckb vss vss sky130_fd_pr__nfet_01v8 L=0.15 W=0.42 nf=1 m=1
XXff_a1_XT1N a0 Xff_a1.ckb Xff_a1.m1 vss sky130_fd_pr__nfet_01v8 L=0.15 W=0.42 nf=1 m=1
XXff_a1_XT1P a0 Xff_a1.ck Xff_a1.m1 vdd sky130_fd_pr__pfet_01v8 L=0.15 W=0.42 nf=1 m=1
XXff_a1_XM1_XP Xff_a1.m2 Xff_a1.m1 vdd vdd sky130_fd_pr__pfet_01v8 L=0.15 W=0.84 nf=1 m=1
XXff_a1_XM1_XN Xff_a1.m2 Xff_a1.m1 vss vss sky130_fd_pr__nfet_01v8 L=0.15 W=0.42 nf=1 m=1
XXff_a1_XM2_XP Xff_a1.m3 Xff_a1.m2 vdd vdd sky130_fd_pr__pfet_01v8 L=0.15 W=0.84 nf=1 m=1
XXff_a1_XM2_XN Xff_a1.m3 Xff_a1.m2 vss vss sky130_fd_pr__nfet_01v8 L=0.15 W=0.42 nf=1 m=1
XXff_a1_XT2N Xff_a1.m3 Xff_a1.ck Xff_a1.m1 vss sky130_fd_pr__nfet_01v8 L=0.15 W=0.42 nf=1 m=1
XXff_a1_XT2P Xff_a1.m3 Xff_a1.ckb Xff_a1.m1 vdd sky130_fd_pr__pfet_01v8 L=0.15 W=0.42 nf=1 m=1
XXff_a1_XT3N Xff_a1.m2 Xff_a1.ck Xff_a1.s1 vss sky130_fd_pr__nfet_01v8 L=0.15 W=0.42 nf=1 m=1
XXff_a1_XT3P Xff_a1.m2 Xff_a1.ckb Xff_a1.s1 vdd sky130_fd_pr__pfet_01v8 L=0.15 W=0.42 nf=1 m=1
XXff_a1_XS1_XP a1 Xff_a1.s1 vdd vdd sky130_fd_pr__pfet_01v8 L=0.15 W=1.26 nf=1 m=1
XXff_a1_XS1_XN a1 Xff_a1.s1 vss vss sky130_fd_pr__nfet_01v8 L=0.15 W=0.63 nf=1 m=1
XXff_a1_XS2_XP ab1 a1 vdd vdd sky130_fd_pr__pfet_01v8 L=0.15 W=0.84 nf=1 m=1
XXff_a1_XS2_XN ab1 a1 vss vss sky130_fd_pr__nfet_01v8 L=0.15 W=0.42 nf=1 m=1
XXff_a1_XT4N ab1 Xff_a1.ckb Xff_a1.s1 vss sky130_fd_pr__nfet_01v8 L=0.15 W=0.42 nf=1 m=1
XXff_a1_XT4P ab1 Xff_a1.ck Xff_a1.s1 vdd sky130_fd_pr__pfet_01v8 L=0.15 W=0.42 nf=1 m=1
XXff_a2_XCI_XP Xff_a2.ckb clk_ff vdd vdd sky130_fd_pr__pfet_01v8 L=0.15 W=0.84 nf=1 m=1
XXff_a2_XCI_XN Xff_a2.ckb clk_ff vss vss sky130_fd_pr__nfet_01v8 L=0.15 W=0.42 nf=1 m=1
XXff_a2_XCI2_XP Xff_a2.ck Xff_a2.ckb vdd vdd sky130_fd_pr__pfet_01v8 L=0.15 W=0.84 nf=1 m=1
XXff_a2_XCI2_XN Xff_a2.ck Xff_a2.ckb vss vss sky130_fd_pr__nfet_01v8 L=0.15 W=0.42 nf=1 m=1
XXff_a2_XT1N a1 Xff_a2.ckb Xff_a2.m1 vss sky130_fd_pr__nfet_01v8 L=0.15 W=0.42 nf=1 m=1
XXff_a2_XT1P a1 Xff_a2.ck Xff_a2.m1 vdd sky130_fd_pr__pfet_01v8 L=0.15 W=0.42 nf=1 m=1
XXff_a2_XM1_XP Xff_a2.m2 Xff_a2.m1 vdd vdd sky130_fd_pr__pfet_01v8 L=0.15 W=0.84 nf=1 m=1
XXff_a2_XM1_XN Xff_a2.m2 Xff_a2.m1 vss vss sky130_fd_pr__nfet_01v8 L=0.15 W=0.42 nf=1 m=1
XXff_a2_XM2_XP Xff_a2.m3 Xff_a2.m2 vdd vdd sky130_fd_pr__pfet_01v8 L=0.15 W=0.84 nf=1 m=1
XXff_a2_XM2_XN Xff_a2.m3 Xff_a2.m2 vss vss sky130_fd_pr__nfet_01v8 L=0.15 W=0.42 nf=1 m=1
XXff_a2_XT2N Xff_a2.m3 Xff_a2.ck Xff_a2.m1 vss sky130_fd_pr__nfet_01v8 L=0.15 W=0.42 nf=1 m=1
XXff_a2_XT2P Xff_a2.m3 Xff_a2.ckb Xff_a2.m1 vdd sky130_fd_pr__pfet_01v8 L=0.15 W=0.42 nf=1 m=1
XXff_a2_XT3N Xff_a2.m2 Xff_a2.ck Xff_a2.s1 vss sky130_fd_pr__nfet_01v8 L=0.15 W=0.42 nf=1 m=1
XXff_a2_XT3P Xff_a2.m2 Xff_a2.ckb Xff_a2.s1 vdd sky130_fd_pr__pfet_01v8 L=0.15 W=0.42 nf=1 m=1
XXff_a2_XS1_XP a2 Xff_a2.s1 vdd vdd sky130_fd_pr__pfet_01v8 L=0.15 W=1.26 nf=1 m=1
XXff_a2_XS1_XN a2 Xff_a2.s1 vss vss sky130_fd_pr__nfet_01v8 L=0.15 W=0.63 nf=1 m=1
XXff_a2_XS2_XP ab2 a2 vdd vdd sky130_fd_pr__pfet_01v8 L=0.15 W=0.84 nf=1 m=1
XXff_a2_XS2_XN ab2 a2 vss vss sky130_fd_pr__nfet_01v8 L=0.15 W=0.42 nf=1 m=1
XXff_a2_XT4N ab2 Xff_a2.ckb Xff_a2.s1 vss sky130_fd_pr__nfet_01v8 L=0.15 W=0.42 nf=1 m=1
XXff_a2_XT4P ab2 Xff_a2.ck Xff_a2.s1 vdd sky130_fd_pr__pfet_01v8 L=0.15 W=0.42 nf=1 m=1
XXff_a3_XCI_XP Xff_a3.ckb clk_ff vdd vdd sky130_fd_pr__pfet_01v8 L=0.15 W=0.84 nf=1 m=1
XXff_a3_XCI_XN Xff_a3.ckb clk_ff vss vss sky130_fd_pr__nfet_01v8 L=0.15 W=0.42 nf=1 m=1
XXff_a3_XCI2_XP Xff_a3.ck Xff_a3.ckb vdd vdd sky130_fd_pr__pfet_01v8 L=0.15 W=0.84 nf=1 m=1
XXff_a3_XCI2_XN Xff_a3.ck Xff_a3.ckb vss vss sky130_fd_pr__nfet_01v8 L=0.15 W=0.42 nf=1 m=1
XXff_a3_XT1N a2 Xff_a3.ckb Xff_a3.m1 vss sky130_fd_pr__nfet_01v8 L=0.15 W=0.42 nf=1 m=1
XXff_a3_XT1P a2 Xff_a3.ck Xff_a3.m1 vdd sky130_fd_pr__pfet_01v8 L=0.15 W=0.42 nf=1 m=1
XXff_a3_XM1_XP Xff_a3.m2 Xff_a3.m1 vdd vdd sky130_fd_pr__pfet_01v8 L=0.15 W=0.84 nf=1 m=1
XXff_a3_XM1_XN Xff_a3.m2 Xff_a3.m1 vss vss sky130_fd_pr__nfet_01v8 L=0.15 W=0.42 nf=1 m=1
XXff_a3_XM2_XP Xff_a3.m3 Xff_a3.m2 vdd vdd sky130_fd_pr__pfet_01v8 L=0.15 W=0.84 nf=1 m=1
XXff_a3_XM2_XN Xff_a3.m3 Xff_a3.m2 vss vss sky130_fd_pr__nfet_01v8 L=0.15 W=0.42 nf=1 m=1
XXff_a3_XT2N Xff_a3.m3 Xff_a3.ck Xff_a3.m1 vss sky130_fd_pr__nfet_01v8 L=0.15 W=0.42 nf=1 m=1
XXff_a3_XT2P Xff_a3.m3 Xff_a3.ckb Xff_a3.m1 vdd sky130_fd_pr__pfet_01v8 L=0.15 W=0.42 nf=1 m=1
XXff_a3_XT3N Xff_a3.m2 Xff_a3.ck Xff_a3.s1 vss sky130_fd_pr__nfet_01v8 L=0.15 W=0.42 nf=1 m=1
XXff_a3_XT3P Xff_a3.m2 Xff_a3.ckb Xff_a3.s1 vdd sky130_fd_pr__pfet_01v8 L=0.15 W=0.42 nf=1 m=1
XXff_a3_XS1_XP a3 Xff_a3.s1 vdd vdd sky130_fd_pr__pfet_01v8 L=0.15 W=1.26 nf=1 m=1
XXff_a3_XS1_XN a3 Xff_a3.s1 vss vss sky130_fd_pr__nfet_01v8 L=0.15 W=0.63 nf=1 m=1
XXff_a3_XS2_XP ab3 a3 vdd vdd sky130_fd_pr__pfet_01v8 L=0.15 W=0.84 nf=1 m=1
XXff_a3_XS2_XN ab3 a3 vss vss sky130_fd_pr__nfet_01v8 L=0.15 W=0.42 nf=1 m=1
XXff_a3_XT4N ab3 Xff_a3.ckb Xff_a3.s1 vss sky130_fd_pr__nfet_01v8 L=0.15 W=0.42 nf=1 m=1
XXff_a3_XT4P ab3 Xff_a3.ck Xff_a3.s1 vdd sky130_fd_pr__pfet_01v8 L=0.15 W=0.42 nf=1 m=1
XXff_a4_XCI_XP Xff_a4.ckb clk_ff vdd vdd sky130_fd_pr__pfet_01v8 L=0.15 W=0.84 nf=1 m=1
XXff_a4_XCI_XN Xff_a4.ckb clk_ff vss vss sky130_fd_pr__nfet_01v8 L=0.15 W=0.42 nf=1 m=1
XXff_a4_XCI2_XP Xff_a4.ck Xff_a4.ckb vdd vdd sky130_fd_pr__pfet_01v8 L=0.15 W=0.84 nf=1 m=1
XXff_a4_XCI2_XN Xff_a4.ck Xff_a4.ckb vss vss sky130_fd_pr__nfet_01v8 L=0.15 W=0.42 nf=1 m=1
XXff_a4_XT1N a3 Xff_a4.ckb Xff_a4.m1 vss sky130_fd_pr__nfet_01v8 L=0.15 W=0.42 nf=1 m=1
XXff_a4_XT1P a3 Xff_a4.ck Xff_a4.m1 vdd sky130_fd_pr__pfet_01v8 L=0.15 W=0.42 nf=1 m=1
XXff_a4_XM1_XP Xff_a4.m2 Xff_a4.m1 vdd vdd sky130_fd_pr__pfet_01v8 L=0.15 W=0.84 nf=1 m=1
XXff_a4_XM1_XN Xff_a4.m2 Xff_a4.m1 vss vss sky130_fd_pr__nfet_01v8 L=0.15 W=0.42 nf=1 m=1
XXff_a4_XM2_XP Xff_a4.m3 Xff_a4.m2 vdd vdd sky130_fd_pr__pfet_01v8 L=0.15 W=0.84 nf=1 m=1
XXff_a4_XM2_XN Xff_a4.m3 Xff_a4.m2 vss vss sky130_fd_pr__nfet_01v8 L=0.15 W=0.42 nf=1 m=1
XXff_a4_XT2N Xff_a4.m3 Xff_a4.ck Xff_a4.m1 vss sky130_fd_pr__nfet_01v8 L=0.15 W=0.42 nf=1 m=1
XXff_a4_XT2P Xff_a4.m3 Xff_a4.ckb Xff_a4.m1 vdd sky130_fd_pr__pfet_01v8 L=0.15 W=0.42 nf=1 m=1
XXff_a4_XT3N Xff_a4.m2 Xff_a4.ck Xff_a4.s1 vss sky130_fd_pr__nfet_01v8 L=0.15 W=0.42 nf=1 m=1
XXff_a4_XT3P Xff_a4.m2 Xff_a4.ckb Xff_a4.s1 vdd sky130_fd_pr__pfet_01v8 L=0.15 W=0.42 nf=1 m=1
XXff_a4_XS1_XP a4 Xff_a4.s1 vdd vdd sky130_fd_pr__pfet_01v8 L=0.15 W=1.26 nf=1 m=1
XXff_a4_XS1_XN a4 Xff_a4.s1 vss vss sky130_fd_pr__nfet_01v8 L=0.15 W=0.63 nf=1 m=1
XXff_a4_XS2_XP ab4 a4 vdd vdd sky130_fd_pr__pfet_01v8 L=0.15 W=0.84 nf=1 m=1
XXff_a4_XS2_XN ab4 a4 vss vss sky130_fd_pr__nfet_01v8 L=0.15 W=0.42 nf=1 m=1
XXff_a4_XT4N ab4 Xff_a4.ckb Xff_a4.s1 vss sky130_fd_pr__nfet_01v8 L=0.15 W=0.42 nf=1 m=1
XXff_a4_XT4P ab4 Xff_a4.ck Xff_a4.s1 vdd sky130_fd_pr__pfet_01v8 L=0.15 W=0.42 nf=1 m=1
XXff_a5_XCI_XP Xff_a5.ckb clk_ff vdd vdd sky130_fd_pr__pfet_01v8 L=0.15 W=0.84 nf=1 m=1
XXff_a5_XCI_XN Xff_a5.ckb clk_ff vss vss sky130_fd_pr__nfet_01v8 L=0.15 W=0.42 nf=1 m=1
XXff_a5_XCI2_XP Xff_a5.ck Xff_a5.ckb vdd vdd sky130_fd_pr__pfet_01v8 L=0.15 W=0.84 nf=1 m=1
XXff_a5_XCI2_XN Xff_a5.ck Xff_a5.ckb vss vss sky130_fd_pr__nfet_01v8 L=0.15 W=0.42 nf=1 m=1
XXff_a5_XT1N a4 Xff_a5.ckb Xff_a5.m1 vss sky130_fd_pr__nfet_01v8 L=0.15 W=0.42 nf=1 m=1
XXff_a5_XT1P a4 Xff_a5.ck Xff_a5.m1 vdd sky130_fd_pr__pfet_01v8 L=0.15 W=0.42 nf=1 m=1
XXff_a5_XM1_XP Xff_a5.m2 Xff_a5.m1 vdd vdd sky130_fd_pr__pfet_01v8 L=0.15 W=0.84 nf=1 m=1
XXff_a5_XM1_XN Xff_a5.m2 Xff_a5.m1 vss vss sky130_fd_pr__nfet_01v8 L=0.15 W=0.42 nf=1 m=1
XXff_a5_XM2_XP Xff_a5.m3 Xff_a5.m2 vdd vdd sky130_fd_pr__pfet_01v8 L=0.15 W=0.84 nf=1 m=1
XXff_a5_XM2_XN Xff_a5.m3 Xff_a5.m2 vss vss sky130_fd_pr__nfet_01v8 L=0.15 W=0.42 nf=1 m=1
XXff_a5_XT2N Xff_a5.m3 Xff_a5.ck Xff_a5.m1 vss sky130_fd_pr__nfet_01v8 L=0.15 W=0.42 nf=1 m=1
XXff_a5_XT2P Xff_a5.m3 Xff_a5.ckb Xff_a5.m1 vdd sky130_fd_pr__pfet_01v8 L=0.15 W=0.42 nf=1 m=1
XXff_a5_XT3N Xff_a5.m2 Xff_a5.ck Xff_a5.s1 vss sky130_fd_pr__nfet_01v8 L=0.15 W=0.42 nf=1 m=1
XXff_a5_XT3P Xff_a5.m2 Xff_a5.ckb Xff_a5.s1 vdd sky130_fd_pr__pfet_01v8 L=0.15 W=0.42 nf=1 m=1
XXff_a5_XS1_XP a5 Xff_a5.s1 vdd vdd sky130_fd_pr__pfet_01v8 L=0.15 W=1.26 nf=1 m=1
XXff_a5_XS1_XN a5 Xff_a5.s1 vss vss sky130_fd_pr__nfet_01v8 L=0.15 W=0.63 nf=1 m=1
XXff_a5_XS2_XP ab5 a5 vdd vdd sky130_fd_pr__pfet_01v8 L=0.15 W=0.84 nf=1 m=1
XXff_a5_XS2_XN ab5 a5 vss vss sky130_fd_pr__nfet_01v8 L=0.15 W=0.42 nf=1 m=1
XXff_a5_XT4N ab5 Xff_a5.ckb Xff_a5.s1 vss sky130_fd_pr__nfet_01v8 L=0.15 W=0.42 nf=1 m=1
XXff_a5_XT4P ab5 Xff_a5.ck Xff_a5.s1 vdd sky130_fd_pr__pfet_01v8 L=0.15 W=0.42 nf=1 m=1
XXff_a6_XCI_XP Xff_a6.ckb clk_ff vdd vdd sky130_fd_pr__pfet_01v8 L=0.15 W=0.84 nf=1 m=1
XXff_a6_XCI_XN Xff_a6.ckb clk_ff vss vss sky130_fd_pr__nfet_01v8 L=0.15 W=0.42 nf=1 m=1
XXff_a6_XCI2_XP Xff_a6.ck Xff_a6.ckb vdd vdd sky130_fd_pr__pfet_01v8 L=0.15 W=0.84 nf=1 m=1
XXff_a6_XCI2_XN Xff_a6.ck Xff_a6.ckb vss vss sky130_fd_pr__nfet_01v8 L=0.15 W=0.42 nf=1 m=1
XXff_a6_XT1N a5 Xff_a6.ckb Xff_a6.m1 vss sky130_fd_pr__nfet_01v8 L=0.15 W=0.42 nf=1 m=1
XXff_a6_XT1P a5 Xff_a6.ck Xff_a6.m1 vdd sky130_fd_pr__pfet_01v8 L=0.15 W=0.42 nf=1 m=1
XXff_a6_XM1_XP Xff_a6.m2 Xff_a6.m1 vdd vdd sky130_fd_pr__pfet_01v8 L=0.15 W=0.84 nf=1 m=1
XXff_a6_XM1_XN Xff_a6.m2 Xff_a6.m1 vss vss sky130_fd_pr__nfet_01v8 L=0.15 W=0.42 nf=1 m=1
XXff_a6_XM2_XP Xff_a6.m3 Xff_a6.m2 vdd vdd sky130_fd_pr__pfet_01v8 L=0.15 W=0.84 nf=1 m=1
XXff_a6_XM2_XN Xff_a6.m3 Xff_a6.m2 vss vss sky130_fd_pr__nfet_01v8 L=0.15 W=0.42 nf=1 m=1
XXff_a6_XT2N Xff_a6.m3 Xff_a6.ck Xff_a6.m1 vss sky130_fd_pr__nfet_01v8 L=0.15 W=0.42 nf=1 m=1
XXff_a6_XT2P Xff_a6.m3 Xff_a6.ckb Xff_a6.m1 vdd sky130_fd_pr__pfet_01v8 L=0.15 W=0.42 nf=1 m=1
XXff_a6_XT3N Xff_a6.m2 Xff_a6.ck Xff_a6.s1 vss sky130_fd_pr__nfet_01v8 L=0.15 W=0.42 nf=1 m=1
XXff_a6_XT3P Xff_a6.m2 Xff_a6.ckb Xff_a6.s1 vdd sky130_fd_pr__pfet_01v8 L=0.15 W=0.42 nf=1 m=1
XXff_a6_XS1_XP a6 Xff_a6.s1 vdd vdd sky130_fd_pr__pfet_01v8 L=0.15 W=1.26 nf=1 m=1
XXff_a6_XS1_XN a6 Xff_a6.s1 vss vss sky130_fd_pr__nfet_01v8 L=0.15 W=0.63 nf=1 m=1
XXff_a6_XS2_XP ab6 a6 vdd vdd sky130_fd_pr__pfet_01v8 L=0.15 W=0.84 nf=1 m=1
XXff_a6_XS2_XN ab6 a6 vss vss sky130_fd_pr__nfet_01v8 L=0.15 W=0.42 nf=1 m=1
XXff_a6_XT4N ab6 Xff_a6.ckb Xff_a6.s1 vss sky130_fd_pr__nfet_01v8 L=0.15 W=0.42 nf=1 m=1
XXff_a6_XT4P ab6 Xff_a6.ck Xff_a6.s1 vdd sky130_fd_pr__pfet_01v8 L=0.15 W=0.42 nf=1 m=1
XXff_a7_XCI_XP Xff_a7.ckb clk_ff vdd vdd sky130_fd_pr__pfet_01v8 L=0.15 W=0.84 nf=1 m=1
XXff_a7_XCI_XN Xff_a7.ckb clk_ff vss vss sky130_fd_pr__nfet_01v8 L=0.15 W=0.42 nf=1 m=1
XXff_a7_XCI2_XP Xff_a7.ck Xff_a7.ckb vdd vdd sky130_fd_pr__pfet_01v8 L=0.15 W=0.84 nf=1 m=1
XXff_a7_XCI2_XN Xff_a7.ck Xff_a7.ckb vss vss sky130_fd_pr__nfet_01v8 L=0.15 W=0.42 nf=1 m=1
XXff_a7_XT1N a6 Xff_a7.ckb Xff_a7.m1 vss sky130_fd_pr__nfet_01v8 L=0.15 W=0.42 nf=1 m=1
XXff_a7_XT1P a6 Xff_a7.ck Xff_a7.m1 vdd sky130_fd_pr__pfet_01v8 L=0.15 W=0.42 nf=1 m=1
XXff_a7_XM1_XP Xff_a7.m2 Xff_a7.m1 vdd vdd sky130_fd_pr__pfet_01v8 L=0.15 W=0.84 nf=1 m=1
XXff_a7_XM1_XN Xff_a7.m2 Xff_a7.m1 vss vss sky130_fd_pr__nfet_01v8 L=0.15 W=0.42 nf=1 m=1
XXff_a7_XM2_XP Xff_a7.m3 Xff_a7.m2 vdd vdd sky130_fd_pr__pfet_01v8 L=0.15 W=0.84 nf=1 m=1
XXff_a7_XM2_XN Xff_a7.m3 Xff_a7.m2 vss vss sky130_fd_pr__nfet_01v8 L=0.15 W=0.42 nf=1 m=1
XXff_a7_XT2N Xff_a7.m3 Xff_a7.ck Xff_a7.m1 vss sky130_fd_pr__nfet_01v8 L=0.15 W=0.42 nf=1 m=1
XXff_a7_XT2P Xff_a7.m3 Xff_a7.ckb Xff_a7.m1 vdd sky130_fd_pr__pfet_01v8 L=0.15 W=0.42 nf=1 m=1
XXff_a7_XT3N Xff_a7.m2 Xff_a7.ck Xff_a7.s1 vss sky130_fd_pr__nfet_01v8 L=0.15 W=0.42 nf=1 m=1
XXff_a7_XT3P Xff_a7.m2 Xff_a7.ckb Xff_a7.s1 vdd sky130_fd_pr__pfet_01v8 L=0.15 W=0.42 nf=1 m=1
XXff_a7_XS1_XP a7 Xff_a7.s1 vdd vdd sky130_fd_pr__pfet_01v8 L=0.15 W=1.26 nf=1 m=1
XXff_a7_XS1_XN a7 Xff_a7.s1 vss vss sky130_fd_pr__nfet_01v8 L=0.15 W=0.63 nf=1 m=1
XXff_a7_XS2_XP ab7 a7 vdd vdd sky130_fd_pr__pfet_01v8 L=0.15 W=0.84 nf=1 m=1
XXff_a7_XS2_XN ab7 a7 vss vss sky130_fd_pr__nfet_01v8 L=0.15 W=0.42 nf=1 m=1
XXff_a7_XT4N ab7 Xff_a7.ckb Xff_a7.s1 vss sky130_fd_pr__nfet_01v8 L=0.15 W=0.42 nf=1 m=1
XXff_a7_XT4P ab7 Xff_a7.ck Xff_a7.s1 vdd sky130_fd_pr__pfet_01v8 L=0.15 W=0.42 nf=1 m=1
XXff_rw_XCI_XP Xff_rw.ckb clk_ff vdd vdd sky130_fd_pr__pfet_01v8 L=0.15 W=0.84 nf=1 m=1
XXff_rw_XCI_XN Xff_rw.ckb clk_ff vss vss sky130_fd_pr__nfet_01v8 L=0.15 W=0.42 nf=1 m=1
XXff_rw_XCI2_XP Xff_rw.ck Xff_rw.ckb vdd vdd sky130_fd_pr__pfet_01v8 L=0.15 W=0.84 nf=1 m=1
XXff_rw_XCI2_XN Xff_rw.ck Xff_rw.ckb vss vss sky130_fd_pr__nfet_01v8 L=0.15 W=0.42 nf=1 m=1
XXff_rw_XT1N rw_in Xff_rw.ckb Xff_rw.m1 vss sky130_fd_pr__nfet_01v8 L=0.15 W=0.42 nf=1 m=1
XXff_rw_XT1P rw_in Xff_rw.ck Xff_rw.m1 vdd sky130_fd_pr__pfet_01v8 L=0.15 W=0.42 nf=1 m=1
XXff_rw_XM1_XP Xff_rw.m2 Xff_rw.m1 vdd vdd sky130_fd_pr__pfet_01v8 L=0.15 W=0.84 nf=1 m=1
XXff_rw_XM1_XN Xff_rw.m2 Xff_rw.m1 vss vss sky130_fd_pr__nfet_01v8 L=0.15 W=0.42 nf=1 m=1
XXff_rw_XM2_XP Xff_rw.m3 Xff_rw.m2 vdd vdd sky130_fd_pr__pfet_01v8 L=0.15 W=0.84 nf=1 m=1
XXff_rw_XM2_XN Xff_rw.m3 Xff_rw.m2 vss vss sky130_fd_pr__nfet_01v8 L=0.15 W=0.42 nf=1 m=1
XXff_rw_XT2N Xff_rw.m3 Xff_rw.ck Xff_rw.m1 vss sky130_fd_pr__nfet_01v8 L=0.15 W=0.42 nf=1 m=1
XXff_rw_XT2P Xff_rw.m3 Xff_rw.ckb Xff_rw.m1 vdd sky130_fd_pr__pfet_01v8 L=0.15 W=0.42 nf=1 m=1
XXff_rw_XT3N Xff_rw.m2 Xff_rw.ck Xff_rw.s1 vss sky130_fd_pr__nfet_01v8 L=0.15 W=0.42 nf=1 m=1
XXff_rw_XT3P Xff_rw.m2 Xff_rw.ckb Xff_rw.s1 vdd sky130_fd_pr__pfet_01v8 L=0.15 W=0.42 nf=1 m=1
XXff_rw_XS1_XP rwq Xff_rw.s1 vdd vdd sky130_fd_pr__pfet_01v8 L=0.15 W=1.26 nf=1 m=1
XXff_rw_XS1_XN rwq Xff_rw.s1 vss vss sky130_fd_pr__nfet_01v8 L=0.15 W=0.63 nf=1 m=1
XXff_rw_XS2_XP rwqb rwq vdd vdd sky130_fd_pr__pfet_01v8 L=0.15 W=0.84 nf=1 m=1
XXff_rw_XS2_XN rwqb rwq vss vss sky130_fd_pr__nfet_01v8 L=0.15 W=0.42 nf=1 m=1
XXff_rw_XT4N rwqb Xff_rw.ckb Xff_rw.s1 vss sky130_fd_pr__nfet_01v8 L=0.15 W=0.42 nf=1 m=1
XXff_rw_XT4P rwqb Xff_rw.ck Xff_rw.s1 vdd sky130_fd_pr__pfet_01v8 L=0.15 W=0.42 nf=1 m=1
XXff_din_XCI_XP Xff_din.ckb clk_ff vdd vdd sky130_fd_pr__pfet_01v8 L=0.15 W=0.84 nf=1 m=1
XXff_din_XCI_XN Xff_din.ckb clk_ff vss vss sky130_fd_pr__nfet_01v8 L=0.15 W=0.42 nf=1 m=1
XXff_din_XCI2_XP Xff_din.ck Xff_din.ckb vdd vdd sky130_fd_pr__pfet_01v8 L=0.15 W=0.84 nf=1 m=1
XXff_din_XCI2_XN Xff_din.ck Xff_din.ckb vss vss sky130_fd_pr__nfet_01v8 L=0.15 W=0.42 nf=1 m=1
XXff_din_XT1N din_in Xff_din.ckb Xff_din.m1 vss sky130_fd_pr__nfet_01v8 L=0.15 W=0.42 nf=1 m=1
XXff_din_XT1P din_in Xff_din.ck Xff_din.m1 vdd sky130_fd_pr__pfet_01v8 L=0.15 W=0.42 nf=1 m=1
XXff_din_XM1_XP Xff_din.m2 Xff_din.m1 vdd vdd sky130_fd_pr__pfet_01v8 L=0.15 W=0.84 nf=1 m=1
XXff_din_XM1_XN Xff_din.m2 Xff_din.m1 vss vss sky130_fd_pr__nfet_01v8 L=0.15 W=0.42 nf=1 m=1
XXff_din_XM2_XP Xff_din.m3 Xff_din.m2 vdd vdd sky130_fd_pr__pfet_01v8 L=0.15 W=0.84 nf=1 m=1
XXff_din_XM2_XN Xff_din.m3 Xff_din.m2 vss vss sky130_fd_pr__nfet_01v8 L=0.15 W=0.42 nf=1 m=1
XXff_din_XT2N Xff_din.m3 Xff_din.ck Xff_din.m1 vss sky130_fd_pr__nfet_01v8 L=0.15 W=0.42 nf=1 m=1
XXff_din_XT2P Xff_din.m3 Xff_din.ckb Xff_din.m1 vdd sky130_fd_pr__pfet_01v8 L=0.15 W=0.42 nf=1 m=1
XXff_din_XT3N Xff_din.m2 Xff_din.ck Xff_din.s1 vss sky130_fd_pr__nfet_01v8 L=0.15 W=0.42 nf=1 m=1
XXff_din_XT3P Xff_din.m2 Xff_din.ckb Xff_din.s1 vdd sky130_fd_pr__pfet_01v8 L=0.15 W=0.42 nf=1 m=1
XXff_din_XS1_XP dinq Xff_din.s1 vdd vdd sky130_fd_pr__pfet_01v8 L=0.15 W=1.26 nf=1 m=1
XXff_din_XS1_XN dinq Xff_din.s1 vss vss sky130_fd_pr__nfet_01v8 L=0.15 W=0.63 nf=1 m=1
XXff_din_XS2_XP dinqb dinq vdd vdd sky130_fd_pr__pfet_01v8 L=0.15 W=0.84 nf=1 m=1
XXff_din_XS2_XN dinqb dinq vss vss sky130_fd_pr__nfet_01v8 L=0.15 W=0.42 nf=1 m=1
XXff_din_XT4N dinqb Xff_din.ckb Xff_din.s1 vss sky130_fd_pr__nfet_01v8 L=0.15 W=0.42 nf=1 m=1
XXff_din_XT4P dinqb Xff_din.ck Xff_din.s1 vdd sky130_fd_pr__pfet_01v8 L=0.15 W=0.42 nf=1 m=1
XXpd_rh0_XP1 rhb0 ab7 vdd vdd sky130_fd_pr__pfet_01v8 L=0.15 W=0.84 nf=1 m=1
XXpd_rh0_XP2 rhb0 ab6 vdd vdd sky130_fd_pr__pfet_01v8 L=0.15 W=0.84 nf=1 m=1
XXpd_rh0_XN1 rhb0 ab7 Xpd_rh0.n1 vss sky130_fd_pr__nfet_01v8 L=0.15 W=0.84 nf=1 m=1
XXpd_rh0_XN2 Xpd_rh0.n1 ab6 vss vss sky130_fd_pr__nfet_01v8 L=0.15 W=0.84 nf=1 m=1
XXpi_rh0_XP rh0 rhb0 vdd vdd sky130_fd_pr__pfet_01v8 L=0.15 W=1.68 nf=1 m=1
XXpi_rh0_XN rh0 rhb0 vss vss sky130_fd_pr__nfet_01v8 L=0.15 W=0.84 nf=1 m=1
XXpd_rh1_XP1 rhb1 ab7 vdd vdd sky130_fd_pr__pfet_01v8 L=0.15 W=0.84 nf=1 m=1
XXpd_rh1_XP2 rhb1 a6 vdd vdd sky130_fd_pr__pfet_01v8 L=0.15 W=0.84 nf=1 m=1
XXpd_rh1_XN1 rhb1 ab7 Xpd_rh1.n1 vss sky130_fd_pr__nfet_01v8 L=0.15 W=0.84 nf=1 m=1
XXpd_rh1_XN2 Xpd_rh1.n1 a6 vss vss sky130_fd_pr__nfet_01v8 L=0.15 W=0.84 nf=1 m=1
XXpi_rh1_XP rh1 rhb1 vdd vdd sky130_fd_pr__pfet_01v8 L=0.15 W=1.68 nf=1 m=1
XXpi_rh1_XN rh1 rhb1 vss vss sky130_fd_pr__nfet_01v8 L=0.15 W=0.84 nf=1 m=1
XXpd_rh2_XP1 rhb2 a7 vdd vdd sky130_fd_pr__pfet_01v8 L=0.15 W=0.84 nf=1 m=1
XXpd_rh2_XP2 rhb2 ab6 vdd vdd sky130_fd_pr__pfet_01v8 L=0.15 W=0.84 nf=1 m=1
XXpd_rh2_XN1 rhb2 a7 Xpd_rh2.n1 vss sky130_fd_pr__nfet_01v8 L=0.15 W=0.84 nf=1 m=1
XXpd_rh2_XN2 Xpd_rh2.n1 ab6 vss vss sky130_fd_pr__nfet_01v8 L=0.15 W=0.84 nf=1 m=1
XXpi_rh2_XP rh2 rhb2 vdd vdd sky130_fd_pr__pfet_01v8 L=0.15 W=1.68 nf=1 m=1
XXpi_rh2_XN rh2 rhb2 vss vss sky130_fd_pr__nfet_01v8 L=0.15 W=0.84 nf=1 m=1
XXpd_rh3_XP1 rhb3 a7 vdd vdd sky130_fd_pr__pfet_01v8 L=0.15 W=0.84 nf=1 m=1
XXpd_rh3_XP2 rhb3 a6 vdd vdd sky130_fd_pr__pfet_01v8 L=0.15 W=0.84 nf=1 m=1
XXpd_rh3_XN1 rhb3 a7 Xpd_rh3.n1 vss sky130_fd_pr__nfet_01v8 L=0.15 W=0.84 nf=1 m=1
XXpd_rh3_XN2 Xpd_rh3.n1 a6 vss vss sky130_fd_pr__nfet_01v8 L=0.15 W=0.84 nf=1 m=1
XXpi_rh3_XP rh3 rhb3 vdd vdd sky130_fd_pr__pfet_01v8 L=0.15 W=1.68 nf=1 m=1
XXpi_rh3_XN rh3 rhb3 vss vss sky130_fd_pr__nfet_01v8 L=0.15 W=0.84 nf=1 m=1
XXpd_rl0_XP1 rlb0 ab5 vdd vdd sky130_fd_pr__pfet_01v8 L=0.15 W=0.84 nf=1 m=1
XXpd_rl0_XP2 rlb0 ab4 vdd vdd sky130_fd_pr__pfet_01v8 L=0.15 W=0.84 nf=1 m=1
XXpd_rl0_XN1 rlb0 ab5 Xpd_rl0.n1 vss sky130_fd_pr__nfet_01v8 L=0.15 W=0.84 nf=1 m=1
XXpd_rl0_XN2 Xpd_rl0.n1 ab4 vss vss sky130_fd_pr__nfet_01v8 L=0.15 W=0.84 nf=1 m=1
XXpi_rl0_XP rl0 rlb0 vdd vdd sky130_fd_pr__pfet_01v8 L=0.15 W=1.68 nf=1 m=1
XXpi_rl0_XN rl0 rlb0 vss vss sky130_fd_pr__nfet_01v8 L=0.15 W=0.84 nf=1 m=1
XXpd_rl1_XP1 rlb1 ab5 vdd vdd sky130_fd_pr__pfet_01v8 L=0.15 W=0.84 nf=1 m=1
XXpd_rl1_XP2 rlb1 a4 vdd vdd sky130_fd_pr__pfet_01v8 L=0.15 W=0.84 nf=1 m=1
XXpd_rl1_XN1 rlb1 ab5 Xpd_rl1.n1 vss sky130_fd_pr__nfet_01v8 L=0.15 W=0.84 nf=1 m=1
XXpd_rl1_XN2 Xpd_rl1.n1 a4 vss vss sky130_fd_pr__nfet_01v8 L=0.15 W=0.84 nf=1 m=1
XXpi_rl1_XP rl1 rlb1 vdd vdd sky130_fd_pr__pfet_01v8 L=0.15 W=1.68 nf=1 m=1
XXpi_rl1_XN rl1 rlb1 vss vss sky130_fd_pr__nfet_01v8 L=0.15 W=0.84 nf=1 m=1
XXpd_rl2_XP1 rlb2 a5 vdd vdd sky130_fd_pr__pfet_01v8 L=0.15 W=0.84 nf=1 m=1
XXpd_rl2_XP2 rlb2 ab4 vdd vdd sky130_fd_pr__pfet_01v8 L=0.15 W=0.84 nf=1 m=1
XXpd_rl2_XN1 rlb2 a5 Xpd_rl2.n1 vss sky130_fd_pr__nfet_01v8 L=0.15 W=0.84 nf=1 m=1
XXpd_rl2_XN2 Xpd_rl2.n1 ab4 vss vss sky130_fd_pr__nfet_01v8 L=0.15 W=0.84 nf=1 m=1
XXpi_rl2_XP rl2 rlb2 vdd vdd sky130_fd_pr__pfet_01v8 L=0.15 W=1.68 nf=1 m=1
XXpi_rl2_XN rl2 rlb2 vss vss sky130_fd_pr__nfet_01v8 L=0.15 W=0.84 nf=1 m=1
XXpd_rl3_XP1 rlb3 a5 vdd vdd sky130_fd_pr__pfet_01v8 L=0.15 W=0.84 nf=1 m=1
XXpd_rl3_XP2 rlb3 a4 vdd vdd sky130_fd_pr__pfet_01v8 L=0.15 W=0.84 nf=1 m=1
XXpd_rl3_XN1 rlb3 a5 Xpd_rl3.n1 vss sky130_fd_pr__nfet_01v8 L=0.15 W=0.84 nf=1 m=1
XXpd_rl3_XN2 Xpd_rl3.n1 a4 vss vss sky130_fd_pr__nfet_01v8 L=0.15 W=0.84 nf=1 m=1
XXpi_rl3_XP rl3 rlb3 vdd vdd sky130_fd_pr__pfet_01v8 L=0.15 W=1.68 nf=1 m=1
XXpi_rl3_XN rl3 rlb3 vss vss sky130_fd_pr__nfet_01v8 L=0.15 W=0.84 nf=1 m=1
XXpd_ch0_XP1 chb0 ab3 vdd vdd sky130_fd_pr__pfet_01v8 L=0.15 W=0.84 nf=1 m=1
XXpd_ch0_XP2 chb0 ab2 vdd vdd sky130_fd_pr__pfet_01v8 L=0.15 W=0.84 nf=1 m=1
XXpd_ch0_XN1 chb0 ab3 Xpd_ch0.n1 vss sky130_fd_pr__nfet_01v8 L=0.15 W=0.84 nf=1 m=1
XXpd_ch0_XN2 Xpd_ch0.n1 ab2 vss vss sky130_fd_pr__nfet_01v8 L=0.15 W=0.84 nf=1 m=1
XXpi_ch0_XP ch0 chb0 vdd vdd sky130_fd_pr__pfet_01v8 L=0.15 W=1.68 nf=1 m=1
XXpi_ch0_XN ch0 chb0 vss vss sky130_fd_pr__nfet_01v8 L=0.15 W=0.84 nf=1 m=1
XXpd_ch1_XP1 chb1 ab3 vdd vdd sky130_fd_pr__pfet_01v8 L=0.15 W=0.84 nf=1 m=1
XXpd_ch1_XP2 chb1 a2 vdd vdd sky130_fd_pr__pfet_01v8 L=0.15 W=0.84 nf=1 m=1
XXpd_ch1_XN1 chb1 ab3 Xpd_ch1.n1 vss sky130_fd_pr__nfet_01v8 L=0.15 W=0.84 nf=1 m=1
XXpd_ch1_XN2 Xpd_ch1.n1 a2 vss vss sky130_fd_pr__nfet_01v8 L=0.15 W=0.84 nf=1 m=1
XXpi_ch1_XP ch1 chb1 vdd vdd sky130_fd_pr__pfet_01v8 L=0.15 W=1.68 nf=1 m=1
XXpi_ch1_XN ch1 chb1 vss vss sky130_fd_pr__nfet_01v8 L=0.15 W=0.84 nf=1 m=1
XXpd_ch2_XP1 chb2 a3 vdd vdd sky130_fd_pr__pfet_01v8 L=0.15 W=0.84 nf=1 m=1
XXpd_ch2_XP2 chb2 ab2 vdd vdd sky130_fd_pr__pfet_01v8 L=0.15 W=0.84 nf=1 m=1
XXpd_ch2_XN1 chb2 a3 Xpd_ch2.n1 vss sky130_fd_pr__nfet_01v8 L=0.15 W=0.84 nf=1 m=1
XXpd_ch2_XN2 Xpd_ch2.n1 ab2 vss vss sky130_fd_pr__nfet_01v8 L=0.15 W=0.84 nf=1 m=1
XXpi_ch2_XP ch2 chb2 vdd vdd sky130_fd_pr__pfet_01v8 L=0.15 W=1.68 nf=1 m=1
XXpi_ch2_XN ch2 chb2 vss vss sky130_fd_pr__nfet_01v8 L=0.15 W=0.84 nf=1 m=1
XXpd_ch3_XP1 chb3 a3 vdd vdd sky130_fd_pr__pfet_01v8 L=0.15 W=0.84 nf=1 m=1
XXpd_ch3_XP2 chb3 a2 vdd vdd sky130_fd_pr__pfet_01v8 L=0.15 W=0.84 nf=1 m=1
XXpd_ch3_XN1 chb3 a3 Xpd_ch3.n1 vss sky130_fd_pr__nfet_01v8 L=0.15 W=0.84 nf=1 m=1
XXpd_ch3_XN2 Xpd_ch3.n1 a2 vss vss sky130_fd_pr__nfet_01v8 L=0.15 W=0.84 nf=1 m=1
XXpi_ch3_XP ch3 chb3 vdd vdd sky130_fd_pr__pfet_01v8 L=0.15 W=1.68 nf=1 m=1
XXpi_ch3_XN ch3 chb3 vss vss sky130_fd_pr__nfet_01v8 L=0.15 W=0.84 nf=1 m=1
XXpd_cl0_XP1 clb0 ab1 vdd vdd sky130_fd_pr__pfet_01v8 L=0.15 W=0.84 nf=1 m=1
XXpd_cl0_XP2 clb0 ab0 vdd vdd sky130_fd_pr__pfet_01v8 L=0.15 W=0.84 nf=1 m=1
XXpd_cl0_XN1 clb0 ab1 Xpd_cl0.n1 vss sky130_fd_pr__nfet_01v8 L=0.15 W=0.84 nf=1 m=1
XXpd_cl0_XN2 Xpd_cl0.n1 ab0 vss vss sky130_fd_pr__nfet_01v8 L=0.15 W=0.84 nf=1 m=1
XXpi_cl0_XP cl0 clb0 vdd vdd sky130_fd_pr__pfet_01v8 L=0.15 W=1.68 nf=1 m=1
XXpi_cl0_XN cl0 clb0 vss vss sky130_fd_pr__nfet_01v8 L=0.15 W=0.84 nf=1 m=1
XXpd_cl1_XP1 clb1 ab1 vdd vdd sky130_fd_pr__pfet_01v8 L=0.15 W=0.84 nf=1 m=1
XXpd_cl1_XP2 clb1 a0 vdd vdd sky130_fd_pr__pfet_01v8 L=0.15 W=0.84 nf=1 m=1
XXpd_cl1_XN1 clb1 ab1 Xpd_cl1.n1 vss sky130_fd_pr__nfet_01v8 L=0.15 W=0.84 nf=1 m=1
XXpd_cl1_XN2 Xpd_cl1.n1 a0 vss vss sky130_fd_pr__nfet_01v8 L=0.15 W=0.84 nf=1 m=1
XXpi_cl1_XP cl1 clb1 vdd vdd sky130_fd_pr__pfet_01v8 L=0.15 W=1.68 nf=1 m=1
XXpi_cl1_XN cl1 clb1 vss vss sky130_fd_pr__nfet_01v8 L=0.15 W=0.84 nf=1 m=1
XXpd_cl2_XP1 clb2 a1 vdd vdd sky130_fd_pr__pfet_01v8 L=0.15 W=0.84 nf=1 m=1
XXpd_cl2_XP2 clb2 ab0 vdd vdd sky130_fd_pr__pfet_01v8 L=0.15 W=0.84 nf=1 m=1
XXpd_cl2_XN1 clb2 a1 Xpd_cl2.n1 vss sky130_fd_pr__nfet_01v8 L=0.15 W=0.84 nf=1 m=1
XXpd_cl2_XN2 Xpd_cl2.n1 ab0 vss vss sky130_fd_pr__nfet_01v8 L=0.15 W=0.84 nf=1 m=1
XXpi_cl2_XP cl2 clb2 vdd vdd sky130_fd_pr__pfet_01v8 L=0.15 W=1.68 nf=1 m=1
XXpi_cl2_XN cl2 clb2 vss vss sky130_fd_pr__nfet_01v8 L=0.15 W=0.84 nf=1 m=1
XXpd_cl3_XP1 clb3 a1 vdd vdd sky130_fd_pr__pfet_01v8 L=0.15 W=0.84 nf=1 m=1
XXpd_cl3_XP2 clb3 a0 vdd vdd sky130_fd_pr__pfet_01v8 L=0.15 W=0.84 nf=1 m=1
XXpd_cl3_XN1 clb3 a1 Xpd_cl3.n1 vss sky130_fd_pr__nfet_01v8 L=0.15 W=0.84 nf=1 m=1
XXpd_cl3_XN2 Xpd_cl3.n1 a0 vss vss sky130_fd_pr__nfet_01v8 L=0.15 W=0.84 nf=1 m=1
XXpi_cl3_XP cl3 clb3 vdd vdd sky130_fd_pr__pfet_01v8 L=0.15 W=1.68 nf=1 m=1
XXpi_cl3_XN cl3 clb3 vss vss sky130_fd_pr__nfet_01v8 L=0.15 W=0.84 nf=1 m=1
XXrd0_XP1 wlb0 rh0 vdd vdd sky130_fd_pr__pfet_01v8 L=0.15 W=0.84 nf=1 m=1
XXrd0_XP2 wlb0 rl0 vdd vdd sky130_fd_pr__pfet_01v8 L=0.15 W=0.84 nf=1 m=1
XXrd0_XP3 wlb0 clkb vdd vdd sky130_fd_pr__pfet_01v8 L=0.15 W=0.84 nf=1 m=1
XXrd0_XN1 wlb0 rh0 Xrd0.n1 vss sky130_fd_pr__nfet_01v8 L=0.15 W=1.26 nf=1 m=1
XXrd0_XN2 Xrd0.n1 rl0 Xrd0.n2 vss sky130_fd_pr__nfet_01v8 L=0.15 W=1.26 nf=1 m=1
XXrd0_XN3 Xrd0.n2 clkb vss vss sky130_fd_pr__nfet_01v8 L=0.15 W=1.26 nf=1 m=1
XXwd0_XP wl0 wlb0 vdd vdd sky130_fd_pr__pfet_01v8 L=0.15 W=1.68 nf=1 m=1
XXwd0_XN wl0 wlb0 vss vss sky130_fd_pr__nfet_01v8 L=0.15 W=0.84 nf=1 m=1
XXrd1_XP1 wlb1 rh0 vdd vdd sky130_fd_pr__pfet_01v8 L=0.15 W=0.84 nf=1 m=1
XXrd1_XP2 wlb1 rl1 vdd vdd sky130_fd_pr__pfet_01v8 L=0.15 W=0.84 nf=1 m=1
XXrd1_XP3 wlb1 clkb vdd vdd sky130_fd_pr__pfet_01v8 L=0.15 W=0.84 nf=1 m=1
XXrd1_XN1 wlb1 rh0 Xrd1.n1 vss sky130_fd_pr__nfet_01v8 L=0.15 W=1.26 nf=1 m=1
XXrd1_XN2 Xrd1.n1 rl1 Xrd1.n2 vss sky130_fd_pr__nfet_01v8 L=0.15 W=1.26 nf=1 m=1
XXrd1_XN3 Xrd1.n2 clkb vss vss sky130_fd_pr__nfet_01v8 L=0.15 W=1.26 nf=1 m=1
XXwd1_XP wl1 wlb1 vdd vdd sky130_fd_pr__pfet_01v8 L=0.15 W=1.68 nf=1 m=1
XXwd1_XN wl1 wlb1 vss vss sky130_fd_pr__nfet_01v8 L=0.15 W=0.84 nf=1 m=1
XXrd2_XP1 wlb2 rh0 vdd vdd sky130_fd_pr__pfet_01v8 L=0.15 W=0.84 nf=1 m=1
XXrd2_XP2 wlb2 rl2 vdd vdd sky130_fd_pr__pfet_01v8 L=0.15 W=0.84 nf=1 m=1
XXrd2_XP3 wlb2 clkb vdd vdd sky130_fd_pr__pfet_01v8 L=0.15 W=0.84 nf=1 m=1
XXrd2_XN1 wlb2 rh0 Xrd2.n1 vss sky130_fd_pr__nfet_01v8 L=0.15 W=1.26 nf=1 m=1
XXrd2_XN2 Xrd2.n1 rl2 Xrd2.n2 vss sky130_fd_pr__nfet_01v8 L=0.15 W=1.26 nf=1 m=1
XXrd2_XN3 Xrd2.n2 clkb vss vss sky130_fd_pr__nfet_01v8 L=0.15 W=1.26 nf=1 m=1
XXwd2_XP wl2 wlb2 vdd vdd sky130_fd_pr__pfet_01v8 L=0.15 W=1.68 nf=1 m=1
XXwd2_XN wl2 wlb2 vss vss sky130_fd_pr__nfet_01v8 L=0.15 W=0.84 nf=1 m=1
XXrd3_XP1 wlb3 rh0 vdd vdd sky130_fd_pr__pfet_01v8 L=0.15 W=0.84 nf=1 m=1
XXrd3_XP2 wlb3 rl3 vdd vdd sky130_fd_pr__pfet_01v8 L=0.15 W=0.84 nf=1 m=1
XXrd3_XP3 wlb3 clkb vdd vdd sky130_fd_pr__pfet_01v8 L=0.15 W=0.84 nf=1 m=1
XXrd3_XN1 wlb3 rh0 Xrd3.n1 vss sky130_fd_pr__nfet_01v8 L=0.15 W=1.26 nf=1 m=1
XXrd3_XN2 Xrd3.n1 rl3 Xrd3.n2 vss sky130_fd_pr__nfet_01v8 L=0.15 W=1.26 nf=1 m=1
XXrd3_XN3 Xrd3.n2 clkb vss vss sky130_fd_pr__nfet_01v8 L=0.15 W=1.26 nf=1 m=1
XXwd3_XP wl3 wlb3 vdd vdd sky130_fd_pr__pfet_01v8 L=0.15 W=1.68 nf=1 m=1
XXwd3_XN wl3 wlb3 vss vss sky130_fd_pr__nfet_01v8 L=0.15 W=0.84 nf=1 m=1
XXrd4_XP1 wlb4 rh1 vdd vdd sky130_fd_pr__pfet_01v8 L=0.15 W=0.84 nf=1 m=1
XXrd4_XP2 wlb4 rl0 vdd vdd sky130_fd_pr__pfet_01v8 L=0.15 W=0.84 nf=1 m=1
XXrd4_XP3 wlb4 clkb vdd vdd sky130_fd_pr__pfet_01v8 L=0.15 W=0.84 nf=1 m=1
XXrd4_XN1 wlb4 rh1 Xrd4.n1 vss sky130_fd_pr__nfet_01v8 L=0.15 W=1.26 nf=1 m=1
XXrd4_XN2 Xrd4.n1 rl0 Xrd4.n2 vss sky130_fd_pr__nfet_01v8 L=0.15 W=1.26 nf=1 m=1
XXrd4_XN3 Xrd4.n2 clkb vss vss sky130_fd_pr__nfet_01v8 L=0.15 W=1.26 nf=1 m=1
XXwd4_XP wl4 wlb4 vdd vdd sky130_fd_pr__pfet_01v8 L=0.15 W=1.68 nf=1 m=1
XXwd4_XN wl4 wlb4 vss vss sky130_fd_pr__nfet_01v8 L=0.15 W=0.84 nf=1 m=1
XXrd5_XP1 wlb5 rh1 vdd vdd sky130_fd_pr__pfet_01v8 L=0.15 W=0.84 nf=1 m=1
XXrd5_XP2 wlb5 rl1 vdd vdd sky130_fd_pr__pfet_01v8 L=0.15 W=0.84 nf=1 m=1
XXrd5_XP3 wlb5 clkb vdd vdd sky130_fd_pr__pfet_01v8 L=0.15 W=0.84 nf=1 m=1
XXrd5_XN1 wlb5 rh1 Xrd5.n1 vss sky130_fd_pr__nfet_01v8 L=0.15 W=1.26 nf=1 m=1
XXrd5_XN2 Xrd5.n1 rl1 Xrd5.n2 vss sky130_fd_pr__nfet_01v8 L=0.15 W=1.26 nf=1 m=1
XXrd5_XN3 Xrd5.n2 clkb vss vss sky130_fd_pr__nfet_01v8 L=0.15 W=1.26 nf=1 m=1
XXwd5_XP wl5 wlb5 vdd vdd sky130_fd_pr__pfet_01v8 L=0.15 W=1.68 nf=1 m=1
XXwd5_XN wl5 wlb5 vss vss sky130_fd_pr__nfet_01v8 L=0.15 W=0.84 nf=1 m=1
XXrd6_XP1 wlb6 rh1 vdd vdd sky130_fd_pr__pfet_01v8 L=0.15 W=0.84 nf=1 m=1
XXrd6_XP2 wlb6 rl2 vdd vdd sky130_fd_pr__pfet_01v8 L=0.15 W=0.84 nf=1 m=1
XXrd6_XP3 wlb6 clkb vdd vdd sky130_fd_pr__pfet_01v8 L=0.15 W=0.84 nf=1 m=1
XXrd6_XN1 wlb6 rh1 Xrd6.n1 vss sky130_fd_pr__nfet_01v8 L=0.15 W=1.26 nf=1 m=1
XXrd6_XN2 Xrd6.n1 rl2 Xrd6.n2 vss sky130_fd_pr__nfet_01v8 L=0.15 W=1.26 nf=1 m=1
XXrd6_XN3 Xrd6.n2 clkb vss vss sky130_fd_pr__nfet_01v8 L=0.15 W=1.26 nf=1 m=1
XXwd6_XP wl6 wlb6 vdd vdd sky130_fd_pr__pfet_01v8 L=0.15 W=1.68 nf=1 m=1
XXwd6_XN wl6 wlb6 vss vss sky130_fd_pr__nfet_01v8 L=0.15 W=0.84 nf=1 m=1
XXrd7_XP1 wlb7 rh1 vdd vdd sky130_fd_pr__pfet_01v8 L=0.15 W=0.84 nf=1 m=1
XXrd7_XP2 wlb7 rl3 vdd vdd sky130_fd_pr__pfet_01v8 L=0.15 W=0.84 nf=1 m=1
XXrd7_XP3 wlb7 clkb vdd vdd sky130_fd_pr__pfet_01v8 L=0.15 W=0.84 nf=1 m=1
XXrd7_XN1 wlb7 rh1 Xrd7.n1 vss sky130_fd_pr__nfet_01v8 L=0.15 W=1.26 nf=1 m=1
XXrd7_XN2 Xrd7.n1 rl3 Xrd7.n2 vss sky130_fd_pr__nfet_01v8 L=0.15 W=1.26 nf=1 m=1
XXrd7_XN3 Xrd7.n2 clkb vss vss sky130_fd_pr__nfet_01v8 L=0.15 W=1.26 nf=1 m=1
XXwd7_XP wl7 wlb7 vdd vdd sky130_fd_pr__pfet_01v8 L=0.15 W=1.68 nf=1 m=1
XXwd7_XN wl7 wlb7 vss vss sky130_fd_pr__nfet_01v8 L=0.15 W=0.84 nf=1 m=1
XXrd8_XP1 wlb8 rh2 vdd vdd sky130_fd_pr__pfet_01v8 L=0.15 W=0.84 nf=1 m=1
XXrd8_XP2 wlb8 rl0 vdd vdd sky130_fd_pr__pfet_01v8 L=0.15 W=0.84 nf=1 m=1
XXrd8_XP3 wlb8 clkb vdd vdd sky130_fd_pr__pfet_01v8 L=0.15 W=0.84 nf=1 m=1
XXrd8_XN1 wlb8 rh2 Xrd8.n1 vss sky130_fd_pr__nfet_01v8 L=0.15 W=1.26 nf=1 m=1
XXrd8_XN2 Xrd8.n1 rl0 Xrd8.n2 vss sky130_fd_pr__nfet_01v8 L=0.15 W=1.26 nf=1 m=1
XXrd8_XN3 Xrd8.n2 clkb vss vss sky130_fd_pr__nfet_01v8 L=0.15 W=1.26 nf=1 m=1
XXwd8_XP wl8 wlb8 vdd vdd sky130_fd_pr__pfet_01v8 L=0.15 W=1.68 nf=1 m=1
XXwd8_XN wl8 wlb8 vss vss sky130_fd_pr__nfet_01v8 L=0.15 W=0.84 nf=1 m=1
XXrd9_XP1 wlb9 rh2 vdd vdd sky130_fd_pr__pfet_01v8 L=0.15 W=0.84 nf=1 m=1
XXrd9_XP2 wlb9 rl1 vdd vdd sky130_fd_pr__pfet_01v8 L=0.15 W=0.84 nf=1 m=1
XXrd9_XP3 wlb9 clkb vdd vdd sky130_fd_pr__pfet_01v8 L=0.15 W=0.84 nf=1 m=1
XXrd9_XN1 wlb9 rh2 Xrd9.n1 vss sky130_fd_pr__nfet_01v8 L=0.15 W=1.26 nf=1 m=1
XXrd9_XN2 Xrd9.n1 rl1 Xrd9.n2 vss sky130_fd_pr__nfet_01v8 L=0.15 W=1.26 nf=1 m=1
XXrd9_XN3 Xrd9.n2 clkb vss vss sky130_fd_pr__nfet_01v8 L=0.15 W=1.26 nf=1 m=1
XXwd9_XP wl9 wlb9 vdd vdd sky130_fd_pr__pfet_01v8 L=0.15 W=1.68 nf=1 m=1
XXwd9_XN wl9 wlb9 vss vss sky130_fd_pr__nfet_01v8 L=0.15 W=0.84 nf=1 m=1
XXrd10_XP1 wlb10 rh2 vdd vdd sky130_fd_pr__pfet_01v8 L=0.15 W=0.84 nf=1 m=1
XXrd10_XP2 wlb10 rl2 vdd vdd sky130_fd_pr__pfet_01v8 L=0.15 W=0.84 nf=1 m=1
XXrd10_XP3 wlb10 clkb vdd vdd sky130_fd_pr__pfet_01v8 L=0.15 W=0.84 nf=1 m=1
XXrd10_XN1 wlb10 rh2 Xrd10.n1 vss sky130_fd_pr__nfet_01v8 L=0.15 W=1.26 nf=1 m=1
XXrd10_XN2 Xrd10.n1 rl2 Xrd10.n2 vss sky130_fd_pr__nfet_01v8 L=0.15 W=1.26 nf=1 m=1
XXrd10_XN3 Xrd10.n2 clkb vss vss sky130_fd_pr__nfet_01v8 L=0.15 W=1.26 nf=1 m=1
XXwd10_XP wl10 wlb10 vdd vdd sky130_fd_pr__pfet_01v8 L=0.15 W=1.68 nf=1 m=1
XXwd10_XN wl10 wlb10 vss vss sky130_fd_pr__nfet_01v8 L=0.15 W=0.84 nf=1 m=1
XXrd11_XP1 wlb11 rh2 vdd vdd sky130_fd_pr__pfet_01v8 L=0.15 W=0.84 nf=1 m=1
XXrd11_XP2 wlb11 rl3 vdd vdd sky130_fd_pr__pfet_01v8 L=0.15 W=0.84 nf=1 m=1
XXrd11_XP3 wlb11 clkb vdd vdd sky130_fd_pr__pfet_01v8 L=0.15 W=0.84 nf=1 m=1
XXrd11_XN1 wlb11 rh2 Xrd11.n1 vss sky130_fd_pr__nfet_01v8 L=0.15 W=1.26 nf=1 m=1
XXrd11_XN2 Xrd11.n1 rl3 Xrd11.n2 vss sky130_fd_pr__nfet_01v8 L=0.15 W=1.26 nf=1 m=1
XXrd11_XN3 Xrd11.n2 clkb vss vss sky130_fd_pr__nfet_01v8 L=0.15 W=1.26 nf=1 m=1
XXwd11_XP wl11 wlb11 vdd vdd sky130_fd_pr__pfet_01v8 L=0.15 W=1.68 nf=1 m=1
XXwd11_XN wl11 wlb11 vss vss sky130_fd_pr__nfet_01v8 L=0.15 W=0.84 nf=1 m=1
XXrd12_XP1 wlb12 rh3 vdd vdd sky130_fd_pr__pfet_01v8 L=0.15 W=0.84 nf=1 m=1
XXrd12_XP2 wlb12 rl0 vdd vdd sky130_fd_pr__pfet_01v8 L=0.15 W=0.84 nf=1 m=1
XXrd12_XP3 wlb12 clkb vdd vdd sky130_fd_pr__pfet_01v8 L=0.15 W=0.84 nf=1 m=1
XXrd12_XN1 wlb12 rh3 Xrd12.n1 vss sky130_fd_pr__nfet_01v8 L=0.15 W=1.26 nf=1 m=1
XXrd12_XN2 Xrd12.n1 rl0 Xrd12.n2 vss sky130_fd_pr__nfet_01v8 L=0.15 W=1.26 nf=1 m=1
XXrd12_XN3 Xrd12.n2 clkb vss vss sky130_fd_pr__nfet_01v8 L=0.15 W=1.26 nf=1 m=1
XXwd12_XP wl12 wlb12 vdd vdd sky130_fd_pr__pfet_01v8 L=0.15 W=1.68 nf=1 m=1
XXwd12_XN wl12 wlb12 vss vss sky130_fd_pr__nfet_01v8 L=0.15 W=0.84 nf=1 m=1
XXrd13_XP1 wlb13 rh3 vdd vdd sky130_fd_pr__pfet_01v8 L=0.15 W=0.84 nf=1 m=1
XXrd13_XP2 wlb13 rl1 vdd vdd sky130_fd_pr__pfet_01v8 L=0.15 W=0.84 nf=1 m=1
XXrd13_XP3 wlb13 clkb vdd vdd sky130_fd_pr__pfet_01v8 L=0.15 W=0.84 nf=1 m=1
XXrd13_XN1 wlb13 rh3 Xrd13.n1 vss sky130_fd_pr__nfet_01v8 L=0.15 W=1.26 nf=1 m=1
XXrd13_XN2 Xrd13.n1 rl1 Xrd13.n2 vss sky130_fd_pr__nfet_01v8 L=0.15 W=1.26 nf=1 m=1
XXrd13_XN3 Xrd13.n2 clkb vss vss sky130_fd_pr__nfet_01v8 L=0.15 W=1.26 nf=1 m=1
XXwd13_XP wl13 wlb13 vdd vdd sky130_fd_pr__pfet_01v8 L=0.15 W=1.68 nf=1 m=1
XXwd13_XN wl13 wlb13 vss vss sky130_fd_pr__nfet_01v8 L=0.15 W=0.84 nf=1 m=1
XXrd14_XP1 wlb14 rh3 vdd vdd sky130_fd_pr__pfet_01v8 L=0.15 W=0.84 nf=1 m=1
XXrd14_XP2 wlb14 rl2 vdd vdd sky130_fd_pr__pfet_01v8 L=0.15 W=0.84 nf=1 m=1
XXrd14_XP3 wlb14 clkb vdd vdd sky130_fd_pr__pfet_01v8 L=0.15 W=0.84 nf=1 m=1
XXrd14_XN1 wlb14 rh3 Xrd14.n1 vss sky130_fd_pr__nfet_01v8 L=0.15 W=1.26 nf=1 m=1
XXrd14_XN2 Xrd14.n1 rl2 Xrd14.n2 vss sky130_fd_pr__nfet_01v8 L=0.15 W=1.26 nf=1 m=1
XXrd14_XN3 Xrd14.n2 clkb vss vss sky130_fd_pr__nfet_01v8 L=0.15 W=1.26 nf=1 m=1
XXwd14_XP wl14 wlb14 vdd vdd sky130_fd_pr__pfet_01v8 L=0.15 W=1.68 nf=1 m=1
XXwd14_XN wl14 wlb14 vss vss sky130_fd_pr__nfet_01v8 L=0.15 W=0.84 nf=1 m=1
XXrd15_XP1 wlb15 rh3 vdd vdd sky130_fd_pr__pfet_01v8 L=0.15 W=0.84 nf=1 m=1
XXrd15_XP2 wlb15 rl3 vdd vdd sky130_fd_pr__pfet_01v8 L=0.15 W=0.84 nf=1 m=1
XXrd15_XP3 wlb15 clkb vdd vdd sky130_fd_pr__pfet_01v8 L=0.15 W=0.84 nf=1 m=1
XXrd15_XN1 wlb15 rh3 Xrd15.n1 vss sky130_fd_pr__nfet_01v8 L=0.15 W=1.26 nf=1 m=1
XXrd15_XN2 Xrd15.n1 rl3 Xrd15.n2 vss sky130_fd_pr__nfet_01v8 L=0.15 W=1.26 nf=1 m=1
XXrd15_XN3 Xrd15.n2 clkb vss vss sky130_fd_pr__nfet_01v8 L=0.15 W=1.26 nf=1 m=1
XXwd15_XP wl15 wlb15 vdd vdd sky130_fd_pr__pfet_01v8 L=0.15 W=1.68 nf=1 m=1
XXwd15_XN wl15 wlb15 vss vss sky130_fd_pr__nfet_01v8 L=0.15 W=0.84 nf=1 m=1
XXcd0_XP1 cselb0 ch0 vdd vdd sky130_fd_pr__pfet_01v8 L=0.15 W=0.84 nf=1 m=1
XXcd0_XP2 cselb0 cl0 vdd vdd sky130_fd_pr__pfet_01v8 L=0.15 W=0.84 nf=1 m=1
XXcd0_XN1 cselb0 ch0 Xcd0.n1 vss sky130_fd_pr__nfet_01v8 L=0.15 W=0.84 nf=1 m=1
XXcd0_XN2 Xcd0.n1 cl0 vss vss sky130_fd_pr__nfet_01v8 L=0.15 W=0.84 nf=1 m=1
XXcs0_XP csel0 cselb0 vdd vdd sky130_fd_pr__pfet_01v8 L=0.15 W=1.68 nf=1 m=1
XXcs0_XN csel0 cselb0 vss vss sky130_fd_pr__nfet_01v8 L=0.15 W=0.84 nf=1 m=1
XXcd1_XP1 cselb1 ch0 vdd vdd sky130_fd_pr__pfet_01v8 L=0.15 W=0.84 nf=1 m=1
XXcd1_XP2 cselb1 cl1 vdd vdd sky130_fd_pr__pfet_01v8 L=0.15 W=0.84 nf=1 m=1
XXcd1_XN1 cselb1 ch0 Xcd1.n1 vss sky130_fd_pr__nfet_01v8 L=0.15 W=0.84 nf=1 m=1
XXcd1_XN2 Xcd1.n1 cl1 vss vss sky130_fd_pr__nfet_01v8 L=0.15 W=0.84 nf=1 m=1
XXcs1_XP csel1 cselb1 vdd vdd sky130_fd_pr__pfet_01v8 L=0.15 W=1.68 nf=1 m=1
XXcs1_XN csel1 cselb1 vss vss sky130_fd_pr__nfet_01v8 L=0.15 W=0.84 nf=1 m=1
XXcd2_XP1 cselb2 ch0 vdd vdd sky130_fd_pr__pfet_01v8 L=0.15 W=0.84 nf=1 m=1
XXcd2_XP2 cselb2 cl2 vdd vdd sky130_fd_pr__pfet_01v8 L=0.15 W=0.84 nf=1 m=1
XXcd2_XN1 cselb2 ch0 Xcd2.n1 vss sky130_fd_pr__nfet_01v8 L=0.15 W=0.84 nf=1 m=1
XXcd2_XN2 Xcd2.n1 cl2 vss vss sky130_fd_pr__nfet_01v8 L=0.15 W=0.84 nf=1 m=1
XXcs2_XP csel2 cselb2 vdd vdd sky130_fd_pr__pfet_01v8 L=0.15 W=1.68 nf=1 m=1
XXcs2_XN csel2 cselb2 vss vss sky130_fd_pr__nfet_01v8 L=0.15 W=0.84 nf=1 m=1
XXcd3_XP1 cselb3 ch0 vdd vdd sky130_fd_pr__pfet_01v8 L=0.15 W=0.84 nf=1 m=1
XXcd3_XP2 cselb3 cl3 vdd vdd sky130_fd_pr__pfet_01v8 L=0.15 W=0.84 nf=1 m=1
XXcd3_XN1 cselb3 ch0 Xcd3.n1 vss sky130_fd_pr__nfet_01v8 L=0.15 W=0.84 nf=1 m=1
XXcd3_XN2 Xcd3.n1 cl3 vss vss sky130_fd_pr__nfet_01v8 L=0.15 W=0.84 nf=1 m=1
XXcs3_XP csel3 cselb3 vdd vdd sky130_fd_pr__pfet_01v8 L=0.15 W=1.68 nf=1 m=1
XXcs3_XN csel3 cselb3 vss vss sky130_fd_pr__nfet_01v8 L=0.15 W=0.84 nf=1 m=1
XXcd4_XP1 cselb4 ch1 vdd vdd sky130_fd_pr__pfet_01v8 L=0.15 W=0.84 nf=1 m=1
XXcd4_XP2 cselb4 cl0 vdd vdd sky130_fd_pr__pfet_01v8 L=0.15 W=0.84 nf=1 m=1
XXcd4_XN1 cselb4 ch1 Xcd4.n1 vss sky130_fd_pr__nfet_01v8 L=0.15 W=0.84 nf=1 m=1
XXcd4_XN2 Xcd4.n1 cl0 vss vss sky130_fd_pr__nfet_01v8 L=0.15 W=0.84 nf=1 m=1
XXcs4_XP csel4 cselb4 vdd vdd sky130_fd_pr__pfet_01v8 L=0.15 W=1.68 nf=1 m=1
XXcs4_XN csel4 cselb4 vss vss sky130_fd_pr__nfet_01v8 L=0.15 W=0.84 nf=1 m=1
XXcd5_XP1 cselb5 ch1 vdd vdd sky130_fd_pr__pfet_01v8 L=0.15 W=0.84 nf=1 m=1
XXcd5_XP2 cselb5 cl1 vdd vdd sky130_fd_pr__pfet_01v8 L=0.15 W=0.84 nf=1 m=1
XXcd5_XN1 cselb5 ch1 Xcd5.n1 vss sky130_fd_pr__nfet_01v8 L=0.15 W=0.84 nf=1 m=1
XXcd5_XN2 Xcd5.n1 cl1 vss vss sky130_fd_pr__nfet_01v8 L=0.15 W=0.84 nf=1 m=1
XXcs5_XP csel5 cselb5 vdd vdd sky130_fd_pr__pfet_01v8 L=0.15 W=1.68 nf=1 m=1
XXcs5_XN csel5 cselb5 vss vss sky130_fd_pr__nfet_01v8 L=0.15 W=0.84 nf=1 m=1
XXcd6_XP1 cselb6 ch1 vdd vdd sky130_fd_pr__pfet_01v8 L=0.15 W=0.84 nf=1 m=1
XXcd6_XP2 cselb6 cl2 vdd vdd sky130_fd_pr__pfet_01v8 L=0.15 W=0.84 nf=1 m=1
XXcd6_XN1 cselb6 ch1 Xcd6.n1 vss sky130_fd_pr__nfet_01v8 L=0.15 W=0.84 nf=1 m=1
XXcd6_XN2 Xcd6.n1 cl2 vss vss sky130_fd_pr__nfet_01v8 L=0.15 W=0.84 nf=1 m=1
XXcs6_XP csel6 cselb6 vdd vdd sky130_fd_pr__pfet_01v8 L=0.15 W=1.68 nf=1 m=1
XXcs6_XN csel6 cselb6 vss vss sky130_fd_pr__nfet_01v8 L=0.15 W=0.84 nf=1 m=1
XXcd7_XP1 cselb7 ch1 vdd vdd sky130_fd_pr__pfet_01v8 L=0.15 W=0.84 nf=1 m=1
XXcd7_XP2 cselb7 cl3 vdd vdd sky130_fd_pr__pfet_01v8 L=0.15 W=0.84 nf=1 m=1
XXcd7_XN1 cselb7 ch1 Xcd7.n1 vss sky130_fd_pr__nfet_01v8 L=0.15 W=0.84 nf=1 m=1
XXcd7_XN2 Xcd7.n1 cl3 vss vss sky130_fd_pr__nfet_01v8 L=0.15 W=0.84 nf=1 m=1
XXcs7_XP csel7 cselb7 vdd vdd sky130_fd_pr__pfet_01v8 L=0.15 W=1.68 nf=1 m=1
XXcs7_XN csel7 cselb7 vss vss sky130_fd_pr__nfet_01v8 L=0.15 W=0.84 nf=1 m=1
XXcd8_XP1 cselb8 ch2 vdd vdd sky130_fd_pr__pfet_01v8 L=0.15 W=0.84 nf=1 m=1
XXcd8_XP2 cselb8 cl0 vdd vdd sky130_fd_pr__pfet_01v8 L=0.15 W=0.84 nf=1 m=1
XXcd8_XN1 cselb8 ch2 Xcd8.n1 vss sky130_fd_pr__nfet_01v8 L=0.15 W=0.84 nf=1 m=1
XXcd8_XN2 Xcd8.n1 cl0 vss vss sky130_fd_pr__nfet_01v8 L=0.15 W=0.84 nf=1 m=1
XXcs8_XP csel8 cselb8 vdd vdd sky130_fd_pr__pfet_01v8 L=0.15 W=1.68 nf=1 m=1
XXcs8_XN csel8 cselb8 vss vss sky130_fd_pr__nfet_01v8 L=0.15 W=0.84 nf=1 m=1
XXcd9_XP1 cselb9 ch2 vdd vdd sky130_fd_pr__pfet_01v8 L=0.15 W=0.84 nf=1 m=1
XXcd9_XP2 cselb9 cl1 vdd vdd sky130_fd_pr__pfet_01v8 L=0.15 W=0.84 nf=1 m=1
XXcd9_XN1 cselb9 ch2 Xcd9.n1 vss sky130_fd_pr__nfet_01v8 L=0.15 W=0.84 nf=1 m=1
XXcd9_XN2 Xcd9.n1 cl1 vss vss sky130_fd_pr__nfet_01v8 L=0.15 W=0.84 nf=1 m=1
XXcs9_XP csel9 cselb9 vdd vdd sky130_fd_pr__pfet_01v8 L=0.15 W=1.68 nf=1 m=1
XXcs9_XN csel9 cselb9 vss vss sky130_fd_pr__nfet_01v8 L=0.15 W=0.84 nf=1 m=1
XXcd10_XP1 cselb10 ch2 vdd vdd sky130_fd_pr__pfet_01v8 L=0.15 W=0.84 nf=1 m=1
XXcd10_XP2 cselb10 cl2 vdd vdd sky130_fd_pr__pfet_01v8 L=0.15 W=0.84 nf=1 m=1
XXcd10_XN1 cselb10 ch2 Xcd10.n1 vss sky130_fd_pr__nfet_01v8 L=0.15 W=0.84 nf=1 m=1
XXcd10_XN2 Xcd10.n1 cl2 vss vss sky130_fd_pr__nfet_01v8 L=0.15 W=0.84 nf=1 m=1
XXcs10_XP csel10 cselb10 vdd vdd sky130_fd_pr__pfet_01v8 L=0.15 W=1.68 nf=1 m=1
XXcs10_XN csel10 cselb10 vss vss sky130_fd_pr__nfet_01v8 L=0.15 W=0.84 nf=1 m=1
XXcd11_XP1 cselb11 ch2 vdd vdd sky130_fd_pr__pfet_01v8 L=0.15 W=0.84 nf=1 m=1
XXcd11_XP2 cselb11 cl3 vdd vdd sky130_fd_pr__pfet_01v8 L=0.15 W=0.84 nf=1 m=1
XXcd11_XN1 cselb11 ch2 Xcd11.n1 vss sky130_fd_pr__nfet_01v8 L=0.15 W=0.84 nf=1 m=1
XXcd11_XN2 Xcd11.n1 cl3 vss vss sky130_fd_pr__nfet_01v8 L=0.15 W=0.84 nf=1 m=1
XXcs11_XP csel11 cselb11 vdd vdd sky130_fd_pr__pfet_01v8 L=0.15 W=1.68 nf=1 m=1
XXcs11_XN csel11 cselb11 vss vss sky130_fd_pr__nfet_01v8 L=0.15 W=0.84 nf=1 m=1
XXcd12_XP1 cselb12 ch3 vdd vdd sky130_fd_pr__pfet_01v8 L=0.15 W=0.84 nf=1 m=1
XXcd12_XP2 cselb12 cl0 vdd vdd sky130_fd_pr__pfet_01v8 L=0.15 W=0.84 nf=1 m=1
XXcd12_XN1 cselb12 ch3 Xcd12.n1 vss sky130_fd_pr__nfet_01v8 L=0.15 W=0.84 nf=1 m=1
XXcd12_XN2 Xcd12.n1 cl0 vss vss sky130_fd_pr__nfet_01v8 L=0.15 W=0.84 nf=1 m=1
XXcs12_XP csel12 cselb12 vdd vdd sky130_fd_pr__pfet_01v8 L=0.15 W=1.68 nf=1 m=1
XXcs12_XN csel12 cselb12 vss vss sky130_fd_pr__nfet_01v8 L=0.15 W=0.84 nf=1 m=1
XXcd13_XP1 cselb13 ch3 vdd vdd sky130_fd_pr__pfet_01v8 L=0.15 W=0.84 nf=1 m=1
XXcd13_XP2 cselb13 cl1 vdd vdd sky130_fd_pr__pfet_01v8 L=0.15 W=0.84 nf=1 m=1
XXcd13_XN1 cselb13 ch3 Xcd13.n1 vss sky130_fd_pr__nfet_01v8 L=0.15 W=0.84 nf=1 m=1
XXcd13_XN2 Xcd13.n1 cl1 vss vss sky130_fd_pr__nfet_01v8 L=0.15 W=0.84 nf=1 m=1
XXcs13_XP csel13 cselb13 vdd vdd sky130_fd_pr__pfet_01v8 L=0.15 W=1.68 nf=1 m=1
XXcs13_XN csel13 cselb13 vss vss sky130_fd_pr__nfet_01v8 L=0.15 W=0.84 nf=1 m=1
XXcd14_XP1 cselb14 ch3 vdd vdd sky130_fd_pr__pfet_01v8 L=0.15 W=0.84 nf=1 m=1
XXcd14_XP2 cselb14 cl2 vdd vdd sky130_fd_pr__pfet_01v8 L=0.15 W=0.84 nf=1 m=1
XXcd14_XN1 cselb14 ch3 Xcd14.n1 vss sky130_fd_pr__nfet_01v8 L=0.15 W=0.84 nf=1 m=1
XXcd14_XN2 Xcd14.n1 cl2 vss vss sky130_fd_pr__nfet_01v8 L=0.15 W=0.84 nf=1 m=1
XXcs14_XP csel14 cselb14 vdd vdd sky130_fd_pr__pfet_01v8 L=0.15 W=1.68 nf=1 m=1
XXcs14_XN csel14 cselb14 vss vss sky130_fd_pr__nfet_01v8 L=0.15 W=0.84 nf=1 m=1
XXcd15_XP1 cselb15 ch3 vdd vdd sky130_fd_pr__pfet_01v8 L=0.15 W=0.84 nf=1 m=1
XXcd15_XP2 cselb15 cl3 vdd vdd sky130_fd_pr__pfet_01v8 L=0.15 W=0.84 nf=1 m=1
XXcd15_XN1 cselb15 ch3 Xcd15.n1 vss sky130_fd_pr__nfet_01v8 L=0.15 W=0.84 nf=1 m=1
XXcd15_XN2 Xcd15.n1 cl3 vss vss sky130_fd_pr__nfet_01v8 L=0.15 W=0.84 nf=1 m=1
XXcs15_XP csel15 cselb15 vdd vdd sky130_fd_pr__pfet_01v8 L=0.15 W=1.68 nf=1 m=1
XXcs15_XN csel15 cselb15 vss vss sky130_fd_pr__nfet_01v8 L=0.15 W=0.84 nf=1 m=1
XXc_0_0_XPU1 Xc_0_0.q Xc_0_0.qb vdd vdd sky130_fd_pr__pfet_01v8 L=0.15 W=0.42 nf=1 m=1
XXc_0_0_XPD1 Xc_0_0.q Xc_0_0.qb vss vss sky130_fd_pr__nfet_01v8 L=0.15 W=0.63 nf=1 m=1
XXc_0_0_XPU2 Xc_0_0.qb Xc_0_0.q vdd vdd sky130_fd_pr__pfet_01v8 L=0.15 W=0.42 nf=1 m=1
XXc_0_0_XPD2 Xc_0_0.qb Xc_0_0.q vss vss sky130_fd_pr__nfet_01v8 L=0.15 W=0.63 nf=1 m=1
XXc_0_0_XPG1 bl0 wl0 Xc_0_0.q vss sky130_fd_pr__nfet_01v8 L=0.15 W=0.42 nf=1 m=1
XXc_0_0_XPG2 blb0 wl0 Xc_0_0.qb vss sky130_fd_pr__nfet_01v8 L=0.15 W=0.42 nf=1 m=1
XXc_0_1_XPU1 Xc_0_1.q Xc_0_1.qb vdd vdd sky130_fd_pr__pfet_01v8 L=0.15 W=0.42 nf=1 m=1
XXc_0_1_XPD1 Xc_0_1.q Xc_0_1.qb vss vss sky130_fd_pr__nfet_01v8 L=0.15 W=0.63 nf=1 m=1
XXc_0_1_XPU2 Xc_0_1.qb Xc_0_1.q vdd vdd sky130_fd_pr__pfet_01v8 L=0.15 W=0.42 nf=1 m=1
XXc_0_1_XPD2 Xc_0_1.qb Xc_0_1.q vss vss sky130_fd_pr__nfet_01v8 L=0.15 W=0.63 nf=1 m=1
XXc_0_1_XPG1 bl1 wl0 Xc_0_1.q vss sky130_fd_pr__nfet_01v8 L=0.15 W=0.42 nf=1 m=1
XXc_0_1_XPG2 blb1 wl0 Xc_0_1.qb vss sky130_fd_pr__nfet_01v8 L=0.15 W=0.42 nf=1 m=1
XXc_0_2_XPU1 Xc_0_2.q Xc_0_2.qb vdd vdd sky130_fd_pr__pfet_01v8 L=0.15 W=0.42 nf=1 m=1
XXc_0_2_XPD1 Xc_0_2.q Xc_0_2.qb vss vss sky130_fd_pr__nfet_01v8 L=0.15 W=0.63 nf=1 m=1
XXc_0_2_XPU2 Xc_0_2.qb Xc_0_2.q vdd vdd sky130_fd_pr__pfet_01v8 L=0.15 W=0.42 nf=1 m=1
XXc_0_2_XPD2 Xc_0_2.qb Xc_0_2.q vss vss sky130_fd_pr__nfet_01v8 L=0.15 W=0.63 nf=1 m=1
XXc_0_2_XPG1 bl2 wl0 Xc_0_2.q vss sky130_fd_pr__nfet_01v8 L=0.15 W=0.42 nf=1 m=1
XXc_0_2_XPG2 blb2 wl0 Xc_0_2.qb vss sky130_fd_pr__nfet_01v8 L=0.15 W=0.42 nf=1 m=1
XXc_0_3_XPU1 Xc_0_3.q Xc_0_3.qb vdd vdd sky130_fd_pr__pfet_01v8 L=0.15 W=0.42 nf=1 m=1
XXc_0_3_XPD1 Xc_0_3.q Xc_0_3.qb vss vss sky130_fd_pr__nfet_01v8 L=0.15 W=0.63 nf=1 m=1
XXc_0_3_XPU2 Xc_0_3.qb Xc_0_3.q vdd vdd sky130_fd_pr__pfet_01v8 L=0.15 W=0.42 nf=1 m=1
XXc_0_3_XPD2 Xc_0_3.qb Xc_0_3.q vss vss sky130_fd_pr__nfet_01v8 L=0.15 W=0.63 nf=1 m=1
XXc_0_3_XPG1 bl3 wl0 Xc_0_3.q vss sky130_fd_pr__nfet_01v8 L=0.15 W=0.42 nf=1 m=1
XXc_0_3_XPG2 blb3 wl0 Xc_0_3.qb vss sky130_fd_pr__nfet_01v8 L=0.15 W=0.42 nf=1 m=1
XXc_0_4_XPU1 Xc_0_4.q Xc_0_4.qb vdd vdd sky130_fd_pr__pfet_01v8 L=0.15 W=0.42 nf=1 m=1
XXc_0_4_XPD1 Xc_0_4.q Xc_0_4.qb vss vss sky130_fd_pr__nfet_01v8 L=0.15 W=0.63 nf=1 m=1
XXc_0_4_XPU2 Xc_0_4.qb Xc_0_4.q vdd vdd sky130_fd_pr__pfet_01v8 L=0.15 W=0.42 nf=1 m=1
XXc_0_4_XPD2 Xc_0_4.qb Xc_0_4.q vss vss sky130_fd_pr__nfet_01v8 L=0.15 W=0.63 nf=1 m=1
XXc_0_4_XPG1 bl4 wl0 Xc_0_4.q vss sky130_fd_pr__nfet_01v8 L=0.15 W=0.42 nf=1 m=1
XXc_0_4_XPG2 blb4 wl0 Xc_0_4.qb vss sky130_fd_pr__nfet_01v8 L=0.15 W=0.42 nf=1 m=1
XXc_0_5_XPU1 Xc_0_5.q Xc_0_5.qb vdd vdd sky130_fd_pr__pfet_01v8 L=0.15 W=0.42 nf=1 m=1
XXc_0_5_XPD1 Xc_0_5.q Xc_0_5.qb vss vss sky130_fd_pr__nfet_01v8 L=0.15 W=0.63 nf=1 m=1
XXc_0_5_XPU2 Xc_0_5.qb Xc_0_5.q vdd vdd sky130_fd_pr__pfet_01v8 L=0.15 W=0.42 nf=1 m=1
XXc_0_5_XPD2 Xc_0_5.qb Xc_0_5.q vss vss sky130_fd_pr__nfet_01v8 L=0.15 W=0.63 nf=1 m=1
XXc_0_5_XPG1 bl5 wl0 Xc_0_5.q vss sky130_fd_pr__nfet_01v8 L=0.15 W=0.42 nf=1 m=1
XXc_0_5_XPG2 blb5 wl0 Xc_0_5.qb vss sky130_fd_pr__nfet_01v8 L=0.15 W=0.42 nf=1 m=1
XXc_0_6_XPU1 Xc_0_6.q Xc_0_6.qb vdd vdd sky130_fd_pr__pfet_01v8 L=0.15 W=0.42 nf=1 m=1
XXc_0_6_XPD1 Xc_0_6.q Xc_0_6.qb vss vss sky130_fd_pr__nfet_01v8 L=0.15 W=0.63 nf=1 m=1
XXc_0_6_XPU2 Xc_0_6.qb Xc_0_6.q vdd vdd sky130_fd_pr__pfet_01v8 L=0.15 W=0.42 nf=1 m=1
XXc_0_6_XPD2 Xc_0_6.qb Xc_0_6.q vss vss sky130_fd_pr__nfet_01v8 L=0.15 W=0.63 nf=1 m=1
XXc_0_6_XPG1 bl6 wl0 Xc_0_6.q vss sky130_fd_pr__nfet_01v8 L=0.15 W=0.42 nf=1 m=1
XXc_0_6_XPG2 blb6 wl0 Xc_0_6.qb vss sky130_fd_pr__nfet_01v8 L=0.15 W=0.42 nf=1 m=1
XXc_0_7_XPU1 Xc_0_7.q Xc_0_7.qb vdd vdd sky130_fd_pr__pfet_01v8 L=0.15 W=0.42 nf=1 m=1
XXc_0_7_XPD1 Xc_0_7.q Xc_0_7.qb vss vss sky130_fd_pr__nfet_01v8 L=0.15 W=0.63 nf=1 m=1
XXc_0_7_XPU2 Xc_0_7.qb Xc_0_7.q vdd vdd sky130_fd_pr__pfet_01v8 L=0.15 W=0.42 nf=1 m=1
XXc_0_7_XPD2 Xc_0_7.qb Xc_0_7.q vss vss sky130_fd_pr__nfet_01v8 L=0.15 W=0.63 nf=1 m=1
XXc_0_7_XPG1 bl7 wl0 Xc_0_7.q vss sky130_fd_pr__nfet_01v8 L=0.15 W=0.42 nf=1 m=1
XXc_0_7_XPG2 blb7 wl0 Xc_0_7.qb vss sky130_fd_pr__nfet_01v8 L=0.15 W=0.42 nf=1 m=1
XXc_0_8_XPU1 Xc_0_8.q Xc_0_8.qb vdd vdd sky130_fd_pr__pfet_01v8 L=0.15 W=0.42 nf=1 m=1
XXc_0_8_XPD1 Xc_0_8.q Xc_0_8.qb vss vss sky130_fd_pr__nfet_01v8 L=0.15 W=0.63 nf=1 m=1
XXc_0_8_XPU2 Xc_0_8.qb Xc_0_8.q vdd vdd sky130_fd_pr__pfet_01v8 L=0.15 W=0.42 nf=1 m=1
XXc_0_8_XPD2 Xc_0_8.qb Xc_0_8.q vss vss sky130_fd_pr__nfet_01v8 L=0.15 W=0.63 nf=1 m=1
XXc_0_8_XPG1 bl8 wl0 Xc_0_8.q vss sky130_fd_pr__nfet_01v8 L=0.15 W=0.42 nf=1 m=1
XXc_0_8_XPG2 blb8 wl0 Xc_0_8.qb vss sky130_fd_pr__nfet_01v8 L=0.15 W=0.42 nf=1 m=1
XXc_0_9_XPU1 Xc_0_9.q Xc_0_9.qb vdd vdd sky130_fd_pr__pfet_01v8 L=0.15 W=0.42 nf=1 m=1
XXc_0_9_XPD1 Xc_0_9.q Xc_0_9.qb vss vss sky130_fd_pr__nfet_01v8 L=0.15 W=0.63 nf=1 m=1
XXc_0_9_XPU2 Xc_0_9.qb Xc_0_9.q vdd vdd sky130_fd_pr__pfet_01v8 L=0.15 W=0.42 nf=1 m=1
XXc_0_9_XPD2 Xc_0_9.qb Xc_0_9.q vss vss sky130_fd_pr__nfet_01v8 L=0.15 W=0.63 nf=1 m=1
XXc_0_9_XPG1 bl9 wl0 Xc_0_9.q vss sky130_fd_pr__nfet_01v8 L=0.15 W=0.42 nf=1 m=1
XXc_0_9_XPG2 blb9 wl0 Xc_0_9.qb vss sky130_fd_pr__nfet_01v8 L=0.15 W=0.42 nf=1 m=1
XXc_0_10_XPU1 Xc_0_10.q Xc_0_10.qb vdd vdd sky130_fd_pr__pfet_01v8 L=0.15 W=0.42 nf=1 m=1
XXc_0_10_XPD1 Xc_0_10.q Xc_0_10.qb vss vss sky130_fd_pr__nfet_01v8 L=0.15 W=0.63 nf=1 m=1
XXc_0_10_XPU2 Xc_0_10.qb Xc_0_10.q vdd vdd sky130_fd_pr__pfet_01v8 L=0.15 W=0.42 nf=1 m=1
XXc_0_10_XPD2 Xc_0_10.qb Xc_0_10.q vss vss sky130_fd_pr__nfet_01v8 L=0.15 W=0.63 nf=1 m=1
XXc_0_10_XPG1 bl10 wl0 Xc_0_10.q vss sky130_fd_pr__nfet_01v8 L=0.15 W=0.42 nf=1 m=1
XXc_0_10_XPG2 blb10 wl0 Xc_0_10.qb vss sky130_fd_pr__nfet_01v8 L=0.15 W=0.42 nf=1 m=1
XXc_0_11_XPU1 Xc_0_11.q Xc_0_11.qb vdd vdd sky130_fd_pr__pfet_01v8 L=0.15 W=0.42 nf=1 m=1
XXc_0_11_XPD1 Xc_0_11.q Xc_0_11.qb vss vss sky130_fd_pr__nfet_01v8 L=0.15 W=0.63 nf=1 m=1
XXc_0_11_XPU2 Xc_0_11.qb Xc_0_11.q vdd vdd sky130_fd_pr__pfet_01v8 L=0.15 W=0.42 nf=1 m=1
XXc_0_11_XPD2 Xc_0_11.qb Xc_0_11.q vss vss sky130_fd_pr__nfet_01v8 L=0.15 W=0.63 nf=1 m=1
XXc_0_11_XPG1 bl11 wl0 Xc_0_11.q vss sky130_fd_pr__nfet_01v8 L=0.15 W=0.42 nf=1 m=1
XXc_0_11_XPG2 blb11 wl0 Xc_0_11.qb vss sky130_fd_pr__nfet_01v8 L=0.15 W=0.42 nf=1 m=1
XXc_0_12_XPU1 Xc_0_12.q Xc_0_12.qb vdd vdd sky130_fd_pr__pfet_01v8 L=0.15 W=0.42 nf=1 m=1
XXc_0_12_XPD1 Xc_0_12.q Xc_0_12.qb vss vss sky130_fd_pr__nfet_01v8 L=0.15 W=0.63 nf=1 m=1
XXc_0_12_XPU2 Xc_0_12.qb Xc_0_12.q vdd vdd sky130_fd_pr__pfet_01v8 L=0.15 W=0.42 nf=1 m=1
XXc_0_12_XPD2 Xc_0_12.qb Xc_0_12.q vss vss sky130_fd_pr__nfet_01v8 L=0.15 W=0.63 nf=1 m=1
XXc_0_12_XPG1 bl12 wl0 Xc_0_12.q vss sky130_fd_pr__nfet_01v8 L=0.15 W=0.42 nf=1 m=1
XXc_0_12_XPG2 blb12 wl0 Xc_0_12.qb vss sky130_fd_pr__nfet_01v8 L=0.15 W=0.42 nf=1 m=1
XXc_0_13_XPU1 Xc_0_13.q Xc_0_13.qb vdd vdd sky130_fd_pr__pfet_01v8 L=0.15 W=0.42 nf=1 m=1
XXc_0_13_XPD1 Xc_0_13.q Xc_0_13.qb vss vss sky130_fd_pr__nfet_01v8 L=0.15 W=0.63 nf=1 m=1
XXc_0_13_XPU2 Xc_0_13.qb Xc_0_13.q vdd vdd sky130_fd_pr__pfet_01v8 L=0.15 W=0.42 nf=1 m=1
XXc_0_13_XPD2 Xc_0_13.qb Xc_0_13.q vss vss sky130_fd_pr__nfet_01v8 L=0.15 W=0.63 nf=1 m=1
XXc_0_13_XPG1 bl13 wl0 Xc_0_13.q vss sky130_fd_pr__nfet_01v8 L=0.15 W=0.42 nf=1 m=1
XXc_0_13_XPG2 blb13 wl0 Xc_0_13.qb vss sky130_fd_pr__nfet_01v8 L=0.15 W=0.42 nf=1 m=1
XXc_0_14_XPU1 Xc_0_14.q Xc_0_14.qb vdd vdd sky130_fd_pr__pfet_01v8 L=0.15 W=0.42 nf=1 m=1
XXc_0_14_XPD1 Xc_0_14.q Xc_0_14.qb vss vss sky130_fd_pr__nfet_01v8 L=0.15 W=0.63 nf=1 m=1
XXc_0_14_XPU2 Xc_0_14.qb Xc_0_14.q vdd vdd sky130_fd_pr__pfet_01v8 L=0.15 W=0.42 nf=1 m=1
XXc_0_14_XPD2 Xc_0_14.qb Xc_0_14.q vss vss sky130_fd_pr__nfet_01v8 L=0.15 W=0.63 nf=1 m=1
XXc_0_14_XPG1 bl14 wl0 Xc_0_14.q vss sky130_fd_pr__nfet_01v8 L=0.15 W=0.42 nf=1 m=1
XXc_0_14_XPG2 blb14 wl0 Xc_0_14.qb vss sky130_fd_pr__nfet_01v8 L=0.15 W=0.42 nf=1 m=1
XXc_0_15_XPU1 Xc_0_15.q Xc_0_15.qb vdd vdd sky130_fd_pr__pfet_01v8 L=0.15 W=0.42 nf=1 m=1
XXc_0_15_XPD1 Xc_0_15.q Xc_0_15.qb vss vss sky130_fd_pr__nfet_01v8 L=0.15 W=0.63 nf=1 m=1
XXc_0_15_XPU2 Xc_0_15.qb Xc_0_15.q vdd vdd sky130_fd_pr__pfet_01v8 L=0.15 W=0.42 nf=1 m=1
XXc_0_15_XPD2 Xc_0_15.qb Xc_0_15.q vss vss sky130_fd_pr__nfet_01v8 L=0.15 W=0.63 nf=1 m=1
XXc_0_15_XPG1 bl15 wl0 Xc_0_15.q vss sky130_fd_pr__nfet_01v8 L=0.15 W=0.42 nf=1 m=1
XXc_0_15_XPG2 blb15 wl0 Xc_0_15.qb vss sky130_fd_pr__nfet_01v8 L=0.15 W=0.42 nf=1 m=1
XXc_1_0_XPU1 Xc_1_0.q Xc_1_0.qb vdd vdd sky130_fd_pr__pfet_01v8 L=0.15 W=0.42 nf=1 m=1
XXc_1_0_XPD1 Xc_1_0.q Xc_1_0.qb vss vss sky130_fd_pr__nfet_01v8 L=0.15 W=0.63 nf=1 m=1
XXc_1_0_XPU2 Xc_1_0.qb Xc_1_0.q vdd vdd sky130_fd_pr__pfet_01v8 L=0.15 W=0.42 nf=1 m=1
XXc_1_0_XPD2 Xc_1_0.qb Xc_1_0.q vss vss sky130_fd_pr__nfet_01v8 L=0.15 W=0.63 nf=1 m=1
XXc_1_0_XPG1 bl0 wl1 Xc_1_0.q vss sky130_fd_pr__nfet_01v8 L=0.15 W=0.42 nf=1 m=1
XXc_1_0_XPG2 blb0 wl1 Xc_1_0.qb vss sky130_fd_pr__nfet_01v8 L=0.15 W=0.42 nf=1 m=1
XXc_1_1_XPU1 Xc_1_1.q Xc_1_1.qb vdd vdd sky130_fd_pr__pfet_01v8 L=0.15 W=0.42 nf=1 m=1
XXc_1_1_XPD1 Xc_1_1.q Xc_1_1.qb vss vss sky130_fd_pr__nfet_01v8 L=0.15 W=0.63 nf=1 m=1
XXc_1_1_XPU2 Xc_1_1.qb Xc_1_1.q vdd vdd sky130_fd_pr__pfet_01v8 L=0.15 W=0.42 nf=1 m=1
XXc_1_1_XPD2 Xc_1_1.qb Xc_1_1.q vss vss sky130_fd_pr__nfet_01v8 L=0.15 W=0.63 nf=1 m=1
XXc_1_1_XPG1 bl1 wl1 Xc_1_1.q vss sky130_fd_pr__nfet_01v8 L=0.15 W=0.42 nf=1 m=1
XXc_1_1_XPG2 blb1 wl1 Xc_1_1.qb vss sky130_fd_pr__nfet_01v8 L=0.15 W=0.42 nf=1 m=1
XXc_1_2_XPU1 Xc_1_2.q Xc_1_2.qb vdd vdd sky130_fd_pr__pfet_01v8 L=0.15 W=0.42 nf=1 m=1
XXc_1_2_XPD1 Xc_1_2.q Xc_1_2.qb vss vss sky130_fd_pr__nfet_01v8 L=0.15 W=0.63 nf=1 m=1
XXc_1_2_XPU2 Xc_1_2.qb Xc_1_2.q vdd vdd sky130_fd_pr__pfet_01v8 L=0.15 W=0.42 nf=1 m=1
XXc_1_2_XPD2 Xc_1_2.qb Xc_1_2.q vss vss sky130_fd_pr__nfet_01v8 L=0.15 W=0.63 nf=1 m=1
XXc_1_2_XPG1 bl2 wl1 Xc_1_2.q vss sky130_fd_pr__nfet_01v8 L=0.15 W=0.42 nf=1 m=1
XXc_1_2_XPG2 blb2 wl1 Xc_1_2.qb vss sky130_fd_pr__nfet_01v8 L=0.15 W=0.42 nf=1 m=1
XXc_1_3_XPU1 Xc_1_3.q Xc_1_3.qb vdd vdd sky130_fd_pr__pfet_01v8 L=0.15 W=0.42 nf=1 m=1
XXc_1_3_XPD1 Xc_1_3.q Xc_1_3.qb vss vss sky130_fd_pr__nfet_01v8 L=0.15 W=0.63 nf=1 m=1
XXc_1_3_XPU2 Xc_1_3.qb Xc_1_3.q vdd vdd sky130_fd_pr__pfet_01v8 L=0.15 W=0.42 nf=1 m=1
XXc_1_3_XPD2 Xc_1_3.qb Xc_1_3.q vss vss sky130_fd_pr__nfet_01v8 L=0.15 W=0.63 nf=1 m=1
XXc_1_3_XPG1 bl3 wl1 Xc_1_3.q vss sky130_fd_pr__nfet_01v8 L=0.15 W=0.42 nf=1 m=1
XXc_1_3_XPG2 blb3 wl1 Xc_1_3.qb vss sky130_fd_pr__nfet_01v8 L=0.15 W=0.42 nf=1 m=1
XXc_1_4_XPU1 Xc_1_4.q Xc_1_4.qb vdd vdd sky130_fd_pr__pfet_01v8 L=0.15 W=0.42 nf=1 m=1
XXc_1_4_XPD1 Xc_1_4.q Xc_1_4.qb vss vss sky130_fd_pr__nfet_01v8 L=0.15 W=0.63 nf=1 m=1
XXc_1_4_XPU2 Xc_1_4.qb Xc_1_4.q vdd vdd sky130_fd_pr__pfet_01v8 L=0.15 W=0.42 nf=1 m=1
XXc_1_4_XPD2 Xc_1_4.qb Xc_1_4.q vss vss sky130_fd_pr__nfet_01v8 L=0.15 W=0.63 nf=1 m=1
XXc_1_4_XPG1 bl4 wl1 Xc_1_4.q vss sky130_fd_pr__nfet_01v8 L=0.15 W=0.42 nf=1 m=1
XXc_1_4_XPG2 blb4 wl1 Xc_1_4.qb vss sky130_fd_pr__nfet_01v8 L=0.15 W=0.42 nf=1 m=1
XXc_1_5_XPU1 Xc_1_5.q Xc_1_5.qb vdd vdd sky130_fd_pr__pfet_01v8 L=0.15 W=0.42 nf=1 m=1
XXc_1_5_XPD1 Xc_1_5.q Xc_1_5.qb vss vss sky130_fd_pr__nfet_01v8 L=0.15 W=0.63 nf=1 m=1
XXc_1_5_XPU2 Xc_1_5.qb Xc_1_5.q vdd vdd sky130_fd_pr__pfet_01v8 L=0.15 W=0.42 nf=1 m=1
XXc_1_5_XPD2 Xc_1_5.qb Xc_1_5.q vss vss sky130_fd_pr__nfet_01v8 L=0.15 W=0.63 nf=1 m=1
XXc_1_5_XPG1 bl5 wl1 Xc_1_5.q vss sky130_fd_pr__nfet_01v8 L=0.15 W=0.42 nf=1 m=1
XXc_1_5_XPG2 blb5 wl1 Xc_1_5.qb vss sky130_fd_pr__nfet_01v8 L=0.15 W=0.42 nf=1 m=1
XXc_1_6_XPU1 Xc_1_6.q Xc_1_6.qb vdd vdd sky130_fd_pr__pfet_01v8 L=0.15 W=0.42 nf=1 m=1
XXc_1_6_XPD1 Xc_1_6.q Xc_1_6.qb vss vss sky130_fd_pr__nfet_01v8 L=0.15 W=0.63 nf=1 m=1
XXc_1_6_XPU2 Xc_1_6.qb Xc_1_6.q vdd vdd sky130_fd_pr__pfet_01v8 L=0.15 W=0.42 nf=1 m=1
XXc_1_6_XPD2 Xc_1_6.qb Xc_1_6.q vss vss sky130_fd_pr__nfet_01v8 L=0.15 W=0.63 nf=1 m=1
XXc_1_6_XPG1 bl6 wl1 Xc_1_6.q vss sky130_fd_pr__nfet_01v8 L=0.15 W=0.42 nf=1 m=1
XXc_1_6_XPG2 blb6 wl1 Xc_1_6.qb vss sky130_fd_pr__nfet_01v8 L=0.15 W=0.42 nf=1 m=1
XXc_1_7_XPU1 Xc_1_7.q Xc_1_7.qb vdd vdd sky130_fd_pr__pfet_01v8 L=0.15 W=0.42 nf=1 m=1
XXc_1_7_XPD1 Xc_1_7.q Xc_1_7.qb vss vss sky130_fd_pr__nfet_01v8 L=0.15 W=0.63 nf=1 m=1
XXc_1_7_XPU2 Xc_1_7.qb Xc_1_7.q vdd vdd sky130_fd_pr__pfet_01v8 L=0.15 W=0.42 nf=1 m=1
XXc_1_7_XPD2 Xc_1_7.qb Xc_1_7.q vss vss sky130_fd_pr__nfet_01v8 L=0.15 W=0.63 nf=1 m=1
XXc_1_7_XPG1 bl7 wl1 Xc_1_7.q vss sky130_fd_pr__nfet_01v8 L=0.15 W=0.42 nf=1 m=1
XXc_1_7_XPG2 blb7 wl1 Xc_1_7.qb vss sky130_fd_pr__nfet_01v8 L=0.15 W=0.42 nf=1 m=1
XXc_1_8_XPU1 Xc_1_8.q Xc_1_8.qb vdd vdd sky130_fd_pr__pfet_01v8 L=0.15 W=0.42 nf=1 m=1
XXc_1_8_XPD1 Xc_1_8.q Xc_1_8.qb vss vss sky130_fd_pr__nfet_01v8 L=0.15 W=0.63 nf=1 m=1
XXc_1_8_XPU2 Xc_1_8.qb Xc_1_8.q vdd vdd sky130_fd_pr__pfet_01v8 L=0.15 W=0.42 nf=1 m=1
XXc_1_8_XPD2 Xc_1_8.qb Xc_1_8.q vss vss sky130_fd_pr__nfet_01v8 L=0.15 W=0.63 nf=1 m=1
XXc_1_8_XPG1 bl8 wl1 Xc_1_8.q vss sky130_fd_pr__nfet_01v8 L=0.15 W=0.42 nf=1 m=1
XXc_1_8_XPG2 blb8 wl1 Xc_1_8.qb vss sky130_fd_pr__nfet_01v8 L=0.15 W=0.42 nf=1 m=1
XXc_1_9_XPU1 Xc_1_9.q Xc_1_9.qb vdd vdd sky130_fd_pr__pfet_01v8 L=0.15 W=0.42 nf=1 m=1
XXc_1_9_XPD1 Xc_1_9.q Xc_1_9.qb vss vss sky130_fd_pr__nfet_01v8 L=0.15 W=0.63 nf=1 m=1
XXc_1_9_XPU2 Xc_1_9.qb Xc_1_9.q vdd vdd sky130_fd_pr__pfet_01v8 L=0.15 W=0.42 nf=1 m=1
XXc_1_9_XPD2 Xc_1_9.qb Xc_1_9.q vss vss sky130_fd_pr__nfet_01v8 L=0.15 W=0.63 nf=1 m=1
XXc_1_9_XPG1 bl9 wl1 Xc_1_9.q vss sky130_fd_pr__nfet_01v8 L=0.15 W=0.42 nf=1 m=1
XXc_1_9_XPG2 blb9 wl1 Xc_1_9.qb vss sky130_fd_pr__nfet_01v8 L=0.15 W=0.42 nf=1 m=1
XXc_1_10_XPU1 Xc_1_10.q Xc_1_10.qb vdd vdd sky130_fd_pr__pfet_01v8 L=0.15 W=0.42 nf=1 m=1
XXc_1_10_XPD1 Xc_1_10.q Xc_1_10.qb vss vss sky130_fd_pr__nfet_01v8 L=0.15 W=0.63 nf=1 m=1
XXc_1_10_XPU2 Xc_1_10.qb Xc_1_10.q vdd vdd sky130_fd_pr__pfet_01v8 L=0.15 W=0.42 nf=1 m=1
XXc_1_10_XPD2 Xc_1_10.qb Xc_1_10.q vss vss sky130_fd_pr__nfet_01v8 L=0.15 W=0.63 nf=1 m=1
XXc_1_10_XPG1 bl10 wl1 Xc_1_10.q vss sky130_fd_pr__nfet_01v8 L=0.15 W=0.42 nf=1 m=1
XXc_1_10_XPG2 blb10 wl1 Xc_1_10.qb vss sky130_fd_pr__nfet_01v8 L=0.15 W=0.42 nf=1 m=1
XXc_1_11_XPU1 Xc_1_11.q Xc_1_11.qb vdd vdd sky130_fd_pr__pfet_01v8 L=0.15 W=0.42 nf=1 m=1
XXc_1_11_XPD1 Xc_1_11.q Xc_1_11.qb vss vss sky130_fd_pr__nfet_01v8 L=0.15 W=0.63 nf=1 m=1
XXc_1_11_XPU2 Xc_1_11.qb Xc_1_11.q vdd vdd sky130_fd_pr__pfet_01v8 L=0.15 W=0.42 nf=1 m=1
XXc_1_11_XPD2 Xc_1_11.qb Xc_1_11.q vss vss sky130_fd_pr__nfet_01v8 L=0.15 W=0.63 nf=1 m=1
XXc_1_11_XPG1 bl11 wl1 Xc_1_11.q vss sky130_fd_pr__nfet_01v8 L=0.15 W=0.42 nf=1 m=1
XXc_1_11_XPG2 blb11 wl1 Xc_1_11.qb vss sky130_fd_pr__nfet_01v8 L=0.15 W=0.42 nf=1 m=1
XXc_1_12_XPU1 Xc_1_12.q Xc_1_12.qb vdd vdd sky130_fd_pr__pfet_01v8 L=0.15 W=0.42 nf=1 m=1
XXc_1_12_XPD1 Xc_1_12.q Xc_1_12.qb vss vss sky130_fd_pr__nfet_01v8 L=0.15 W=0.63 nf=1 m=1
XXc_1_12_XPU2 Xc_1_12.qb Xc_1_12.q vdd vdd sky130_fd_pr__pfet_01v8 L=0.15 W=0.42 nf=1 m=1
XXc_1_12_XPD2 Xc_1_12.qb Xc_1_12.q vss vss sky130_fd_pr__nfet_01v8 L=0.15 W=0.63 nf=1 m=1
XXc_1_12_XPG1 bl12 wl1 Xc_1_12.q vss sky130_fd_pr__nfet_01v8 L=0.15 W=0.42 nf=1 m=1
XXc_1_12_XPG2 blb12 wl1 Xc_1_12.qb vss sky130_fd_pr__nfet_01v8 L=0.15 W=0.42 nf=1 m=1
XXc_1_13_XPU1 Xc_1_13.q Xc_1_13.qb vdd vdd sky130_fd_pr__pfet_01v8 L=0.15 W=0.42 nf=1 m=1
XXc_1_13_XPD1 Xc_1_13.q Xc_1_13.qb vss vss sky130_fd_pr__nfet_01v8 L=0.15 W=0.63 nf=1 m=1
XXc_1_13_XPU2 Xc_1_13.qb Xc_1_13.q vdd vdd sky130_fd_pr__pfet_01v8 L=0.15 W=0.42 nf=1 m=1
XXc_1_13_XPD2 Xc_1_13.qb Xc_1_13.q vss vss sky130_fd_pr__nfet_01v8 L=0.15 W=0.63 nf=1 m=1
XXc_1_13_XPG1 bl13 wl1 Xc_1_13.q vss sky130_fd_pr__nfet_01v8 L=0.15 W=0.42 nf=1 m=1
XXc_1_13_XPG2 blb13 wl1 Xc_1_13.qb vss sky130_fd_pr__nfet_01v8 L=0.15 W=0.42 nf=1 m=1
XXc_1_14_XPU1 Xc_1_14.q Xc_1_14.qb vdd vdd sky130_fd_pr__pfet_01v8 L=0.15 W=0.42 nf=1 m=1
XXc_1_14_XPD1 Xc_1_14.q Xc_1_14.qb vss vss sky130_fd_pr__nfet_01v8 L=0.15 W=0.63 nf=1 m=1
XXc_1_14_XPU2 Xc_1_14.qb Xc_1_14.q vdd vdd sky130_fd_pr__pfet_01v8 L=0.15 W=0.42 nf=1 m=1
XXc_1_14_XPD2 Xc_1_14.qb Xc_1_14.q vss vss sky130_fd_pr__nfet_01v8 L=0.15 W=0.63 nf=1 m=1
XXc_1_14_XPG1 bl14 wl1 Xc_1_14.q vss sky130_fd_pr__nfet_01v8 L=0.15 W=0.42 nf=1 m=1
XXc_1_14_XPG2 blb14 wl1 Xc_1_14.qb vss sky130_fd_pr__nfet_01v8 L=0.15 W=0.42 nf=1 m=1
XXc_1_15_XPU1 Xc_1_15.q Xc_1_15.qb vdd vdd sky130_fd_pr__pfet_01v8 L=0.15 W=0.42 nf=1 m=1
XXc_1_15_XPD1 Xc_1_15.q Xc_1_15.qb vss vss sky130_fd_pr__nfet_01v8 L=0.15 W=0.63 nf=1 m=1
XXc_1_15_XPU2 Xc_1_15.qb Xc_1_15.q vdd vdd sky130_fd_pr__pfet_01v8 L=0.15 W=0.42 nf=1 m=1
XXc_1_15_XPD2 Xc_1_15.qb Xc_1_15.q vss vss sky130_fd_pr__nfet_01v8 L=0.15 W=0.63 nf=1 m=1
XXc_1_15_XPG1 bl15 wl1 Xc_1_15.q vss sky130_fd_pr__nfet_01v8 L=0.15 W=0.42 nf=1 m=1
XXc_1_15_XPG2 blb15 wl1 Xc_1_15.qb vss sky130_fd_pr__nfet_01v8 L=0.15 W=0.42 nf=1 m=1
XXc_2_0_XPU1 Xc_2_0.q Xc_2_0.qb vdd vdd sky130_fd_pr__pfet_01v8 L=0.15 W=0.42 nf=1 m=1
XXc_2_0_XPD1 Xc_2_0.q Xc_2_0.qb vss vss sky130_fd_pr__nfet_01v8 L=0.15 W=0.63 nf=1 m=1
XXc_2_0_XPU2 Xc_2_0.qb Xc_2_0.q vdd vdd sky130_fd_pr__pfet_01v8 L=0.15 W=0.42 nf=1 m=1
XXc_2_0_XPD2 Xc_2_0.qb Xc_2_0.q vss vss sky130_fd_pr__nfet_01v8 L=0.15 W=0.63 nf=1 m=1
XXc_2_0_XPG1 bl0 wl2 Xc_2_0.q vss sky130_fd_pr__nfet_01v8 L=0.15 W=0.42 nf=1 m=1
XXc_2_0_XPG2 blb0 wl2 Xc_2_0.qb vss sky130_fd_pr__nfet_01v8 L=0.15 W=0.42 nf=1 m=1
XXc_2_1_XPU1 Xc_2_1.q Xc_2_1.qb vdd vdd sky130_fd_pr__pfet_01v8 L=0.15 W=0.42 nf=1 m=1
XXc_2_1_XPD1 Xc_2_1.q Xc_2_1.qb vss vss sky130_fd_pr__nfet_01v8 L=0.15 W=0.63 nf=1 m=1
XXc_2_1_XPU2 Xc_2_1.qb Xc_2_1.q vdd vdd sky130_fd_pr__pfet_01v8 L=0.15 W=0.42 nf=1 m=1
XXc_2_1_XPD2 Xc_2_1.qb Xc_2_1.q vss vss sky130_fd_pr__nfet_01v8 L=0.15 W=0.63 nf=1 m=1
XXc_2_1_XPG1 bl1 wl2 Xc_2_1.q vss sky130_fd_pr__nfet_01v8 L=0.15 W=0.42 nf=1 m=1
XXc_2_1_XPG2 blb1 wl2 Xc_2_1.qb vss sky130_fd_pr__nfet_01v8 L=0.15 W=0.42 nf=1 m=1
XXc_2_2_XPU1 Xc_2_2.q Xc_2_2.qb vdd vdd sky130_fd_pr__pfet_01v8 L=0.15 W=0.42 nf=1 m=1
XXc_2_2_XPD1 Xc_2_2.q Xc_2_2.qb vss vss sky130_fd_pr__nfet_01v8 L=0.15 W=0.63 nf=1 m=1
XXc_2_2_XPU2 Xc_2_2.qb Xc_2_2.q vdd vdd sky130_fd_pr__pfet_01v8 L=0.15 W=0.42 nf=1 m=1
XXc_2_2_XPD2 Xc_2_2.qb Xc_2_2.q vss vss sky130_fd_pr__nfet_01v8 L=0.15 W=0.63 nf=1 m=1
XXc_2_2_XPG1 bl2 wl2 Xc_2_2.q vss sky130_fd_pr__nfet_01v8 L=0.15 W=0.42 nf=1 m=1
XXc_2_2_XPG2 blb2 wl2 Xc_2_2.qb vss sky130_fd_pr__nfet_01v8 L=0.15 W=0.42 nf=1 m=1
XXc_2_3_XPU1 Xc_2_3.q Xc_2_3.qb vdd vdd sky130_fd_pr__pfet_01v8 L=0.15 W=0.42 nf=1 m=1
XXc_2_3_XPD1 Xc_2_3.q Xc_2_3.qb vss vss sky130_fd_pr__nfet_01v8 L=0.15 W=0.63 nf=1 m=1
XXc_2_3_XPU2 Xc_2_3.qb Xc_2_3.q vdd vdd sky130_fd_pr__pfet_01v8 L=0.15 W=0.42 nf=1 m=1
XXc_2_3_XPD2 Xc_2_3.qb Xc_2_3.q vss vss sky130_fd_pr__nfet_01v8 L=0.15 W=0.63 nf=1 m=1
XXc_2_3_XPG1 bl3 wl2 Xc_2_3.q vss sky130_fd_pr__nfet_01v8 L=0.15 W=0.42 nf=1 m=1
XXc_2_3_XPG2 blb3 wl2 Xc_2_3.qb vss sky130_fd_pr__nfet_01v8 L=0.15 W=0.42 nf=1 m=1
XXc_2_4_XPU1 Xc_2_4.q Xc_2_4.qb vdd vdd sky130_fd_pr__pfet_01v8 L=0.15 W=0.42 nf=1 m=1
XXc_2_4_XPD1 Xc_2_4.q Xc_2_4.qb vss vss sky130_fd_pr__nfet_01v8 L=0.15 W=0.63 nf=1 m=1
XXc_2_4_XPU2 Xc_2_4.qb Xc_2_4.q vdd vdd sky130_fd_pr__pfet_01v8 L=0.15 W=0.42 nf=1 m=1
XXc_2_4_XPD2 Xc_2_4.qb Xc_2_4.q vss vss sky130_fd_pr__nfet_01v8 L=0.15 W=0.63 nf=1 m=1
XXc_2_4_XPG1 bl4 wl2 Xc_2_4.q vss sky130_fd_pr__nfet_01v8 L=0.15 W=0.42 nf=1 m=1
XXc_2_4_XPG2 blb4 wl2 Xc_2_4.qb vss sky130_fd_pr__nfet_01v8 L=0.15 W=0.42 nf=1 m=1
XXc_2_5_XPU1 Xc_2_5.q Xc_2_5.qb vdd vdd sky130_fd_pr__pfet_01v8 L=0.15 W=0.42 nf=1 m=1
XXc_2_5_XPD1 Xc_2_5.q Xc_2_5.qb vss vss sky130_fd_pr__nfet_01v8 L=0.15 W=0.63 nf=1 m=1
XXc_2_5_XPU2 Xc_2_5.qb Xc_2_5.q vdd vdd sky130_fd_pr__pfet_01v8 L=0.15 W=0.42 nf=1 m=1
XXc_2_5_XPD2 Xc_2_5.qb Xc_2_5.q vss vss sky130_fd_pr__nfet_01v8 L=0.15 W=0.63 nf=1 m=1
XXc_2_5_XPG1 bl5 wl2 Xc_2_5.q vss sky130_fd_pr__nfet_01v8 L=0.15 W=0.42 nf=1 m=1
XXc_2_5_XPG2 blb5 wl2 Xc_2_5.qb vss sky130_fd_pr__nfet_01v8 L=0.15 W=0.42 nf=1 m=1
XXc_2_6_XPU1 Xc_2_6.q Xc_2_6.qb vdd vdd sky130_fd_pr__pfet_01v8 L=0.15 W=0.42 nf=1 m=1
XXc_2_6_XPD1 Xc_2_6.q Xc_2_6.qb vss vss sky130_fd_pr__nfet_01v8 L=0.15 W=0.63 nf=1 m=1
XXc_2_6_XPU2 Xc_2_6.qb Xc_2_6.q vdd vdd sky130_fd_pr__pfet_01v8 L=0.15 W=0.42 nf=1 m=1
XXc_2_6_XPD2 Xc_2_6.qb Xc_2_6.q vss vss sky130_fd_pr__nfet_01v8 L=0.15 W=0.63 nf=1 m=1
XXc_2_6_XPG1 bl6 wl2 Xc_2_6.q vss sky130_fd_pr__nfet_01v8 L=0.15 W=0.42 nf=1 m=1
XXc_2_6_XPG2 blb6 wl2 Xc_2_6.qb vss sky130_fd_pr__nfet_01v8 L=0.15 W=0.42 nf=1 m=1
XXc_2_7_XPU1 Xc_2_7.q Xc_2_7.qb vdd vdd sky130_fd_pr__pfet_01v8 L=0.15 W=0.42 nf=1 m=1
XXc_2_7_XPD1 Xc_2_7.q Xc_2_7.qb vss vss sky130_fd_pr__nfet_01v8 L=0.15 W=0.63 nf=1 m=1
XXc_2_7_XPU2 Xc_2_7.qb Xc_2_7.q vdd vdd sky130_fd_pr__pfet_01v8 L=0.15 W=0.42 nf=1 m=1
XXc_2_7_XPD2 Xc_2_7.qb Xc_2_7.q vss vss sky130_fd_pr__nfet_01v8 L=0.15 W=0.63 nf=1 m=1
XXc_2_7_XPG1 bl7 wl2 Xc_2_7.q vss sky130_fd_pr__nfet_01v8 L=0.15 W=0.42 nf=1 m=1
XXc_2_7_XPG2 blb7 wl2 Xc_2_7.qb vss sky130_fd_pr__nfet_01v8 L=0.15 W=0.42 nf=1 m=1
XXc_2_8_XPU1 Xc_2_8.q Xc_2_8.qb vdd vdd sky130_fd_pr__pfet_01v8 L=0.15 W=0.42 nf=1 m=1
XXc_2_8_XPD1 Xc_2_8.q Xc_2_8.qb vss vss sky130_fd_pr__nfet_01v8 L=0.15 W=0.63 nf=1 m=1
XXc_2_8_XPU2 Xc_2_8.qb Xc_2_8.q vdd vdd sky130_fd_pr__pfet_01v8 L=0.15 W=0.42 nf=1 m=1
XXc_2_8_XPD2 Xc_2_8.qb Xc_2_8.q vss vss sky130_fd_pr__nfet_01v8 L=0.15 W=0.63 nf=1 m=1
XXc_2_8_XPG1 bl8 wl2 Xc_2_8.q vss sky130_fd_pr__nfet_01v8 L=0.15 W=0.42 nf=1 m=1
XXc_2_8_XPG2 blb8 wl2 Xc_2_8.qb vss sky130_fd_pr__nfet_01v8 L=0.15 W=0.42 nf=1 m=1
XXc_2_9_XPU1 Xc_2_9.q Xc_2_9.qb vdd vdd sky130_fd_pr__pfet_01v8 L=0.15 W=0.42 nf=1 m=1
XXc_2_9_XPD1 Xc_2_9.q Xc_2_9.qb vss vss sky130_fd_pr__nfet_01v8 L=0.15 W=0.63 nf=1 m=1
XXc_2_9_XPU2 Xc_2_9.qb Xc_2_9.q vdd vdd sky130_fd_pr__pfet_01v8 L=0.15 W=0.42 nf=1 m=1
XXc_2_9_XPD2 Xc_2_9.qb Xc_2_9.q vss vss sky130_fd_pr__nfet_01v8 L=0.15 W=0.63 nf=1 m=1
XXc_2_9_XPG1 bl9 wl2 Xc_2_9.q vss sky130_fd_pr__nfet_01v8 L=0.15 W=0.42 nf=1 m=1
XXc_2_9_XPG2 blb9 wl2 Xc_2_9.qb vss sky130_fd_pr__nfet_01v8 L=0.15 W=0.42 nf=1 m=1
XXc_2_10_XPU1 Xc_2_10.q Xc_2_10.qb vdd vdd sky130_fd_pr__pfet_01v8 L=0.15 W=0.42 nf=1 m=1
XXc_2_10_XPD1 Xc_2_10.q Xc_2_10.qb vss vss sky130_fd_pr__nfet_01v8 L=0.15 W=0.63 nf=1 m=1
XXc_2_10_XPU2 Xc_2_10.qb Xc_2_10.q vdd vdd sky130_fd_pr__pfet_01v8 L=0.15 W=0.42 nf=1 m=1
XXc_2_10_XPD2 Xc_2_10.qb Xc_2_10.q vss vss sky130_fd_pr__nfet_01v8 L=0.15 W=0.63 nf=1 m=1
XXc_2_10_XPG1 bl10 wl2 Xc_2_10.q vss sky130_fd_pr__nfet_01v8 L=0.15 W=0.42 nf=1 m=1
XXc_2_10_XPG2 blb10 wl2 Xc_2_10.qb vss sky130_fd_pr__nfet_01v8 L=0.15 W=0.42 nf=1 m=1
XXc_2_11_XPU1 Xc_2_11.q Xc_2_11.qb vdd vdd sky130_fd_pr__pfet_01v8 L=0.15 W=0.42 nf=1 m=1
XXc_2_11_XPD1 Xc_2_11.q Xc_2_11.qb vss vss sky130_fd_pr__nfet_01v8 L=0.15 W=0.63 nf=1 m=1
XXc_2_11_XPU2 Xc_2_11.qb Xc_2_11.q vdd vdd sky130_fd_pr__pfet_01v8 L=0.15 W=0.42 nf=1 m=1
XXc_2_11_XPD2 Xc_2_11.qb Xc_2_11.q vss vss sky130_fd_pr__nfet_01v8 L=0.15 W=0.63 nf=1 m=1
XXc_2_11_XPG1 bl11 wl2 Xc_2_11.q vss sky130_fd_pr__nfet_01v8 L=0.15 W=0.42 nf=1 m=1
XXc_2_11_XPG2 blb11 wl2 Xc_2_11.qb vss sky130_fd_pr__nfet_01v8 L=0.15 W=0.42 nf=1 m=1
XXc_2_12_XPU1 Xc_2_12.q Xc_2_12.qb vdd vdd sky130_fd_pr__pfet_01v8 L=0.15 W=0.42 nf=1 m=1
XXc_2_12_XPD1 Xc_2_12.q Xc_2_12.qb vss vss sky130_fd_pr__nfet_01v8 L=0.15 W=0.63 nf=1 m=1
XXc_2_12_XPU2 Xc_2_12.qb Xc_2_12.q vdd vdd sky130_fd_pr__pfet_01v8 L=0.15 W=0.42 nf=1 m=1
XXc_2_12_XPD2 Xc_2_12.qb Xc_2_12.q vss vss sky130_fd_pr__nfet_01v8 L=0.15 W=0.63 nf=1 m=1
XXc_2_12_XPG1 bl12 wl2 Xc_2_12.q vss sky130_fd_pr__nfet_01v8 L=0.15 W=0.42 nf=1 m=1
XXc_2_12_XPG2 blb12 wl2 Xc_2_12.qb vss sky130_fd_pr__nfet_01v8 L=0.15 W=0.42 nf=1 m=1
XXc_2_13_XPU1 Xc_2_13.q Xc_2_13.qb vdd vdd sky130_fd_pr__pfet_01v8 L=0.15 W=0.42 nf=1 m=1
XXc_2_13_XPD1 Xc_2_13.q Xc_2_13.qb vss vss sky130_fd_pr__nfet_01v8 L=0.15 W=0.63 nf=1 m=1
XXc_2_13_XPU2 Xc_2_13.qb Xc_2_13.q vdd vdd sky130_fd_pr__pfet_01v8 L=0.15 W=0.42 nf=1 m=1
XXc_2_13_XPD2 Xc_2_13.qb Xc_2_13.q vss vss sky130_fd_pr__nfet_01v8 L=0.15 W=0.63 nf=1 m=1
XXc_2_13_XPG1 bl13 wl2 Xc_2_13.q vss sky130_fd_pr__nfet_01v8 L=0.15 W=0.42 nf=1 m=1
XXc_2_13_XPG2 blb13 wl2 Xc_2_13.qb vss sky130_fd_pr__nfet_01v8 L=0.15 W=0.42 nf=1 m=1
XXc_2_14_XPU1 Xc_2_14.q Xc_2_14.qb vdd vdd sky130_fd_pr__pfet_01v8 L=0.15 W=0.42 nf=1 m=1
XXc_2_14_XPD1 Xc_2_14.q Xc_2_14.qb vss vss sky130_fd_pr__nfet_01v8 L=0.15 W=0.63 nf=1 m=1
XXc_2_14_XPU2 Xc_2_14.qb Xc_2_14.q vdd vdd sky130_fd_pr__pfet_01v8 L=0.15 W=0.42 nf=1 m=1
XXc_2_14_XPD2 Xc_2_14.qb Xc_2_14.q vss vss sky130_fd_pr__nfet_01v8 L=0.15 W=0.63 nf=1 m=1
XXc_2_14_XPG1 bl14 wl2 Xc_2_14.q vss sky130_fd_pr__nfet_01v8 L=0.15 W=0.42 nf=1 m=1
XXc_2_14_XPG2 blb14 wl2 Xc_2_14.qb vss sky130_fd_pr__nfet_01v8 L=0.15 W=0.42 nf=1 m=1
XXc_2_15_XPU1 Xc_2_15.q Xc_2_15.qb vdd vdd sky130_fd_pr__pfet_01v8 L=0.15 W=0.42 nf=1 m=1
XXc_2_15_XPD1 Xc_2_15.q Xc_2_15.qb vss vss sky130_fd_pr__nfet_01v8 L=0.15 W=0.63 nf=1 m=1
XXc_2_15_XPU2 Xc_2_15.qb Xc_2_15.q vdd vdd sky130_fd_pr__pfet_01v8 L=0.15 W=0.42 nf=1 m=1
XXc_2_15_XPD2 Xc_2_15.qb Xc_2_15.q vss vss sky130_fd_pr__nfet_01v8 L=0.15 W=0.63 nf=1 m=1
XXc_2_15_XPG1 bl15 wl2 Xc_2_15.q vss sky130_fd_pr__nfet_01v8 L=0.15 W=0.42 nf=1 m=1
XXc_2_15_XPG2 blb15 wl2 Xc_2_15.qb vss sky130_fd_pr__nfet_01v8 L=0.15 W=0.42 nf=1 m=1
XXc_3_0_XPU1 Xc_3_0.q Xc_3_0.qb vdd vdd sky130_fd_pr__pfet_01v8 L=0.15 W=0.42 nf=1 m=1
XXc_3_0_XPD1 Xc_3_0.q Xc_3_0.qb vss vss sky130_fd_pr__nfet_01v8 L=0.15 W=0.63 nf=1 m=1
XXc_3_0_XPU2 Xc_3_0.qb Xc_3_0.q vdd vdd sky130_fd_pr__pfet_01v8 L=0.15 W=0.42 nf=1 m=1
XXc_3_0_XPD2 Xc_3_0.qb Xc_3_0.q vss vss sky130_fd_pr__nfet_01v8 L=0.15 W=0.63 nf=1 m=1
XXc_3_0_XPG1 bl0 wl3 Xc_3_0.q vss sky130_fd_pr__nfet_01v8 L=0.15 W=0.42 nf=1 m=1
XXc_3_0_XPG2 blb0 wl3 Xc_3_0.qb vss sky130_fd_pr__nfet_01v8 L=0.15 W=0.42 nf=1 m=1
XXc_3_1_XPU1 Xc_3_1.q Xc_3_1.qb vdd vdd sky130_fd_pr__pfet_01v8 L=0.15 W=0.42 nf=1 m=1
XXc_3_1_XPD1 Xc_3_1.q Xc_3_1.qb vss vss sky130_fd_pr__nfet_01v8 L=0.15 W=0.63 nf=1 m=1
XXc_3_1_XPU2 Xc_3_1.qb Xc_3_1.q vdd vdd sky130_fd_pr__pfet_01v8 L=0.15 W=0.42 nf=1 m=1
XXc_3_1_XPD2 Xc_3_1.qb Xc_3_1.q vss vss sky130_fd_pr__nfet_01v8 L=0.15 W=0.63 nf=1 m=1
XXc_3_1_XPG1 bl1 wl3 Xc_3_1.q vss sky130_fd_pr__nfet_01v8 L=0.15 W=0.42 nf=1 m=1
XXc_3_1_XPG2 blb1 wl3 Xc_3_1.qb vss sky130_fd_pr__nfet_01v8 L=0.15 W=0.42 nf=1 m=1
XXc_3_2_XPU1 Xc_3_2.q Xc_3_2.qb vdd vdd sky130_fd_pr__pfet_01v8 L=0.15 W=0.42 nf=1 m=1
XXc_3_2_XPD1 Xc_3_2.q Xc_3_2.qb vss vss sky130_fd_pr__nfet_01v8 L=0.15 W=0.63 nf=1 m=1
XXc_3_2_XPU2 Xc_3_2.qb Xc_3_2.q vdd vdd sky130_fd_pr__pfet_01v8 L=0.15 W=0.42 nf=1 m=1
XXc_3_2_XPD2 Xc_3_2.qb Xc_3_2.q vss vss sky130_fd_pr__nfet_01v8 L=0.15 W=0.63 nf=1 m=1
XXc_3_2_XPG1 bl2 wl3 Xc_3_2.q vss sky130_fd_pr__nfet_01v8 L=0.15 W=0.42 nf=1 m=1
XXc_3_2_XPG2 blb2 wl3 Xc_3_2.qb vss sky130_fd_pr__nfet_01v8 L=0.15 W=0.42 nf=1 m=1
XXc_3_3_XPU1 Xc_3_3.q Xc_3_3.qb vdd vdd sky130_fd_pr__pfet_01v8 L=0.15 W=0.42 nf=1 m=1
XXc_3_3_XPD1 Xc_3_3.q Xc_3_3.qb vss vss sky130_fd_pr__nfet_01v8 L=0.15 W=0.63 nf=1 m=1
XXc_3_3_XPU2 Xc_3_3.qb Xc_3_3.q vdd vdd sky130_fd_pr__pfet_01v8 L=0.15 W=0.42 nf=1 m=1
XXc_3_3_XPD2 Xc_3_3.qb Xc_3_3.q vss vss sky130_fd_pr__nfet_01v8 L=0.15 W=0.63 nf=1 m=1
XXc_3_3_XPG1 bl3 wl3 Xc_3_3.q vss sky130_fd_pr__nfet_01v8 L=0.15 W=0.42 nf=1 m=1
XXc_3_3_XPG2 blb3 wl3 Xc_3_3.qb vss sky130_fd_pr__nfet_01v8 L=0.15 W=0.42 nf=1 m=1
XXc_3_4_XPU1 Xc_3_4.q Xc_3_4.qb vdd vdd sky130_fd_pr__pfet_01v8 L=0.15 W=0.42 nf=1 m=1
XXc_3_4_XPD1 Xc_3_4.q Xc_3_4.qb vss vss sky130_fd_pr__nfet_01v8 L=0.15 W=0.63 nf=1 m=1
XXc_3_4_XPU2 Xc_3_4.qb Xc_3_4.q vdd vdd sky130_fd_pr__pfet_01v8 L=0.15 W=0.42 nf=1 m=1
XXc_3_4_XPD2 Xc_3_4.qb Xc_3_4.q vss vss sky130_fd_pr__nfet_01v8 L=0.15 W=0.63 nf=1 m=1
XXc_3_4_XPG1 bl4 wl3 Xc_3_4.q vss sky130_fd_pr__nfet_01v8 L=0.15 W=0.42 nf=1 m=1
XXc_3_4_XPG2 blb4 wl3 Xc_3_4.qb vss sky130_fd_pr__nfet_01v8 L=0.15 W=0.42 nf=1 m=1
XXc_3_5_XPU1 Xc_3_5.q Xc_3_5.qb vdd vdd sky130_fd_pr__pfet_01v8 L=0.15 W=0.42 nf=1 m=1
XXc_3_5_XPD1 Xc_3_5.q Xc_3_5.qb vss vss sky130_fd_pr__nfet_01v8 L=0.15 W=0.63 nf=1 m=1
XXc_3_5_XPU2 Xc_3_5.qb Xc_3_5.q vdd vdd sky130_fd_pr__pfet_01v8 L=0.15 W=0.42 nf=1 m=1
XXc_3_5_XPD2 Xc_3_5.qb Xc_3_5.q vss vss sky130_fd_pr__nfet_01v8 L=0.15 W=0.63 nf=1 m=1
XXc_3_5_XPG1 bl5 wl3 Xc_3_5.q vss sky130_fd_pr__nfet_01v8 L=0.15 W=0.42 nf=1 m=1
XXc_3_5_XPG2 blb5 wl3 Xc_3_5.qb vss sky130_fd_pr__nfet_01v8 L=0.15 W=0.42 nf=1 m=1
XXc_3_6_XPU1 Xc_3_6.q Xc_3_6.qb vdd vdd sky130_fd_pr__pfet_01v8 L=0.15 W=0.42 nf=1 m=1
XXc_3_6_XPD1 Xc_3_6.q Xc_3_6.qb vss vss sky130_fd_pr__nfet_01v8 L=0.15 W=0.63 nf=1 m=1
XXc_3_6_XPU2 Xc_3_6.qb Xc_3_6.q vdd vdd sky130_fd_pr__pfet_01v8 L=0.15 W=0.42 nf=1 m=1
XXc_3_6_XPD2 Xc_3_6.qb Xc_3_6.q vss vss sky130_fd_pr__nfet_01v8 L=0.15 W=0.63 nf=1 m=1
XXc_3_6_XPG1 bl6 wl3 Xc_3_6.q vss sky130_fd_pr__nfet_01v8 L=0.15 W=0.42 nf=1 m=1
XXc_3_6_XPG2 blb6 wl3 Xc_3_6.qb vss sky130_fd_pr__nfet_01v8 L=0.15 W=0.42 nf=1 m=1
XXc_3_7_XPU1 Xc_3_7.q Xc_3_7.qb vdd vdd sky130_fd_pr__pfet_01v8 L=0.15 W=0.42 nf=1 m=1
XXc_3_7_XPD1 Xc_3_7.q Xc_3_7.qb vss vss sky130_fd_pr__nfet_01v8 L=0.15 W=0.63 nf=1 m=1
XXc_3_7_XPU2 Xc_3_7.qb Xc_3_7.q vdd vdd sky130_fd_pr__pfet_01v8 L=0.15 W=0.42 nf=1 m=1
XXc_3_7_XPD2 Xc_3_7.qb Xc_3_7.q vss vss sky130_fd_pr__nfet_01v8 L=0.15 W=0.63 nf=1 m=1
XXc_3_7_XPG1 bl7 wl3 Xc_3_7.q vss sky130_fd_pr__nfet_01v8 L=0.15 W=0.42 nf=1 m=1
XXc_3_7_XPG2 blb7 wl3 Xc_3_7.qb vss sky130_fd_pr__nfet_01v8 L=0.15 W=0.42 nf=1 m=1
XXc_3_8_XPU1 Xc_3_8.q Xc_3_8.qb vdd vdd sky130_fd_pr__pfet_01v8 L=0.15 W=0.42 nf=1 m=1
XXc_3_8_XPD1 Xc_3_8.q Xc_3_8.qb vss vss sky130_fd_pr__nfet_01v8 L=0.15 W=0.63 nf=1 m=1
XXc_3_8_XPU2 Xc_3_8.qb Xc_3_8.q vdd vdd sky130_fd_pr__pfet_01v8 L=0.15 W=0.42 nf=1 m=1
XXc_3_8_XPD2 Xc_3_8.qb Xc_3_8.q vss vss sky130_fd_pr__nfet_01v8 L=0.15 W=0.63 nf=1 m=1
XXc_3_8_XPG1 bl8 wl3 Xc_3_8.q vss sky130_fd_pr__nfet_01v8 L=0.15 W=0.42 nf=1 m=1
XXc_3_8_XPG2 blb8 wl3 Xc_3_8.qb vss sky130_fd_pr__nfet_01v8 L=0.15 W=0.42 nf=1 m=1
XXc_3_9_XPU1 Xc_3_9.q Xc_3_9.qb vdd vdd sky130_fd_pr__pfet_01v8 L=0.15 W=0.42 nf=1 m=1
XXc_3_9_XPD1 Xc_3_9.q Xc_3_9.qb vss vss sky130_fd_pr__nfet_01v8 L=0.15 W=0.63 nf=1 m=1
XXc_3_9_XPU2 Xc_3_9.qb Xc_3_9.q vdd vdd sky130_fd_pr__pfet_01v8 L=0.15 W=0.42 nf=1 m=1
XXc_3_9_XPD2 Xc_3_9.qb Xc_3_9.q vss vss sky130_fd_pr__nfet_01v8 L=0.15 W=0.63 nf=1 m=1
XXc_3_9_XPG1 bl9 wl3 Xc_3_9.q vss sky130_fd_pr__nfet_01v8 L=0.15 W=0.42 nf=1 m=1
XXc_3_9_XPG2 blb9 wl3 Xc_3_9.qb vss sky130_fd_pr__nfet_01v8 L=0.15 W=0.42 nf=1 m=1
XXc_3_10_XPU1 Xc_3_10.q Xc_3_10.qb vdd vdd sky130_fd_pr__pfet_01v8 L=0.15 W=0.42 nf=1 m=1
XXc_3_10_XPD1 Xc_3_10.q Xc_3_10.qb vss vss sky130_fd_pr__nfet_01v8 L=0.15 W=0.63 nf=1 m=1
XXc_3_10_XPU2 Xc_3_10.qb Xc_3_10.q vdd vdd sky130_fd_pr__pfet_01v8 L=0.15 W=0.42 nf=1 m=1
XXc_3_10_XPD2 Xc_3_10.qb Xc_3_10.q vss vss sky130_fd_pr__nfet_01v8 L=0.15 W=0.63 nf=1 m=1
XXc_3_10_XPG1 bl10 wl3 Xc_3_10.q vss sky130_fd_pr__nfet_01v8 L=0.15 W=0.42 nf=1 m=1
XXc_3_10_XPG2 blb10 wl3 Xc_3_10.qb vss sky130_fd_pr__nfet_01v8 L=0.15 W=0.42 nf=1 m=1
XXc_3_11_XPU1 Xc_3_11.q Xc_3_11.qb vdd vdd sky130_fd_pr__pfet_01v8 L=0.15 W=0.42 nf=1 m=1
XXc_3_11_XPD1 Xc_3_11.q Xc_3_11.qb vss vss sky130_fd_pr__nfet_01v8 L=0.15 W=0.63 nf=1 m=1
XXc_3_11_XPU2 Xc_3_11.qb Xc_3_11.q vdd vdd sky130_fd_pr__pfet_01v8 L=0.15 W=0.42 nf=1 m=1
XXc_3_11_XPD2 Xc_3_11.qb Xc_3_11.q vss vss sky130_fd_pr__nfet_01v8 L=0.15 W=0.63 nf=1 m=1
XXc_3_11_XPG1 bl11 wl3 Xc_3_11.q vss sky130_fd_pr__nfet_01v8 L=0.15 W=0.42 nf=1 m=1
XXc_3_11_XPG2 blb11 wl3 Xc_3_11.qb vss sky130_fd_pr__nfet_01v8 L=0.15 W=0.42 nf=1 m=1
XXc_3_12_XPU1 Xc_3_12.q Xc_3_12.qb vdd vdd sky130_fd_pr__pfet_01v8 L=0.15 W=0.42 nf=1 m=1
XXc_3_12_XPD1 Xc_3_12.q Xc_3_12.qb vss vss sky130_fd_pr__nfet_01v8 L=0.15 W=0.63 nf=1 m=1
XXc_3_12_XPU2 Xc_3_12.qb Xc_3_12.q vdd vdd sky130_fd_pr__pfet_01v8 L=0.15 W=0.42 nf=1 m=1
XXc_3_12_XPD2 Xc_3_12.qb Xc_3_12.q vss vss sky130_fd_pr__nfet_01v8 L=0.15 W=0.63 nf=1 m=1
XXc_3_12_XPG1 bl12 wl3 Xc_3_12.q vss sky130_fd_pr__nfet_01v8 L=0.15 W=0.42 nf=1 m=1
XXc_3_12_XPG2 blb12 wl3 Xc_3_12.qb vss sky130_fd_pr__nfet_01v8 L=0.15 W=0.42 nf=1 m=1
XXc_3_13_XPU1 Xc_3_13.q Xc_3_13.qb vdd vdd sky130_fd_pr__pfet_01v8 L=0.15 W=0.42 nf=1 m=1
XXc_3_13_XPD1 Xc_3_13.q Xc_3_13.qb vss vss sky130_fd_pr__nfet_01v8 L=0.15 W=0.63 nf=1 m=1
XXc_3_13_XPU2 Xc_3_13.qb Xc_3_13.q vdd vdd sky130_fd_pr__pfet_01v8 L=0.15 W=0.42 nf=1 m=1
XXc_3_13_XPD2 Xc_3_13.qb Xc_3_13.q vss vss sky130_fd_pr__nfet_01v8 L=0.15 W=0.63 nf=1 m=1
XXc_3_13_XPG1 bl13 wl3 Xc_3_13.q vss sky130_fd_pr__nfet_01v8 L=0.15 W=0.42 nf=1 m=1
XXc_3_13_XPG2 blb13 wl3 Xc_3_13.qb vss sky130_fd_pr__nfet_01v8 L=0.15 W=0.42 nf=1 m=1
XXc_3_14_XPU1 Xc_3_14.q Xc_3_14.qb vdd vdd sky130_fd_pr__pfet_01v8 L=0.15 W=0.42 nf=1 m=1
XXc_3_14_XPD1 Xc_3_14.q Xc_3_14.qb vss vss sky130_fd_pr__nfet_01v8 L=0.15 W=0.63 nf=1 m=1
XXc_3_14_XPU2 Xc_3_14.qb Xc_3_14.q vdd vdd sky130_fd_pr__pfet_01v8 L=0.15 W=0.42 nf=1 m=1
XXc_3_14_XPD2 Xc_3_14.qb Xc_3_14.q vss vss sky130_fd_pr__nfet_01v8 L=0.15 W=0.63 nf=1 m=1
XXc_3_14_XPG1 bl14 wl3 Xc_3_14.q vss sky130_fd_pr__nfet_01v8 L=0.15 W=0.42 nf=1 m=1
XXc_3_14_XPG2 blb14 wl3 Xc_3_14.qb vss sky130_fd_pr__nfet_01v8 L=0.15 W=0.42 nf=1 m=1
XXc_3_15_XPU1 Xc_3_15.q Xc_3_15.qb vdd vdd sky130_fd_pr__pfet_01v8 L=0.15 W=0.42 nf=1 m=1
XXc_3_15_XPD1 Xc_3_15.q Xc_3_15.qb vss vss sky130_fd_pr__nfet_01v8 L=0.15 W=0.63 nf=1 m=1
XXc_3_15_XPU2 Xc_3_15.qb Xc_3_15.q vdd vdd sky130_fd_pr__pfet_01v8 L=0.15 W=0.42 nf=1 m=1
XXc_3_15_XPD2 Xc_3_15.qb Xc_3_15.q vss vss sky130_fd_pr__nfet_01v8 L=0.15 W=0.63 nf=1 m=1
XXc_3_15_XPG1 bl15 wl3 Xc_3_15.q vss sky130_fd_pr__nfet_01v8 L=0.15 W=0.42 nf=1 m=1
XXc_3_15_XPG2 blb15 wl3 Xc_3_15.qb vss sky130_fd_pr__nfet_01v8 L=0.15 W=0.42 nf=1 m=1
XXc_4_0_XPU1 Xc_4_0.q Xc_4_0.qb vdd vdd sky130_fd_pr__pfet_01v8 L=0.15 W=0.42 nf=1 m=1
XXc_4_0_XPD1 Xc_4_0.q Xc_4_0.qb vss vss sky130_fd_pr__nfet_01v8 L=0.15 W=0.63 nf=1 m=1
XXc_4_0_XPU2 Xc_4_0.qb Xc_4_0.q vdd vdd sky130_fd_pr__pfet_01v8 L=0.15 W=0.42 nf=1 m=1
XXc_4_0_XPD2 Xc_4_0.qb Xc_4_0.q vss vss sky130_fd_pr__nfet_01v8 L=0.15 W=0.63 nf=1 m=1
XXc_4_0_XPG1 bl0 wl4 Xc_4_0.q vss sky130_fd_pr__nfet_01v8 L=0.15 W=0.42 nf=1 m=1
XXc_4_0_XPG2 blb0 wl4 Xc_4_0.qb vss sky130_fd_pr__nfet_01v8 L=0.15 W=0.42 nf=1 m=1
XXc_4_1_XPU1 Xc_4_1.q Xc_4_1.qb vdd vdd sky130_fd_pr__pfet_01v8 L=0.15 W=0.42 nf=1 m=1
XXc_4_1_XPD1 Xc_4_1.q Xc_4_1.qb vss vss sky130_fd_pr__nfet_01v8 L=0.15 W=0.63 nf=1 m=1
XXc_4_1_XPU2 Xc_4_1.qb Xc_4_1.q vdd vdd sky130_fd_pr__pfet_01v8 L=0.15 W=0.42 nf=1 m=1
XXc_4_1_XPD2 Xc_4_1.qb Xc_4_1.q vss vss sky130_fd_pr__nfet_01v8 L=0.15 W=0.63 nf=1 m=1
XXc_4_1_XPG1 bl1 wl4 Xc_4_1.q vss sky130_fd_pr__nfet_01v8 L=0.15 W=0.42 nf=1 m=1
XXc_4_1_XPG2 blb1 wl4 Xc_4_1.qb vss sky130_fd_pr__nfet_01v8 L=0.15 W=0.42 nf=1 m=1
XXc_4_2_XPU1 Xc_4_2.q Xc_4_2.qb vdd vdd sky130_fd_pr__pfet_01v8 L=0.15 W=0.42 nf=1 m=1
XXc_4_2_XPD1 Xc_4_2.q Xc_4_2.qb vss vss sky130_fd_pr__nfet_01v8 L=0.15 W=0.63 nf=1 m=1
XXc_4_2_XPU2 Xc_4_2.qb Xc_4_2.q vdd vdd sky130_fd_pr__pfet_01v8 L=0.15 W=0.42 nf=1 m=1
XXc_4_2_XPD2 Xc_4_2.qb Xc_4_2.q vss vss sky130_fd_pr__nfet_01v8 L=0.15 W=0.63 nf=1 m=1
XXc_4_2_XPG1 bl2 wl4 Xc_4_2.q vss sky130_fd_pr__nfet_01v8 L=0.15 W=0.42 nf=1 m=1
XXc_4_2_XPG2 blb2 wl4 Xc_4_2.qb vss sky130_fd_pr__nfet_01v8 L=0.15 W=0.42 nf=1 m=1
XXc_4_3_XPU1 Xc_4_3.q Xc_4_3.qb vdd vdd sky130_fd_pr__pfet_01v8 L=0.15 W=0.42 nf=1 m=1
XXc_4_3_XPD1 Xc_4_3.q Xc_4_3.qb vss vss sky130_fd_pr__nfet_01v8 L=0.15 W=0.63 nf=1 m=1
XXc_4_3_XPU2 Xc_4_3.qb Xc_4_3.q vdd vdd sky130_fd_pr__pfet_01v8 L=0.15 W=0.42 nf=1 m=1
XXc_4_3_XPD2 Xc_4_3.qb Xc_4_3.q vss vss sky130_fd_pr__nfet_01v8 L=0.15 W=0.63 nf=1 m=1
XXc_4_3_XPG1 bl3 wl4 Xc_4_3.q vss sky130_fd_pr__nfet_01v8 L=0.15 W=0.42 nf=1 m=1
XXc_4_3_XPG2 blb3 wl4 Xc_4_3.qb vss sky130_fd_pr__nfet_01v8 L=0.15 W=0.42 nf=1 m=1
XXc_4_4_XPU1 Xc_4_4.q Xc_4_4.qb vdd vdd sky130_fd_pr__pfet_01v8 L=0.15 W=0.42 nf=1 m=1
XXc_4_4_XPD1 Xc_4_4.q Xc_4_4.qb vss vss sky130_fd_pr__nfet_01v8 L=0.15 W=0.63 nf=1 m=1
XXc_4_4_XPU2 Xc_4_4.qb Xc_4_4.q vdd vdd sky130_fd_pr__pfet_01v8 L=0.15 W=0.42 nf=1 m=1
XXc_4_4_XPD2 Xc_4_4.qb Xc_4_4.q vss vss sky130_fd_pr__nfet_01v8 L=0.15 W=0.63 nf=1 m=1
XXc_4_4_XPG1 bl4 wl4 Xc_4_4.q vss sky130_fd_pr__nfet_01v8 L=0.15 W=0.42 nf=1 m=1
XXc_4_4_XPG2 blb4 wl4 Xc_4_4.qb vss sky130_fd_pr__nfet_01v8 L=0.15 W=0.42 nf=1 m=1
XXc_4_5_XPU1 Xc_4_5.q Xc_4_5.qb vdd vdd sky130_fd_pr__pfet_01v8 L=0.15 W=0.42 nf=1 m=1
XXc_4_5_XPD1 Xc_4_5.q Xc_4_5.qb vss vss sky130_fd_pr__nfet_01v8 L=0.15 W=0.63 nf=1 m=1
XXc_4_5_XPU2 Xc_4_5.qb Xc_4_5.q vdd vdd sky130_fd_pr__pfet_01v8 L=0.15 W=0.42 nf=1 m=1
XXc_4_5_XPD2 Xc_4_5.qb Xc_4_5.q vss vss sky130_fd_pr__nfet_01v8 L=0.15 W=0.63 nf=1 m=1
XXc_4_5_XPG1 bl5 wl4 Xc_4_5.q vss sky130_fd_pr__nfet_01v8 L=0.15 W=0.42 nf=1 m=1
XXc_4_5_XPG2 blb5 wl4 Xc_4_5.qb vss sky130_fd_pr__nfet_01v8 L=0.15 W=0.42 nf=1 m=1
XXc_4_6_XPU1 Xc_4_6.q Xc_4_6.qb vdd vdd sky130_fd_pr__pfet_01v8 L=0.15 W=0.42 nf=1 m=1
XXc_4_6_XPD1 Xc_4_6.q Xc_4_6.qb vss vss sky130_fd_pr__nfet_01v8 L=0.15 W=0.63 nf=1 m=1
XXc_4_6_XPU2 Xc_4_6.qb Xc_4_6.q vdd vdd sky130_fd_pr__pfet_01v8 L=0.15 W=0.42 nf=1 m=1
XXc_4_6_XPD2 Xc_4_6.qb Xc_4_6.q vss vss sky130_fd_pr__nfet_01v8 L=0.15 W=0.63 nf=1 m=1
XXc_4_6_XPG1 bl6 wl4 Xc_4_6.q vss sky130_fd_pr__nfet_01v8 L=0.15 W=0.42 nf=1 m=1
XXc_4_6_XPG2 blb6 wl4 Xc_4_6.qb vss sky130_fd_pr__nfet_01v8 L=0.15 W=0.42 nf=1 m=1
XXc_4_7_XPU1 Xc_4_7.q Xc_4_7.qb vdd vdd sky130_fd_pr__pfet_01v8 L=0.15 W=0.42 nf=1 m=1
XXc_4_7_XPD1 Xc_4_7.q Xc_4_7.qb vss vss sky130_fd_pr__nfet_01v8 L=0.15 W=0.63 nf=1 m=1
XXc_4_7_XPU2 Xc_4_7.qb Xc_4_7.q vdd vdd sky130_fd_pr__pfet_01v8 L=0.15 W=0.42 nf=1 m=1
XXc_4_7_XPD2 Xc_4_7.qb Xc_4_7.q vss vss sky130_fd_pr__nfet_01v8 L=0.15 W=0.63 nf=1 m=1
XXc_4_7_XPG1 bl7 wl4 Xc_4_7.q vss sky130_fd_pr__nfet_01v8 L=0.15 W=0.42 nf=1 m=1
XXc_4_7_XPG2 blb7 wl4 Xc_4_7.qb vss sky130_fd_pr__nfet_01v8 L=0.15 W=0.42 nf=1 m=1
XXc_4_8_XPU1 Xc_4_8.q Xc_4_8.qb vdd vdd sky130_fd_pr__pfet_01v8 L=0.15 W=0.42 nf=1 m=1
XXc_4_8_XPD1 Xc_4_8.q Xc_4_8.qb vss vss sky130_fd_pr__nfet_01v8 L=0.15 W=0.63 nf=1 m=1
XXc_4_8_XPU2 Xc_4_8.qb Xc_4_8.q vdd vdd sky130_fd_pr__pfet_01v8 L=0.15 W=0.42 nf=1 m=1
XXc_4_8_XPD2 Xc_4_8.qb Xc_4_8.q vss vss sky130_fd_pr__nfet_01v8 L=0.15 W=0.63 nf=1 m=1
XXc_4_8_XPG1 bl8 wl4 Xc_4_8.q vss sky130_fd_pr__nfet_01v8 L=0.15 W=0.42 nf=1 m=1
XXc_4_8_XPG2 blb8 wl4 Xc_4_8.qb vss sky130_fd_pr__nfet_01v8 L=0.15 W=0.42 nf=1 m=1
XXc_4_9_XPU1 Xc_4_9.q Xc_4_9.qb vdd vdd sky130_fd_pr__pfet_01v8 L=0.15 W=0.42 nf=1 m=1
XXc_4_9_XPD1 Xc_4_9.q Xc_4_9.qb vss vss sky130_fd_pr__nfet_01v8 L=0.15 W=0.63 nf=1 m=1
XXc_4_9_XPU2 Xc_4_9.qb Xc_4_9.q vdd vdd sky130_fd_pr__pfet_01v8 L=0.15 W=0.42 nf=1 m=1
XXc_4_9_XPD2 Xc_4_9.qb Xc_4_9.q vss vss sky130_fd_pr__nfet_01v8 L=0.15 W=0.63 nf=1 m=1
XXc_4_9_XPG1 bl9 wl4 Xc_4_9.q vss sky130_fd_pr__nfet_01v8 L=0.15 W=0.42 nf=1 m=1
XXc_4_9_XPG2 blb9 wl4 Xc_4_9.qb vss sky130_fd_pr__nfet_01v8 L=0.15 W=0.42 nf=1 m=1
XXc_4_10_XPU1 Xc_4_10.q Xc_4_10.qb vdd vdd sky130_fd_pr__pfet_01v8 L=0.15 W=0.42 nf=1 m=1
XXc_4_10_XPD1 Xc_4_10.q Xc_4_10.qb vss vss sky130_fd_pr__nfet_01v8 L=0.15 W=0.63 nf=1 m=1
XXc_4_10_XPU2 Xc_4_10.qb Xc_4_10.q vdd vdd sky130_fd_pr__pfet_01v8 L=0.15 W=0.42 nf=1 m=1
XXc_4_10_XPD2 Xc_4_10.qb Xc_4_10.q vss vss sky130_fd_pr__nfet_01v8 L=0.15 W=0.63 nf=1 m=1
XXc_4_10_XPG1 bl10 wl4 Xc_4_10.q vss sky130_fd_pr__nfet_01v8 L=0.15 W=0.42 nf=1 m=1
XXc_4_10_XPG2 blb10 wl4 Xc_4_10.qb vss sky130_fd_pr__nfet_01v8 L=0.15 W=0.42 nf=1 m=1
XXc_4_11_XPU1 Xc_4_11.q Xc_4_11.qb vdd vdd sky130_fd_pr__pfet_01v8 L=0.15 W=0.42 nf=1 m=1
XXc_4_11_XPD1 Xc_4_11.q Xc_4_11.qb vss vss sky130_fd_pr__nfet_01v8 L=0.15 W=0.63 nf=1 m=1
XXc_4_11_XPU2 Xc_4_11.qb Xc_4_11.q vdd vdd sky130_fd_pr__pfet_01v8 L=0.15 W=0.42 nf=1 m=1
XXc_4_11_XPD2 Xc_4_11.qb Xc_4_11.q vss vss sky130_fd_pr__nfet_01v8 L=0.15 W=0.63 nf=1 m=1
XXc_4_11_XPG1 bl11 wl4 Xc_4_11.q vss sky130_fd_pr__nfet_01v8 L=0.15 W=0.42 nf=1 m=1
XXc_4_11_XPG2 blb11 wl4 Xc_4_11.qb vss sky130_fd_pr__nfet_01v8 L=0.15 W=0.42 nf=1 m=1
XXc_4_12_XPU1 Xc_4_12.q Xc_4_12.qb vdd vdd sky130_fd_pr__pfet_01v8 L=0.15 W=0.42 nf=1 m=1
XXc_4_12_XPD1 Xc_4_12.q Xc_4_12.qb vss vss sky130_fd_pr__nfet_01v8 L=0.15 W=0.63 nf=1 m=1
XXc_4_12_XPU2 Xc_4_12.qb Xc_4_12.q vdd vdd sky130_fd_pr__pfet_01v8 L=0.15 W=0.42 nf=1 m=1
XXc_4_12_XPD2 Xc_4_12.qb Xc_4_12.q vss vss sky130_fd_pr__nfet_01v8 L=0.15 W=0.63 nf=1 m=1
XXc_4_12_XPG1 bl12 wl4 Xc_4_12.q vss sky130_fd_pr__nfet_01v8 L=0.15 W=0.42 nf=1 m=1
XXc_4_12_XPG2 blb12 wl4 Xc_4_12.qb vss sky130_fd_pr__nfet_01v8 L=0.15 W=0.42 nf=1 m=1
XXc_4_13_XPU1 Xc_4_13.q Xc_4_13.qb vdd vdd sky130_fd_pr__pfet_01v8 L=0.15 W=0.42 nf=1 m=1
XXc_4_13_XPD1 Xc_4_13.q Xc_4_13.qb vss vss sky130_fd_pr__nfet_01v8 L=0.15 W=0.63 nf=1 m=1
XXc_4_13_XPU2 Xc_4_13.qb Xc_4_13.q vdd vdd sky130_fd_pr__pfet_01v8 L=0.15 W=0.42 nf=1 m=1
XXc_4_13_XPD2 Xc_4_13.qb Xc_4_13.q vss vss sky130_fd_pr__nfet_01v8 L=0.15 W=0.63 nf=1 m=1
XXc_4_13_XPG1 bl13 wl4 Xc_4_13.q vss sky130_fd_pr__nfet_01v8 L=0.15 W=0.42 nf=1 m=1
XXc_4_13_XPG2 blb13 wl4 Xc_4_13.qb vss sky130_fd_pr__nfet_01v8 L=0.15 W=0.42 nf=1 m=1
XXc_4_14_XPU1 Xc_4_14.q Xc_4_14.qb vdd vdd sky130_fd_pr__pfet_01v8 L=0.15 W=0.42 nf=1 m=1
XXc_4_14_XPD1 Xc_4_14.q Xc_4_14.qb vss vss sky130_fd_pr__nfet_01v8 L=0.15 W=0.63 nf=1 m=1
XXc_4_14_XPU2 Xc_4_14.qb Xc_4_14.q vdd vdd sky130_fd_pr__pfet_01v8 L=0.15 W=0.42 nf=1 m=1
XXc_4_14_XPD2 Xc_4_14.qb Xc_4_14.q vss vss sky130_fd_pr__nfet_01v8 L=0.15 W=0.63 nf=1 m=1
XXc_4_14_XPG1 bl14 wl4 Xc_4_14.q vss sky130_fd_pr__nfet_01v8 L=0.15 W=0.42 nf=1 m=1
XXc_4_14_XPG2 blb14 wl4 Xc_4_14.qb vss sky130_fd_pr__nfet_01v8 L=0.15 W=0.42 nf=1 m=1
XXc_4_15_XPU1 Xc_4_15.q Xc_4_15.qb vdd vdd sky130_fd_pr__pfet_01v8 L=0.15 W=0.42 nf=1 m=1
XXc_4_15_XPD1 Xc_4_15.q Xc_4_15.qb vss vss sky130_fd_pr__nfet_01v8 L=0.15 W=0.63 nf=1 m=1
XXc_4_15_XPU2 Xc_4_15.qb Xc_4_15.q vdd vdd sky130_fd_pr__pfet_01v8 L=0.15 W=0.42 nf=1 m=1
XXc_4_15_XPD2 Xc_4_15.qb Xc_4_15.q vss vss sky130_fd_pr__nfet_01v8 L=0.15 W=0.63 nf=1 m=1
XXc_4_15_XPG1 bl15 wl4 Xc_4_15.q vss sky130_fd_pr__nfet_01v8 L=0.15 W=0.42 nf=1 m=1
XXc_4_15_XPG2 blb15 wl4 Xc_4_15.qb vss sky130_fd_pr__nfet_01v8 L=0.15 W=0.42 nf=1 m=1
XXc_5_0_XPU1 Xc_5_0.q Xc_5_0.qb vdd vdd sky130_fd_pr__pfet_01v8 L=0.15 W=0.42 nf=1 m=1
XXc_5_0_XPD1 Xc_5_0.q Xc_5_0.qb vss vss sky130_fd_pr__nfet_01v8 L=0.15 W=0.63 nf=1 m=1
XXc_5_0_XPU2 Xc_5_0.qb Xc_5_0.q vdd vdd sky130_fd_pr__pfet_01v8 L=0.15 W=0.42 nf=1 m=1
XXc_5_0_XPD2 Xc_5_0.qb Xc_5_0.q vss vss sky130_fd_pr__nfet_01v8 L=0.15 W=0.63 nf=1 m=1
XXc_5_0_XPG1 bl0 wl5 Xc_5_0.q vss sky130_fd_pr__nfet_01v8 L=0.15 W=0.42 nf=1 m=1
XXc_5_0_XPG2 blb0 wl5 Xc_5_0.qb vss sky130_fd_pr__nfet_01v8 L=0.15 W=0.42 nf=1 m=1
XXc_5_1_XPU1 Xc_5_1.q Xc_5_1.qb vdd vdd sky130_fd_pr__pfet_01v8 L=0.15 W=0.42 nf=1 m=1
XXc_5_1_XPD1 Xc_5_1.q Xc_5_1.qb vss vss sky130_fd_pr__nfet_01v8 L=0.15 W=0.63 nf=1 m=1
XXc_5_1_XPU2 Xc_5_1.qb Xc_5_1.q vdd vdd sky130_fd_pr__pfet_01v8 L=0.15 W=0.42 nf=1 m=1
XXc_5_1_XPD2 Xc_5_1.qb Xc_5_1.q vss vss sky130_fd_pr__nfet_01v8 L=0.15 W=0.63 nf=1 m=1
XXc_5_1_XPG1 bl1 wl5 Xc_5_1.q vss sky130_fd_pr__nfet_01v8 L=0.15 W=0.42 nf=1 m=1
XXc_5_1_XPG2 blb1 wl5 Xc_5_1.qb vss sky130_fd_pr__nfet_01v8 L=0.15 W=0.42 nf=1 m=1
XXc_5_2_XPU1 Xc_5_2.q Xc_5_2.qb vdd vdd sky130_fd_pr__pfet_01v8 L=0.15 W=0.42 nf=1 m=1
XXc_5_2_XPD1 Xc_5_2.q Xc_5_2.qb vss vss sky130_fd_pr__nfet_01v8 L=0.15 W=0.63 nf=1 m=1
XXc_5_2_XPU2 Xc_5_2.qb Xc_5_2.q vdd vdd sky130_fd_pr__pfet_01v8 L=0.15 W=0.42 nf=1 m=1
XXc_5_2_XPD2 Xc_5_2.qb Xc_5_2.q vss vss sky130_fd_pr__nfet_01v8 L=0.15 W=0.63 nf=1 m=1
XXc_5_2_XPG1 bl2 wl5 Xc_5_2.q vss sky130_fd_pr__nfet_01v8 L=0.15 W=0.42 nf=1 m=1
XXc_5_2_XPG2 blb2 wl5 Xc_5_2.qb vss sky130_fd_pr__nfet_01v8 L=0.15 W=0.42 nf=1 m=1
XXc_5_3_XPU1 Xc_5_3.q Xc_5_3.qb vdd vdd sky130_fd_pr__pfet_01v8 L=0.15 W=0.42 nf=1 m=1
XXc_5_3_XPD1 Xc_5_3.q Xc_5_3.qb vss vss sky130_fd_pr__nfet_01v8 L=0.15 W=0.63 nf=1 m=1
XXc_5_3_XPU2 Xc_5_3.qb Xc_5_3.q vdd vdd sky130_fd_pr__pfet_01v8 L=0.15 W=0.42 nf=1 m=1
XXc_5_3_XPD2 Xc_5_3.qb Xc_5_3.q vss vss sky130_fd_pr__nfet_01v8 L=0.15 W=0.63 nf=1 m=1
XXc_5_3_XPG1 bl3 wl5 Xc_5_3.q vss sky130_fd_pr__nfet_01v8 L=0.15 W=0.42 nf=1 m=1
XXc_5_3_XPG2 blb3 wl5 Xc_5_3.qb vss sky130_fd_pr__nfet_01v8 L=0.15 W=0.42 nf=1 m=1
XXc_5_4_XPU1 Xc_5_4.q Xc_5_4.qb vdd vdd sky130_fd_pr__pfet_01v8 L=0.15 W=0.42 nf=1 m=1
XXc_5_4_XPD1 Xc_5_4.q Xc_5_4.qb vss vss sky130_fd_pr__nfet_01v8 L=0.15 W=0.63 nf=1 m=1
XXc_5_4_XPU2 Xc_5_4.qb Xc_5_4.q vdd vdd sky130_fd_pr__pfet_01v8 L=0.15 W=0.42 nf=1 m=1
XXc_5_4_XPD2 Xc_5_4.qb Xc_5_4.q vss vss sky130_fd_pr__nfet_01v8 L=0.15 W=0.63 nf=1 m=1
XXc_5_4_XPG1 bl4 wl5 Xc_5_4.q vss sky130_fd_pr__nfet_01v8 L=0.15 W=0.42 nf=1 m=1
XXc_5_4_XPG2 blb4 wl5 Xc_5_4.qb vss sky130_fd_pr__nfet_01v8 L=0.15 W=0.42 nf=1 m=1
XXc_5_5_XPU1 Xc_5_5.q Xc_5_5.qb vdd vdd sky130_fd_pr__pfet_01v8 L=0.15 W=0.42 nf=1 m=1
XXc_5_5_XPD1 Xc_5_5.q Xc_5_5.qb vss vss sky130_fd_pr__nfet_01v8 L=0.15 W=0.63 nf=1 m=1
XXc_5_5_XPU2 Xc_5_5.qb Xc_5_5.q vdd vdd sky130_fd_pr__pfet_01v8 L=0.15 W=0.42 nf=1 m=1
XXc_5_5_XPD2 Xc_5_5.qb Xc_5_5.q vss vss sky130_fd_pr__nfet_01v8 L=0.15 W=0.63 nf=1 m=1
XXc_5_5_XPG1 bl5 wl5 Xc_5_5.q vss sky130_fd_pr__nfet_01v8 L=0.15 W=0.42 nf=1 m=1
XXc_5_5_XPG2 blb5 wl5 Xc_5_5.qb vss sky130_fd_pr__nfet_01v8 L=0.15 W=0.42 nf=1 m=1
XXc_5_6_XPU1 Xc_5_6.q Xc_5_6.qb vdd vdd sky130_fd_pr__pfet_01v8 L=0.15 W=0.42 nf=1 m=1
XXc_5_6_XPD1 Xc_5_6.q Xc_5_6.qb vss vss sky130_fd_pr__nfet_01v8 L=0.15 W=0.63 nf=1 m=1
XXc_5_6_XPU2 Xc_5_6.qb Xc_5_6.q vdd vdd sky130_fd_pr__pfet_01v8 L=0.15 W=0.42 nf=1 m=1
XXc_5_6_XPD2 Xc_5_6.qb Xc_5_6.q vss vss sky130_fd_pr__nfet_01v8 L=0.15 W=0.63 nf=1 m=1
XXc_5_6_XPG1 bl6 wl5 Xc_5_6.q vss sky130_fd_pr__nfet_01v8 L=0.15 W=0.42 nf=1 m=1
XXc_5_6_XPG2 blb6 wl5 Xc_5_6.qb vss sky130_fd_pr__nfet_01v8 L=0.15 W=0.42 nf=1 m=1
XXc_5_7_XPU1 Xc_5_7.q Xc_5_7.qb vdd vdd sky130_fd_pr__pfet_01v8 L=0.15 W=0.42 nf=1 m=1
XXc_5_7_XPD1 Xc_5_7.q Xc_5_7.qb vss vss sky130_fd_pr__nfet_01v8 L=0.15 W=0.63 nf=1 m=1
XXc_5_7_XPU2 Xc_5_7.qb Xc_5_7.q vdd vdd sky130_fd_pr__pfet_01v8 L=0.15 W=0.42 nf=1 m=1
XXc_5_7_XPD2 Xc_5_7.qb Xc_5_7.q vss vss sky130_fd_pr__nfet_01v8 L=0.15 W=0.63 nf=1 m=1
XXc_5_7_XPG1 bl7 wl5 Xc_5_7.q vss sky130_fd_pr__nfet_01v8 L=0.15 W=0.42 nf=1 m=1
XXc_5_7_XPG2 blb7 wl5 Xc_5_7.qb vss sky130_fd_pr__nfet_01v8 L=0.15 W=0.42 nf=1 m=1
XXc_5_8_XPU1 Xc_5_8.q Xc_5_8.qb vdd vdd sky130_fd_pr__pfet_01v8 L=0.15 W=0.42 nf=1 m=1
XXc_5_8_XPD1 Xc_5_8.q Xc_5_8.qb vss vss sky130_fd_pr__nfet_01v8 L=0.15 W=0.63 nf=1 m=1
XXc_5_8_XPU2 Xc_5_8.qb Xc_5_8.q vdd vdd sky130_fd_pr__pfet_01v8 L=0.15 W=0.42 nf=1 m=1
XXc_5_8_XPD2 Xc_5_8.qb Xc_5_8.q vss vss sky130_fd_pr__nfet_01v8 L=0.15 W=0.63 nf=1 m=1
XXc_5_8_XPG1 bl8 wl5 Xc_5_8.q vss sky130_fd_pr__nfet_01v8 L=0.15 W=0.42 nf=1 m=1
XXc_5_8_XPG2 blb8 wl5 Xc_5_8.qb vss sky130_fd_pr__nfet_01v8 L=0.15 W=0.42 nf=1 m=1
XXc_5_9_XPU1 Xc_5_9.q Xc_5_9.qb vdd vdd sky130_fd_pr__pfet_01v8 L=0.15 W=0.42 nf=1 m=1
XXc_5_9_XPD1 Xc_5_9.q Xc_5_9.qb vss vss sky130_fd_pr__nfet_01v8 L=0.15 W=0.63 nf=1 m=1
XXc_5_9_XPU2 Xc_5_9.qb Xc_5_9.q vdd vdd sky130_fd_pr__pfet_01v8 L=0.15 W=0.42 nf=1 m=1
XXc_5_9_XPD2 Xc_5_9.qb Xc_5_9.q vss vss sky130_fd_pr__nfet_01v8 L=0.15 W=0.63 nf=1 m=1
XXc_5_9_XPG1 bl9 wl5 Xc_5_9.q vss sky130_fd_pr__nfet_01v8 L=0.15 W=0.42 nf=1 m=1
XXc_5_9_XPG2 blb9 wl5 Xc_5_9.qb vss sky130_fd_pr__nfet_01v8 L=0.15 W=0.42 nf=1 m=1
XXc_5_10_XPU1 Xc_5_10.q Xc_5_10.qb vdd vdd sky130_fd_pr__pfet_01v8 L=0.15 W=0.42 nf=1 m=1
XXc_5_10_XPD1 Xc_5_10.q Xc_5_10.qb vss vss sky130_fd_pr__nfet_01v8 L=0.15 W=0.63 nf=1 m=1
XXc_5_10_XPU2 Xc_5_10.qb Xc_5_10.q vdd vdd sky130_fd_pr__pfet_01v8 L=0.15 W=0.42 nf=1 m=1
XXc_5_10_XPD2 Xc_5_10.qb Xc_5_10.q vss vss sky130_fd_pr__nfet_01v8 L=0.15 W=0.63 nf=1 m=1
XXc_5_10_XPG1 bl10 wl5 Xc_5_10.q vss sky130_fd_pr__nfet_01v8 L=0.15 W=0.42 nf=1 m=1
XXc_5_10_XPG2 blb10 wl5 Xc_5_10.qb vss sky130_fd_pr__nfet_01v8 L=0.15 W=0.42 nf=1 m=1
XXc_5_11_XPU1 Xc_5_11.q Xc_5_11.qb vdd vdd sky130_fd_pr__pfet_01v8 L=0.15 W=0.42 nf=1 m=1
XXc_5_11_XPD1 Xc_5_11.q Xc_5_11.qb vss vss sky130_fd_pr__nfet_01v8 L=0.15 W=0.63 nf=1 m=1
XXc_5_11_XPU2 Xc_5_11.qb Xc_5_11.q vdd vdd sky130_fd_pr__pfet_01v8 L=0.15 W=0.42 nf=1 m=1
XXc_5_11_XPD2 Xc_5_11.qb Xc_5_11.q vss vss sky130_fd_pr__nfet_01v8 L=0.15 W=0.63 nf=1 m=1
XXc_5_11_XPG1 bl11 wl5 Xc_5_11.q vss sky130_fd_pr__nfet_01v8 L=0.15 W=0.42 nf=1 m=1
XXc_5_11_XPG2 blb11 wl5 Xc_5_11.qb vss sky130_fd_pr__nfet_01v8 L=0.15 W=0.42 nf=1 m=1
XXc_5_12_XPU1 Xc_5_12.q Xc_5_12.qb vdd vdd sky130_fd_pr__pfet_01v8 L=0.15 W=0.42 nf=1 m=1
XXc_5_12_XPD1 Xc_5_12.q Xc_5_12.qb vss vss sky130_fd_pr__nfet_01v8 L=0.15 W=0.63 nf=1 m=1
XXc_5_12_XPU2 Xc_5_12.qb Xc_5_12.q vdd vdd sky130_fd_pr__pfet_01v8 L=0.15 W=0.42 nf=1 m=1
XXc_5_12_XPD2 Xc_5_12.qb Xc_5_12.q vss vss sky130_fd_pr__nfet_01v8 L=0.15 W=0.63 nf=1 m=1
XXc_5_12_XPG1 bl12 wl5 Xc_5_12.q vss sky130_fd_pr__nfet_01v8 L=0.15 W=0.42 nf=1 m=1
XXc_5_12_XPG2 blb12 wl5 Xc_5_12.qb vss sky130_fd_pr__nfet_01v8 L=0.15 W=0.42 nf=1 m=1
XXc_5_13_XPU1 Xc_5_13.q Xc_5_13.qb vdd vdd sky130_fd_pr__pfet_01v8 L=0.15 W=0.42 nf=1 m=1
XXc_5_13_XPD1 Xc_5_13.q Xc_5_13.qb vss vss sky130_fd_pr__nfet_01v8 L=0.15 W=0.63 nf=1 m=1
XXc_5_13_XPU2 Xc_5_13.qb Xc_5_13.q vdd vdd sky130_fd_pr__pfet_01v8 L=0.15 W=0.42 nf=1 m=1
XXc_5_13_XPD2 Xc_5_13.qb Xc_5_13.q vss vss sky130_fd_pr__nfet_01v8 L=0.15 W=0.63 nf=1 m=1
XXc_5_13_XPG1 bl13 wl5 Xc_5_13.q vss sky130_fd_pr__nfet_01v8 L=0.15 W=0.42 nf=1 m=1
XXc_5_13_XPG2 blb13 wl5 Xc_5_13.qb vss sky130_fd_pr__nfet_01v8 L=0.15 W=0.42 nf=1 m=1
XXc_5_14_XPU1 Xc_5_14.q Xc_5_14.qb vdd vdd sky130_fd_pr__pfet_01v8 L=0.15 W=0.42 nf=1 m=1
XXc_5_14_XPD1 Xc_5_14.q Xc_5_14.qb vss vss sky130_fd_pr__nfet_01v8 L=0.15 W=0.63 nf=1 m=1
XXc_5_14_XPU2 Xc_5_14.qb Xc_5_14.q vdd vdd sky130_fd_pr__pfet_01v8 L=0.15 W=0.42 nf=1 m=1
XXc_5_14_XPD2 Xc_5_14.qb Xc_5_14.q vss vss sky130_fd_pr__nfet_01v8 L=0.15 W=0.63 nf=1 m=1
XXc_5_14_XPG1 bl14 wl5 Xc_5_14.q vss sky130_fd_pr__nfet_01v8 L=0.15 W=0.42 nf=1 m=1
XXc_5_14_XPG2 blb14 wl5 Xc_5_14.qb vss sky130_fd_pr__nfet_01v8 L=0.15 W=0.42 nf=1 m=1
XXc_5_15_XPU1 Xc_5_15.q Xc_5_15.qb vdd vdd sky130_fd_pr__pfet_01v8 L=0.15 W=0.42 nf=1 m=1
XXc_5_15_XPD1 Xc_5_15.q Xc_5_15.qb vss vss sky130_fd_pr__nfet_01v8 L=0.15 W=0.63 nf=1 m=1
XXc_5_15_XPU2 Xc_5_15.qb Xc_5_15.q vdd vdd sky130_fd_pr__pfet_01v8 L=0.15 W=0.42 nf=1 m=1
XXc_5_15_XPD2 Xc_5_15.qb Xc_5_15.q vss vss sky130_fd_pr__nfet_01v8 L=0.15 W=0.63 nf=1 m=1
XXc_5_15_XPG1 bl15 wl5 Xc_5_15.q vss sky130_fd_pr__nfet_01v8 L=0.15 W=0.42 nf=1 m=1
XXc_5_15_XPG2 blb15 wl5 Xc_5_15.qb vss sky130_fd_pr__nfet_01v8 L=0.15 W=0.42 nf=1 m=1
XXc_6_0_XPU1 Xc_6_0.q Xc_6_0.qb vdd vdd sky130_fd_pr__pfet_01v8 L=0.15 W=0.42 nf=1 m=1
XXc_6_0_XPD1 Xc_6_0.q Xc_6_0.qb vss vss sky130_fd_pr__nfet_01v8 L=0.15 W=0.63 nf=1 m=1
XXc_6_0_XPU2 Xc_6_0.qb Xc_6_0.q vdd vdd sky130_fd_pr__pfet_01v8 L=0.15 W=0.42 nf=1 m=1
XXc_6_0_XPD2 Xc_6_0.qb Xc_6_0.q vss vss sky130_fd_pr__nfet_01v8 L=0.15 W=0.63 nf=1 m=1
XXc_6_0_XPG1 bl0 wl6 Xc_6_0.q vss sky130_fd_pr__nfet_01v8 L=0.15 W=0.42 nf=1 m=1
XXc_6_0_XPG2 blb0 wl6 Xc_6_0.qb vss sky130_fd_pr__nfet_01v8 L=0.15 W=0.42 nf=1 m=1
XXc_6_1_XPU1 Xc_6_1.q Xc_6_1.qb vdd vdd sky130_fd_pr__pfet_01v8 L=0.15 W=0.42 nf=1 m=1
XXc_6_1_XPD1 Xc_6_1.q Xc_6_1.qb vss vss sky130_fd_pr__nfet_01v8 L=0.15 W=0.63 nf=1 m=1
XXc_6_1_XPU2 Xc_6_1.qb Xc_6_1.q vdd vdd sky130_fd_pr__pfet_01v8 L=0.15 W=0.42 nf=1 m=1
XXc_6_1_XPD2 Xc_6_1.qb Xc_6_1.q vss vss sky130_fd_pr__nfet_01v8 L=0.15 W=0.63 nf=1 m=1
XXc_6_1_XPG1 bl1 wl6 Xc_6_1.q vss sky130_fd_pr__nfet_01v8 L=0.15 W=0.42 nf=1 m=1
XXc_6_1_XPG2 blb1 wl6 Xc_6_1.qb vss sky130_fd_pr__nfet_01v8 L=0.15 W=0.42 nf=1 m=1
XXc_6_2_XPU1 Xc_6_2.q Xc_6_2.qb vdd vdd sky130_fd_pr__pfet_01v8 L=0.15 W=0.42 nf=1 m=1
XXc_6_2_XPD1 Xc_6_2.q Xc_6_2.qb vss vss sky130_fd_pr__nfet_01v8 L=0.15 W=0.63 nf=1 m=1
XXc_6_2_XPU2 Xc_6_2.qb Xc_6_2.q vdd vdd sky130_fd_pr__pfet_01v8 L=0.15 W=0.42 nf=1 m=1
XXc_6_2_XPD2 Xc_6_2.qb Xc_6_2.q vss vss sky130_fd_pr__nfet_01v8 L=0.15 W=0.63 nf=1 m=1
XXc_6_2_XPG1 bl2 wl6 Xc_6_2.q vss sky130_fd_pr__nfet_01v8 L=0.15 W=0.42 nf=1 m=1
XXc_6_2_XPG2 blb2 wl6 Xc_6_2.qb vss sky130_fd_pr__nfet_01v8 L=0.15 W=0.42 nf=1 m=1
XXc_6_3_XPU1 Xc_6_3.q Xc_6_3.qb vdd vdd sky130_fd_pr__pfet_01v8 L=0.15 W=0.42 nf=1 m=1
XXc_6_3_XPD1 Xc_6_3.q Xc_6_3.qb vss vss sky130_fd_pr__nfet_01v8 L=0.15 W=0.63 nf=1 m=1
XXc_6_3_XPU2 Xc_6_3.qb Xc_6_3.q vdd vdd sky130_fd_pr__pfet_01v8 L=0.15 W=0.42 nf=1 m=1
XXc_6_3_XPD2 Xc_6_3.qb Xc_6_3.q vss vss sky130_fd_pr__nfet_01v8 L=0.15 W=0.63 nf=1 m=1
XXc_6_3_XPG1 bl3 wl6 Xc_6_3.q vss sky130_fd_pr__nfet_01v8 L=0.15 W=0.42 nf=1 m=1
XXc_6_3_XPG2 blb3 wl6 Xc_6_3.qb vss sky130_fd_pr__nfet_01v8 L=0.15 W=0.42 nf=1 m=1
XXc_6_4_XPU1 Xc_6_4.q Xc_6_4.qb vdd vdd sky130_fd_pr__pfet_01v8 L=0.15 W=0.42 nf=1 m=1
XXc_6_4_XPD1 Xc_6_4.q Xc_6_4.qb vss vss sky130_fd_pr__nfet_01v8 L=0.15 W=0.63 nf=1 m=1
XXc_6_4_XPU2 Xc_6_4.qb Xc_6_4.q vdd vdd sky130_fd_pr__pfet_01v8 L=0.15 W=0.42 nf=1 m=1
XXc_6_4_XPD2 Xc_6_4.qb Xc_6_4.q vss vss sky130_fd_pr__nfet_01v8 L=0.15 W=0.63 nf=1 m=1
XXc_6_4_XPG1 bl4 wl6 Xc_6_4.q vss sky130_fd_pr__nfet_01v8 L=0.15 W=0.42 nf=1 m=1
XXc_6_4_XPG2 blb4 wl6 Xc_6_4.qb vss sky130_fd_pr__nfet_01v8 L=0.15 W=0.42 nf=1 m=1
XXc_6_5_XPU1 Xc_6_5.q Xc_6_5.qb vdd vdd sky130_fd_pr__pfet_01v8 L=0.15 W=0.42 nf=1 m=1
XXc_6_5_XPD1 Xc_6_5.q Xc_6_5.qb vss vss sky130_fd_pr__nfet_01v8 L=0.15 W=0.63 nf=1 m=1
XXc_6_5_XPU2 Xc_6_5.qb Xc_6_5.q vdd vdd sky130_fd_pr__pfet_01v8 L=0.15 W=0.42 nf=1 m=1
XXc_6_5_XPD2 Xc_6_5.qb Xc_6_5.q vss vss sky130_fd_pr__nfet_01v8 L=0.15 W=0.63 nf=1 m=1
XXc_6_5_XPG1 bl5 wl6 Xc_6_5.q vss sky130_fd_pr__nfet_01v8 L=0.15 W=0.42 nf=1 m=1
XXc_6_5_XPG2 blb5 wl6 Xc_6_5.qb vss sky130_fd_pr__nfet_01v8 L=0.15 W=0.42 nf=1 m=1
XXc_6_6_XPU1 Xc_6_6.q Xc_6_6.qb vdd vdd sky130_fd_pr__pfet_01v8 L=0.15 W=0.42 nf=1 m=1
XXc_6_6_XPD1 Xc_6_6.q Xc_6_6.qb vss vss sky130_fd_pr__nfet_01v8 L=0.15 W=0.63 nf=1 m=1
XXc_6_6_XPU2 Xc_6_6.qb Xc_6_6.q vdd vdd sky130_fd_pr__pfet_01v8 L=0.15 W=0.42 nf=1 m=1
XXc_6_6_XPD2 Xc_6_6.qb Xc_6_6.q vss vss sky130_fd_pr__nfet_01v8 L=0.15 W=0.63 nf=1 m=1
XXc_6_6_XPG1 bl6 wl6 Xc_6_6.q vss sky130_fd_pr__nfet_01v8 L=0.15 W=0.42 nf=1 m=1
XXc_6_6_XPG2 blb6 wl6 Xc_6_6.qb vss sky130_fd_pr__nfet_01v8 L=0.15 W=0.42 nf=1 m=1
XXc_6_7_XPU1 Xc_6_7.q Xc_6_7.qb vdd vdd sky130_fd_pr__pfet_01v8 L=0.15 W=0.42 nf=1 m=1
XXc_6_7_XPD1 Xc_6_7.q Xc_6_7.qb vss vss sky130_fd_pr__nfet_01v8 L=0.15 W=0.63 nf=1 m=1
XXc_6_7_XPU2 Xc_6_7.qb Xc_6_7.q vdd vdd sky130_fd_pr__pfet_01v8 L=0.15 W=0.42 nf=1 m=1
XXc_6_7_XPD2 Xc_6_7.qb Xc_6_7.q vss vss sky130_fd_pr__nfet_01v8 L=0.15 W=0.63 nf=1 m=1
XXc_6_7_XPG1 bl7 wl6 Xc_6_7.q vss sky130_fd_pr__nfet_01v8 L=0.15 W=0.42 nf=1 m=1
XXc_6_7_XPG2 blb7 wl6 Xc_6_7.qb vss sky130_fd_pr__nfet_01v8 L=0.15 W=0.42 nf=1 m=1
XXc_6_8_XPU1 Xc_6_8.q Xc_6_8.qb vdd vdd sky130_fd_pr__pfet_01v8 L=0.15 W=0.42 nf=1 m=1
XXc_6_8_XPD1 Xc_6_8.q Xc_6_8.qb vss vss sky130_fd_pr__nfet_01v8 L=0.15 W=0.63 nf=1 m=1
XXc_6_8_XPU2 Xc_6_8.qb Xc_6_8.q vdd vdd sky130_fd_pr__pfet_01v8 L=0.15 W=0.42 nf=1 m=1
XXc_6_8_XPD2 Xc_6_8.qb Xc_6_8.q vss vss sky130_fd_pr__nfet_01v8 L=0.15 W=0.63 nf=1 m=1
XXc_6_8_XPG1 bl8 wl6 Xc_6_8.q vss sky130_fd_pr__nfet_01v8 L=0.15 W=0.42 nf=1 m=1
XXc_6_8_XPG2 blb8 wl6 Xc_6_8.qb vss sky130_fd_pr__nfet_01v8 L=0.15 W=0.42 nf=1 m=1
XXc_6_9_XPU1 Xc_6_9.q Xc_6_9.qb vdd vdd sky130_fd_pr__pfet_01v8 L=0.15 W=0.42 nf=1 m=1
XXc_6_9_XPD1 Xc_6_9.q Xc_6_9.qb vss vss sky130_fd_pr__nfet_01v8 L=0.15 W=0.63 nf=1 m=1
XXc_6_9_XPU2 Xc_6_9.qb Xc_6_9.q vdd vdd sky130_fd_pr__pfet_01v8 L=0.15 W=0.42 nf=1 m=1
XXc_6_9_XPD2 Xc_6_9.qb Xc_6_9.q vss vss sky130_fd_pr__nfet_01v8 L=0.15 W=0.63 nf=1 m=1
XXc_6_9_XPG1 bl9 wl6 Xc_6_9.q vss sky130_fd_pr__nfet_01v8 L=0.15 W=0.42 nf=1 m=1
XXc_6_9_XPG2 blb9 wl6 Xc_6_9.qb vss sky130_fd_pr__nfet_01v8 L=0.15 W=0.42 nf=1 m=1
XXc_6_10_XPU1 Xc_6_10.q Xc_6_10.qb vdd vdd sky130_fd_pr__pfet_01v8 L=0.15 W=0.42 nf=1 m=1
XXc_6_10_XPD1 Xc_6_10.q Xc_6_10.qb vss vss sky130_fd_pr__nfet_01v8 L=0.15 W=0.63 nf=1 m=1
XXc_6_10_XPU2 Xc_6_10.qb Xc_6_10.q vdd vdd sky130_fd_pr__pfet_01v8 L=0.15 W=0.42 nf=1 m=1
XXc_6_10_XPD2 Xc_6_10.qb Xc_6_10.q vss vss sky130_fd_pr__nfet_01v8 L=0.15 W=0.63 nf=1 m=1
XXc_6_10_XPG1 bl10 wl6 Xc_6_10.q vss sky130_fd_pr__nfet_01v8 L=0.15 W=0.42 nf=1 m=1
XXc_6_10_XPG2 blb10 wl6 Xc_6_10.qb vss sky130_fd_pr__nfet_01v8 L=0.15 W=0.42 nf=1 m=1
XXc_6_11_XPU1 Xc_6_11.q Xc_6_11.qb vdd vdd sky130_fd_pr__pfet_01v8 L=0.15 W=0.42 nf=1 m=1
XXc_6_11_XPD1 Xc_6_11.q Xc_6_11.qb vss vss sky130_fd_pr__nfet_01v8 L=0.15 W=0.63 nf=1 m=1
XXc_6_11_XPU2 Xc_6_11.qb Xc_6_11.q vdd vdd sky130_fd_pr__pfet_01v8 L=0.15 W=0.42 nf=1 m=1
XXc_6_11_XPD2 Xc_6_11.qb Xc_6_11.q vss vss sky130_fd_pr__nfet_01v8 L=0.15 W=0.63 nf=1 m=1
XXc_6_11_XPG1 bl11 wl6 Xc_6_11.q vss sky130_fd_pr__nfet_01v8 L=0.15 W=0.42 nf=1 m=1
XXc_6_11_XPG2 blb11 wl6 Xc_6_11.qb vss sky130_fd_pr__nfet_01v8 L=0.15 W=0.42 nf=1 m=1
XXc_6_12_XPU1 Xc_6_12.q Xc_6_12.qb vdd vdd sky130_fd_pr__pfet_01v8 L=0.15 W=0.42 nf=1 m=1
XXc_6_12_XPD1 Xc_6_12.q Xc_6_12.qb vss vss sky130_fd_pr__nfet_01v8 L=0.15 W=0.63 nf=1 m=1
XXc_6_12_XPU2 Xc_6_12.qb Xc_6_12.q vdd vdd sky130_fd_pr__pfet_01v8 L=0.15 W=0.42 nf=1 m=1
XXc_6_12_XPD2 Xc_6_12.qb Xc_6_12.q vss vss sky130_fd_pr__nfet_01v8 L=0.15 W=0.63 nf=1 m=1
XXc_6_12_XPG1 bl12 wl6 Xc_6_12.q vss sky130_fd_pr__nfet_01v8 L=0.15 W=0.42 nf=1 m=1
XXc_6_12_XPG2 blb12 wl6 Xc_6_12.qb vss sky130_fd_pr__nfet_01v8 L=0.15 W=0.42 nf=1 m=1
XXc_6_13_XPU1 Xc_6_13.q Xc_6_13.qb vdd vdd sky130_fd_pr__pfet_01v8 L=0.15 W=0.42 nf=1 m=1
XXc_6_13_XPD1 Xc_6_13.q Xc_6_13.qb vss vss sky130_fd_pr__nfet_01v8 L=0.15 W=0.63 nf=1 m=1
XXc_6_13_XPU2 Xc_6_13.qb Xc_6_13.q vdd vdd sky130_fd_pr__pfet_01v8 L=0.15 W=0.42 nf=1 m=1
XXc_6_13_XPD2 Xc_6_13.qb Xc_6_13.q vss vss sky130_fd_pr__nfet_01v8 L=0.15 W=0.63 nf=1 m=1
XXc_6_13_XPG1 bl13 wl6 Xc_6_13.q vss sky130_fd_pr__nfet_01v8 L=0.15 W=0.42 nf=1 m=1
XXc_6_13_XPG2 blb13 wl6 Xc_6_13.qb vss sky130_fd_pr__nfet_01v8 L=0.15 W=0.42 nf=1 m=1
XXc_6_14_XPU1 Xc_6_14.q Xc_6_14.qb vdd vdd sky130_fd_pr__pfet_01v8 L=0.15 W=0.42 nf=1 m=1
XXc_6_14_XPD1 Xc_6_14.q Xc_6_14.qb vss vss sky130_fd_pr__nfet_01v8 L=0.15 W=0.63 nf=1 m=1
XXc_6_14_XPU2 Xc_6_14.qb Xc_6_14.q vdd vdd sky130_fd_pr__pfet_01v8 L=0.15 W=0.42 nf=1 m=1
XXc_6_14_XPD2 Xc_6_14.qb Xc_6_14.q vss vss sky130_fd_pr__nfet_01v8 L=0.15 W=0.63 nf=1 m=1
XXc_6_14_XPG1 bl14 wl6 Xc_6_14.q vss sky130_fd_pr__nfet_01v8 L=0.15 W=0.42 nf=1 m=1
XXc_6_14_XPG2 blb14 wl6 Xc_6_14.qb vss sky130_fd_pr__nfet_01v8 L=0.15 W=0.42 nf=1 m=1
XXc_6_15_XPU1 Xc_6_15.q Xc_6_15.qb vdd vdd sky130_fd_pr__pfet_01v8 L=0.15 W=0.42 nf=1 m=1
XXc_6_15_XPD1 Xc_6_15.q Xc_6_15.qb vss vss sky130_fd_pr__nfet_01v8 L=0.15 W=0.63 nf=1 m=1
XXc_6_15_XPU2 Xc_6_15.qb Xc_6_15.q vdd vdd sky130_fd_pr__pfet_01v8 L=0.15 W=0.42 nf=1 m=1
XXc_6_15_XPD2 Xc_6_15.qb Xc_6_15.q vss vss sky130_fd_pr__nfet_01v8 L=0.15 W=0.63 nf=1 m=1
XXc_6_15_XPG1 bl15 wl6 Xc_6_15.q vss sky130_fd_pr__nfet_01v8 L=0.15 W=0.42 nf=1 m=1
XXc_6_15_XPG2 blb15 wl6 Xc_6_15.qb vss sky130_fd_pr__nfet_01v8 L=0.15 W=0.42 nf=1 m=1
XXc_7_0_XPU1 Xc_7_0.q Xc_7_0.qb vdd vdd sky130_fd_pr__pfet_01v8 L=0.15 W=0.42 nf=1 m=1
XXc_7_0_XPD1 Xc_7_0.q Xc_7_0.qb vss vss sky130_fd_pr__nfet_01v8 L=0.15 W=0.63 nf=1 m=1
XXc_7_0_XPU2 Xc_7_0.qb Xc_7_0.q vdd vdd sky130_fd_pr__pfet_01v8 L=0.15 W=0.42 nf=1 m=1
XXc_7_0_XPD2 Xc_7_0.qb Xc_7_0.q vss vss sky130_fd_pr__nfet_01v8 L=0.15 W=0.63 nf=1 m=1
XXc_7_0_XPG1 bl0 wl7 Xc_7_0.q vss sky130_fd_pr__nfet_01v8 L=0.15 W=0.42 nf=1 m=1
XXc_7_0_XPG2 blb0 wl7 Xc_7_0.qb vss sky130_fd_pr__nfet_01v8 L=0.15 W=0.42 nf=1 m=1
XXc_7_1_XPU1 Xc_7_1.q Xc_7_1.qb vdd vdd sky130_fd_pr__pfet_01v8 L=0.15 W=0.42 nf=1 m=1
XXc_7_1_XPD1 Xc_7_1.q Xc_7_1.qb vss vss sky130_fd_pr__nfet_01v8 L=0.15 W=0.63 nf=1 m=1
XXc_7_1_XPU2 Xc_7_1.qb Xc_7_1.q vdd vdd sky130_fd_pr__pfet_01v8 L=0.15 W=0.42 nf=1 m=1
XXc_7_1_XPD2 Xc_7_1.qb Xc_7_1.q vss vss sky130_fd_pr__nfet_01v8 L=0.15 W=0.63 nf=1 m=1
XXc_7_1_XPG1 bl1 wl7 Xc_7_1.q vss sky130_fd_pr__nfet_01v8 L=0.15 W=0.42 nf=1 m=1
XXc_7_1_XPG2 blb1 wl7 Xc_7_1.qb vss sky130_fd_pr__nfet_01v8 L=0.15 W=0.42 nf=1 m=1
XXc_7_2_XPU1 Xc_7_2.q Xc_7_2.qb vdd vdd sky130_fd_pr__pfet_01v8 L=0.15 W=0.42 nf=1 m=1
XXc_7_2_XPD1 Xc_7_2.q Xc_7_2.qb vss vss sky130_fd_pr__nfet_01v8 L=0.15 W=0.63 nf=1 m=1
XXc_7_2_XPU2 Xc_7_2.qb Xc_7_2.q vdd vdd sky130_fd_pr__pfet_01v8 L=0.15 W=0.42 nf=1 m=1
XXc_7_2_XPD2 Xc_7_2.qb Xc_7_2.q vss vss sky130_fd_pr__nfet_01v8 L=0.15 W=0.63 nf=1 m=1
XXc_7_2_XPG1 bl2 wl7 Xc_7_2.q vss sky130_fd_pr__nfet_01v8 L=0.15 W=0.42 nf=1 m=1
XXc_7_2_XPG2 blb2 wl7 Xc_7_2.qb vss sky130_fd_pr__nfet_01v8 L=0.15 W=0.42 nf=1 m=1
XXc_7_3_XPU1 Xc_7_3.q Xc_7_3.qb vdd vdd sky130_fd_pr__pfet_01v8 L=0.15 W=0.42 nf=1 m=1
XXc_7_3_XPD1 Xc_7_3.q Xc_7_3.qb vss vss sky130_fd_pr__nfet_01v8 L=0.15 W=0.63 nf=1 m=1
XXc_7_3_XPU2 Xc_7_3.qb Xc_7_3.q vdd vdd sky130_fd_pr__pfet_01v8 L=0.15 W=0.42 nf=1 m=1
XXc_7_3_XPD2 Xc_7_3.qb Xc_7_3.q vss vss sky130_fd_pr__nfet_01v8 L=0.15 W=0.63 nf=1 m=1
XXc_7_3_XPG1 bl3 wl7 Xc_7_3.q vss sky130_fd_pr__nfet_01v8 L=0.15 W=0.42 nf=1 m=1
XXc_7_3_XPG2 blb3 wl7 Xc_7_3.qb vss sky130_fd_pr__nfet_01v8 L=0.15 W=0.42 nf=1 m=1
XXc_7_4_XPU1 Xc_7_4.q Xc_7_4.qb vdd vdd sky130_fd_pr__pfet_01v8 L=0.15 W=0.42 nf=1 m=1
XXc_7_4_XPD1 Xc_7_4.q Xc_7_4.qb vss vss sky130_fd_pr__nfet_01v8 L=0.15 W=0.63 nf=1 m=1
XXc_7_4_XPU2 Xc_7_4.qb Xc_7_4.q vdd vdd sky130_fd_pr__pfet_01v8 L=0.15 W=0.42 nf=1 m=1
XXc_7_4_XPD2 Xc_7_4.qb Xc_7_4.q vss vss sky130_fd_pr__nfet_01v8 L=0.15 W=0.63 nf=1 m=1
XXc_7_4_XPG1 bl4 wl7 Xc_7_4.q vss sky130_fd_pr__nfet_01v8 L=0.15 W=0.42 nf=1 m=1
XXc_7_4_XPG2 blb4 wl7 Xc_7_4.qb vss sky130_fd_pr__nfet_01v8 L=0.15 W=0.42 nf=1 m=1
XXc_7_5_XPU1 Xc_7_5.q Xc_7_5.qb vdd vdd sky130_fd_pr__pfet_01v8 L=0.15 W=0.42 nf=1 m=1
XXc_7_5_XPD1 Xc_7_5.q Xc_7_5.qb vss vss sky130_fd_pr__nfet_01v8 L=0.15 W=0.63 nf=1 m=1
XXc_7_5_XPU2 Xc_7_5.qb Xc_7_5.q vdd vdd sky130_fd_pr__pfet_01v8 L=0.15 W=0.42 nf=1 m=1
XXc_7_5_XPD2 Xc_7_5.qb Xc_7_5.q vss vss sky130_fd_pr__nfet_01v8 L=0.15 W=0.63 nf=1 m=1
XXc_7_5_XPG1 bl5 wl7 Xc_7_5.q vss sky130_fd_pr__nfet_01v8 L=0.15 W=0.42 nf=1 m=1
XXc_7_5_XPG2 blb5 wl7 Xc_7_5.qb vss sky130_fd_pr__nfet_01v8 L=0.15 W=0.42 nf=1 m=1
XXc_7_6_XPU1 Xc_7_6.q Xc_7_6.qb vdd vdd sky130_fd_pr__pfet_01v8 L=0.15 W=0.42 nf=1 m=1
XXc_7_6_XPD1 Xc_7_6.q Xc_7_6.qb vss vss sky130_fd_pr__nfet_01v8 L=0.15 W=0.63 nf=1 m=1
XXc_7_6_XPU2 Xc_7_6.qb Xc_7_6.q vdd vdd sky130_fd_pr__pfet_01v8 L=0.15 W=0.42 nf=1 m=1
XXc_7_6_XPD2 Xc_7_6.qb Xc_7_6.q vss vss sky130_fd_pr__nfet_01v8 L=0.15 W=0.63 nf=1 m=1
XXc_7_6_XPG1 bl6 wl7 Xc_7_6.q vss sky130_fd_pr__nfet_01v8 L=0.15 W=0.42 nf=1 m=1
XXc_7_6_XPG2 blb6 wl7 Xc_7_6.qb vss sky130_fd_pr__nfet_01v8 L=0.15 W=0.42 nf=1 m=1
XXc_7_7_XPU1 Xc_7_7.q Xc_7_7.qb vdd vdd sky130_fd_pr__pfet_01v8 L=0.15 W=0.42 nf=1 m=1
XXc_7_7_XPD1 Xc_7_7.q Xc_7_7.qb vss vss sky130_fd_pr__nfet_01v8 L=0.15 W=0.63 nf=1 m=1
XXc_7_7_XPU2 Xc_7_7.qb Xc_7_7.q vdd vdd sky130_fd_pr__pfet_01v8 L=0.15 W=0.42 nf=1 m=1
XXc_7_7_XPD2 Xc_7_7.qb Xc_7_7.q vss vss sky130_fd_pr__nfet_01v8 L=0.15 W=0.63 nf=1 m=1
XXc_7_7_XPG1 bl7 wl7 Xc_7_7.q vss sky130_fd_pr__nfet_01v8 L=0.15 W=0.42 nf=1 m=1
XXc_7_7_XPG2 blb7 wl7 Xc_7_7.qb vss sky130_fd_pr__nfet_01v8 L=0.15 W=0.42 nf=1 m=1
XXc_7_8_XPU1 Xc_7_8.q Xc_7_8.qb vdd vdd sky130_fd_pr__pfet_01v8 L=0.15 W=0.42 nf=1 m=1
XXc_7_8_XPD1 Xc_7_8.q Xc_7_8.qb vss vss sky130_fd_pr__nfet_01v8 L=0.15 W=0.63 nf=1 m=1
XXc_7_8_XPU2 Xc_7_8.qb Xc_7_8.q vdd vdd sky130_fd_pr__pfet_01v8 L=0.15 W=0.42 nf=1 m=1
XXc_7_8_XPD2 Xc_7_8.qb Xc_7_8.q vss vss sky130_fd_pr__nfet_01v8 L=0.15 W=0.63 nf=1 m=1
XXc_7_8_XPG1 bl8 wl7 Xc_7_8.q vss sky130_fd_pr__nfet_01v8 L=0.15 W=0.42 nf=1 m=1
XXc_7_8_XPG2 blb8 wl7 Xc_7_8.qb vss sky130_fd_pr__nfet_01v8 L=0.15 W=0.42 nf=1 m=1
XXc_7_9_XPU1 Xc_7_9.q Xc_7_9.qb vdd vdd sky130_fd_pr__pfet_01v8 L=0.15 W=0.42 nf=1 m=1
XXc_7_9_XPD1 Xc_7_9.q Xc_7_9.qb vss vss sky130_fd_pr__nfet_01v8 L=0.15 W=0.63 nf=1 m=1
XXc_7_9_XPU2 Xc_7_9.qb Xc_7_9.q vdd vdd sky130_fd_pr__pfet_01v8 L=0.15 W=0.42 nf=1 m=1
XXc_7_9_XPD2 Xc_7_9.qb Xc_7_9.q vss vss sky130_fd_pr__nfet_01v8 L=0.15 W=0.63 nf=1 m=1
XXc_7_9_XPG1 bl9 wl7 Xc_7_9.q vss sky130_fd_pr__nfet_01v8 L=0.15 W=0.42 nf=1 m=1
XXc_7_9_XPG2 blb9 wl7 Xc_7_9.qb vss sky130_fd_pr__nfet_01v8 L=0.15 W=0.42 nf=1 m=1
XXc_7_10_XPU1 Xc_7_10.q Xc_7_10.qb vdd vdd sky130_fd_pr__pfet_01v8 L=0.15 W=0.42 nf=1 m=1
XXc_7_10_XPD1 Xc_7_10.q Xc_7_10.qb vss vss sky130_fd_pr__nfet_01v8 L=0.15 W=0.63 nf=1 m=1
XXc_7_10_XPU2 Xc_7_10.qb Xc_7_10.q vdd vdd sky130_fd_pr__pfet_01v8 L=0.15 W=0.42 nf=1 m=1
XXc_7_10_XPD2 Xc_7_10.qb Xc_7_10.q vss vss sky130_fd_pr__nfet_01v8 L=0.15 W=0.63 nf=1 m=1
XXc_7_10_XPG1 bl10 wl7 Xc_7_10.q vss sky130_fd_pr__nfet_01v8 L=0.15 W=0.42 nf=1 m=1
XXc_7_10_XPG2 blb10 wl7 Xc_7_10.qb vss sky130_fd_pr__nfet_01v8 L=0.15 W=0.42 nf=1 m=1
XXc_7_11_XPU1 Xc_7_11.q Xc_7_11.qb vdd vdd sky130_fd_pr__pfet_01v8 L=0.15 W=0.42 nf=1 m=1
XXc_7_11_XPD1 Xc_7_11.q Xc_7_11.qb vss vss sky130_fd_pr__nfet_01v8 L=0.15 W=0.63 nf=1 m=1
XXc_7_11_XPU2 Xc_7_11.qb Xc_7_11.q vdd vdd sky130_fd_pr__pfet_01v8 L=0.15 W=0.42 nf=1 m=1
XXc_7_11_XPD2 Xc_7_11.qb Xc_7_11.q vss vss sky130_fd_pr__nfet_01v8 L=0.15 W=0.63 nf=1 m=1
XXc_7_11_XPG1 bl11 wl7 Xc_7_11.q vss sky130_fd_pr__nfet_01v8 L=0.15 W=0.42 nf=1 m=1
XXc_7_11_XPG2 blb11 wl7 Xc_7_11.qb vss sky130_fd_pr__nfet_01v8 L=0.15 W=0.42 nf=1 m=1
XXc_7_12_XPU1 Xc_7_12.q Xc_7_12.qb vdd vdd sky130_fd_pr__pfet_01v8 L=0.15 W=0.42 nf=1 m=1
XXc_7_12_XPD1 Xc_7_12.q Xc_7_12.qb vss vss sky130_fd_pr__nfet_01v8 L=0.15 W=0.63 nf=1 m=1
XXc_7_12_XPU2 Xc_7_12.qb Xc_7_12.q vdd vdd sky130_fd_pr__pfet_01v8 L=0.15 W=0.42 nf=1 m=1
XXc_7_12_XPD2 Xc_7_12.qb Xc_7_12.q vss vss sky130_fd_pr__nfet_01v8 L=0.15 W=0.63 nf=1 m=1
XXc_7_12_XPG1 bl12 wl7 Xc_7_12.q vss sky130_fd_pr__nfet_01v8 L=0.15 W=0.42 nf=1 m=1
XXc_7_12_XPG2 blb12 wl7 Xc_7_12.qb vss sky130_fd_pr__nfet_01v8 L=0.15 W=0.42 nf=1 m=1
XXc_7_13_XPU1 Xc_7_13.q Xc_7_13.qb vdd vdd sky130_fd_pr__pfet_01v8 L=0.15 W=0.42 nf=1 m=1
XXc_7_13_XPD1 Xc_7_13.q Xc_7_13.qb vss vss sky130_fd_pr__nfet_01v8 L=0.15 W=0.63 nf=1 m=1
XXc_7_13_XPU2 Xc_7_13.qb Xc_7_13.q vdd vdd sky130_fd_pr__pfet_01v8 L=0.15 W=0.42 nf=1 m=1
XXc_7_13_XPD2 Xc_7_13.qb Xc_7_13.q vss vss sky130_fd_pr__nfet_01v8 L=0.15 W=0.63 nf=1 m=1
XXc_7_13_XPG1 bl13 wl7 Xc_7_13.q vss sky130_fd_pr__nfet_01v8 L=0.15 W=0.42 nf=1 m=1
XXc_7_13_XPG2 blb13 wl7 Xc_7_13.qb vss sky130_fd_pr__nfet_01v8 L=0.15 W=0.42 nf=1 m=1
XXc_7_14_XPU1 Xc_7_14.q Xc_7_14.qb vdd vdd sky130_fd_pr__pfet_01v8 L=0.15 W=0.42 nf=1 m=1
XXc_7_14_XPD1 Xc_7_14.q Xc_7_14.qb vss vss sky130_fd_pr__nfet_01v8 L=0.15 W=0.63 nf=1 m=1
XXc_7_14_XPU2 Xc_7_14.qb Xc_7_14.q vdd vdd sky130_fd_pr__pfet_01v8 L=0.15 W=0.42 nf=1 m=1
XXc_7_14_XPD2 Xc_7_14.qb Xc_7_14.q vss vss sky130_fd_pr__nfet_01v8 L=0.15 W=0.63 nf=1 m=1
XXc_7_14_XPG1 bl14 wl7 Xc_7_14.q vss sky130_fd_pr__nfet_01v8 L=0.15 W=0.42 nf=1 m=1
XXc_7_14_XPG2 blb14 wl7 Xc_7_14.qb vss sky130_fd_pr__nfet_01v8 L=0.15 W=0.42 nf=1 m=1
XXc_7_15_XPU1 Xc_7_15.q Xc_7_15.qb vdd vdd sky130_fd_pr__pfet_01v8 L=0.15 W=0.42 nf=1 m=1
XXc_7_15_XPD1 Xc_7_15.q Xc_7_15.qb vss vss sky130_fd_pr__nfet_01v8 L=0.15 W=0.63 nf=1 m=1
XXc_7_15_XPU2 Xc_7_15.qb Xc_7_15.q vdd vdd sky130_fd_pr__pfet_01v8 L=0.15 W=0.42 nf=1 m=1
XXc_7_15_XPD2 Xc_7_15.qb Xc_7_15.q vss vss sky130_fd_pr__nfet_01v8 L=0.15 W=0.63 nf=1 m=1
XXc_7_15_XPG1 bl15 wl7 Xc_7_15.q vss sky130_fd_pr__nfet_01v8 L=0.15 W=0.42 nf=1 m=1
XXc_7_15_XPG2 blb15 wl7 Xc_7_15.qb vss sky130_fd_pr__nfet_01v8 L=0.15 W=0.42 nf=1 m=1
XXc_8_0_XPU1 Xc_8_0.q Xc_8_0.qb vdd vdd sky130_fd_pr__pfet_01v8 L=0.15 W=0.42 nf=1 m=1
XXc_8_0_XPD1 Xc_8_0.q Xc_8_0.qb vss vss sky130_fd_pr__nfet_01v8 L=0.15 W=0.63 nf=1 m=1
XXc_8_0_XPU2 Xc_8_0.qb Xc_8_0.q vdd vdd sky130_fd_pr__pfet_01v8 L=0.15 W=0.42 nf=1 m=1
XXc_8_0_XPD2 Xc_8_0.qb Xc_8_0.q vss vss sky130_fd_pr__nfet_01v8 L=0.15 W=0.63 nf=1 m=1
XXc_8_0_XPG1 bl0 wl8 Xc_8_0.q vss sky130_fd_pr__nfet_01v8 L=0.15 W=0.42 nf=1 m=1
XXc_8_0_XPG2 blb0 wl8 Xc_8_0.qb vss sky130_fd_pr__nfet_01v8 L=0.15 W=0.42 nf=1 m=1
XXc_8_1_XPU1 Xc_8_1.q Xc_8_1.qb vdd vdd sky130_fd_pr__pfet_01v8 L=0.15 W=0.42 nf=1 m=1
XXc_8_1_XPD1 Xc_8_1.q Xc_8_1.qb vss vss sky130_fd_pr__nfet_01v8 L=0.15 W=0.63 nf=1 m=1
XXc_8_1_XPU2 Xc_8_1.qb Xc_8_1.q vdd vdd sky130_fd_pr__pfet_01v8 L=0.15 W=0.42 nf=1 m=1
XXc_8_1_XPD2 Xc_8_1.qb Xc_8_1.q vss vss sky130_fd_pr__nfet_01v8 L=0.15 W=0.63 nf=1 m=1
XXc_8_1_XPG1 bl1 wl8 Xc_8_1.q vss sky130_fd_pr__nfet_01v8 L=0.15 W=0.42 nf=1 m=1
XXc_8_1_XPG2 blb1 wl8 Xc_8_1.qb vss sky130_fd_pr__nfet_01v8 L=0.15 W=0.42 nf=1 m=1
XXc_8_2_XPU1 Xc_8_2.q Xc_8_2.qb vdd vdd sky130_fd_pr__pfet_01v8 L=0.15 W=0.42 nf=1 m=1
XXc_8_2_XPD1 Xc_8_2.q Xc_8_2.qb vss vss sky130_fd_pr__nfet_01v8 L=0.15 W=0.63 nf=1 m=1
XXc_8_2_XPU2 Xc_8_2.qb Xc_8_2.q vdd vdd sky130_fd_pr__pfet_01v8 L=0.15 W=0.42 nf=1 m=1
XXc_8_2_XPD2 Xc_8_2.qb Xc_8_2.q vss vss sky130_fd_pr__nfet_01v8 L=0.15 W=0.63 nf=1 m=1
XXc_8_2_XPG1 bl2 wl8 Xc_8_2.q vss sky130_fd_pr__nfet_01v8 L=0.15 W=0.42 nf=1 m=1
XXc_8_2_XPG2 blb2 wl8 Xc_8_2.qb vss sky130_fd_pr__nfet_01v8 L=0.15 W=0.42 nf=1 m=1
XXc_8_3_XPU1 Xc_8_3.q Xc_8_3.qb vdd vdd sky130_fd_pr__pfet_01v8 L=0.15 W=0.42 nf=1 m=1
XXc_8_3_XPD1 Xc_8_3.q Xc_8_3.qb vss vss sky130_fd_pr__nfet_01v8 L=0.15 W=0.63 nf=1 m=1
XXc_8_3_XPU2 Xc_8_3.qb Xc_8_3.q vdd vdd sky130_fd_pr__pfet_01v8 L=0.15 W=0.42 nf=1 m=1
XXc_8_3_XPD2 Xc_8_3.qb Xc_8_3.q vss vss sky130_fd_pr__nfet_01v8 L=0.15 W=0.63 nf=1 m=1
XXc_8_3_XPG1 bl3 wl8 Xc_8_3.q vss sky130_fd_pr__nfet_01v8 L=0.15 W=0.42 nf=1 m=1
XXc_8_3_XPG2 blb3 wl8 Xc_8_3.qb vss sky130_fd_pr__nfet_01v8 L=0.15 W=0.42 nf=1 m=1
XXc_8_4_XPU1 Xc_8_4.q Xc_8_4.qb vdd vdd sky130_fd_pr__pfet_01v8 L=0.15 W=0.42 nf=1 m=1
XXc_8_4_XPD1 Xc_8_4.q Xc_8_4.qb vss vss sky130_fd_pr__nfet_01v8 L=0.15 W=0.63 nf=1 m=1
XXc_8_4_XPU2 Xc_8_4.qb Xc_8_4.q vdd vdd sky130_fd_pr__pfet_01v8 L=0.15 W=0.42 nf=1 m=1
XXc_8_4_XPD2 Xc_8_4.qb Xc_8_4.q vss vss sky130_fd_pr__nfet_01v8 L=0.15 W=0.63 nf=1 m=1
XXc_8_4_XPG1 bl4 wl8 Xc_8_4.q vss sky130_fd_pr__nfet_01v8 L=0.15 W=0.42 nf=1 m=1
XXc_8_4_XPG2 blb4 wl8 Xc_8_4.qb vss sky130_fd_pr__nfet_01v8 L=0.15 W=0.42 nf=1 m=1
XXc_8_5_XPU1 Xc_8_5.q Xc_8_5.qb vdd vdd sky130_fd_pr__pfet_01v8 L=0.15 W=0.42 nf=1 m=1
XXc_8_5_XPD1 Xc_8_5.q Xc_8_5.qb vss vss sky130_fd_pr__nfet_01v8 L=0.15 W=0.63 nf=1 m=1
XXc_8_5_XPU2 Xc_8_5.qb Xc_8_5.q vdd vdd sky130_fd_pr__pfet_01v8 L=0.15 W=0.42 nf=1 m=1
XXc_8_5_XPD2 Xc_8_5.qb Xc_8_5.q vss vss sky130_fd_pr__nfet_01v8 L=0.15 W=0.63 nf=1 m=1
XXc_8_5_XPG1 bl5 wl8 Xc_8_5.q vss sky130_fd_pr__nfet_01v8 L=0.15 W=0.42 nf=1 m=1
XXc_8_5_XPG2 blb5 wl8 Xc_8_5.qb vss sky130_fd_pr__nfet_01v8 L=0.15 W=0.42 nf=1 m=1
XXc_8_6_XPU1 Xc_8_6.q Xc_8_6.qb vdd vdd sky130_fd_pr__pfet_01v8 L=0.15 W=0.42 nf=1 m=1
XXc_8_6_XPD1 Xc_8_6.q Xc_8_6.qb vss vss sky130_fd_pr__nfet_01v8 L=0.15 W=0.63 nf=1 m=1
XXc_8_6_XPU2 Xc_8_6.qb Xc_8_6.q vdd vdd sky130_fd_pr__pfet_01v8 L=0.15 W=0.42 nf=1 m=1
XXc_8_6_XPD2 Xc_8_6.qb Xc_8_6.q vss vss sky130_fd_pr__nfet_01v8 L=0.15 W=0.63 nf=1 m=1
XXc_8_6_XPG1 bl6 wl8 Xc_8_6.q vss sky130_fd_pr__nfet_01v8 L=0.15 W=0.42 nf=1 m=1
XXc_8_6_XPG2 blb6 wl8 Xc_8_6.qb vss sky130_fd_pr__nfet_01v8 L=0.15 W=0.42 nf=1 m=1
XXc_8_7_XPU1 Xc_8_7.q Xc_8_7.qb vdd vdd sky130_fd_pr__pfet_01v8 L=0.15 W=0.42 nf=1 m=1
XXc_8_7_XPD1 Xc_8_7.q Xc_8_7.qb vss vss sky130_fd_pr__nfet_01v8 L=0.15 W=0.63 nf=1 m=1
XXc_8_7_XPU2 Xc_8_7.qb Xc_8_7.q vdd vdd sky130_fd_pr__pfet_01v8 L=0.15 W=0.42 nf=1 m=1
XXc_8_7_XPD2 Xc_8_7.qb Xc_8_7.q vss vss sky130_fd_pr__nfet_01v8 L=0.15 W=0.63 nf=1 m=1
XXc_8_7_XPG1 bl7 wl8 Xc_8_7.q vss sky130_fd_pr__nfet_01v8 L=0.15 W=0.42 nf=1 m=1
XXc_8_7_XPG2 blb7 wl8 Xc_8_7.qb vss sky130_fd_pr__nfet_01v8 L=0.15 W=0.42 nf=1 m=1
XXc_8_8_XPU1 Xc_8_8.q Xc_8_8.qb vdd vdd sky130_fd_pr__pfet_01v8 L=0.15 W=0.42 nf=1 m=1
XXc_8_8_XPD1 Xc_8_8.q Xc_8_8.qb vss vss sky130_fd_pr__nfet_01v8 L=0.15 W=0.63 nf=1 m=1
XXc_8_8_XPU2 Xc_8_8.qb Xc_8_8.q vdd vdd sky130_fd_pr__pfet_01v8 L=0.15 W=0.42 nf=1 m=1
XXc_8_8_XPD2 Xc_8_8.qb Xc_8_8.q vss vss sky130_fd_pr__nfet_01v8 L=0.15 W=0.63 nf=1 m=1
XXc_8_8_XPG1 bl8 wl8 Xc_8_8.q vss sky130_fd_pr__nfet_01v8 L=0.15 W=0.42 nf=1 m=1
XXc_8_8_XPG2 blb8 wl8 Xc_8_8.qb vss sky130_fd_pr__nfet_01v8 L=0.15 W=0.42 nf=1 m=1
XXc_8_9_XPU1 Xc_8_9.q Xc_8_9.qb vdd vdd sky130_fd_pr__pfet_01v8 L=0.15 W=0.42 nf=1 m=1
XXc_8_9_XPD1 Xc_8_9.q Xc_8_9.qb vss vss sky130_fd_pr__nfet_01v8 L=0.15 W=0.63 nf=1 m=1
XXc_8_9_XPU2 Xc_8_9.qb Xc_8_9.q vdd vdd sky130_fd_pr__pfet_01v8 L=0.15 W=0.42 nf=1 m=1
XXc_8_9_XPD2 Xc_8_9.qb Xc_8_9.q vss vss sky130_fd_pr__nfet_01v8 L=0.15 W=0.63 nf=1 m=1
XXc_8_9_XPG1 bl9 wl8 Xc_8_9.q vss sky130_fd_pr__nfet_01v8 L=0.15 W=0.42 nf=1 m=1
XXc_8_9_XPG2 blb9 wl8 Xc_8_9.qb vss sky130_fd_pr__nfet_01v8 L=0.15 W=0.42 nf=1 m=1
XXc_8_10_XPU1 Xc_8_10.q Xc_8_10.qb vdd vdd sky130_fd_pr__pfet_01v8 L=0.15 W=0.42 nf=1 m=1
XXc_8_10_XPD1 Xc_8_10.q Xc_8_10.qb vss vss sky130_fd_pr__nfet_01v8 L=0.15 W=0.63 nf=1 m=1
XXc_8_10_XPU2 Xc_8_10.qb Xc_8_10.q vdd vdd sky130_fd_pr__pfet_01v8 L=0.15 W=0.42 nf=1 m=1
XXc_8_10_XPD2 Xc_8_10.qb Xc_8_10.q vss vss sky130_fd_pr__nfet_01v8 L=0.15 W=0.63 nf=1 m=1
XXc_8_10_XPG1 bl10 wl8 Xc_8_10.q vss sky130_fd_pr__nfet_01v8 L=0.15 W=0.42 nf=1 m=1
XXc_8_10_XPG2 blb10 wl8 Xc_8_10.qb vss sky130_fd_pr__nfet_01v8 L=0.15 W=0.42 nf=1 m=1
XXc_8_11_XPU1 Xc_8_11.q Xc_8_11.qb vdd vdd sky130_fd_pr__pfet_01v8 L=0.15 W=0.42 nf=1 m=1
XXc_8_11_XPD1 Xc_8_11.q Xc_8_11.qb vss vss sky130_fd_pr__nfet_01v8 L=0.15 W=0.63 nf=1 m=1
XXc_8_11_XPU2 Xc_8_11.qb Xc_8_11.q vdd vdd sky130_fd_pr__pfet_01v8 L=0.15 W=0.42 nf=1 m=1
XXc_8_11_XPD2 Xc_8_11.qb Xc_8_11.q vss vss sky130_fd_pr__nfet_01v8 L=0.15 W=0.63 nf=1 m=1
XXc_8_11_XPG1 bl11 wl8 Xc_8_11.q vss sky130_fd_pr__nfet_01v8 L=0.15 W=0.42 nf=1 m=1
XXc_8_11_XPG2 blb11 wl8 Xc_8_11.qb vss sky130_fd_pr__nfet_01v8 L=0.15 W=0.42 nf=1 m=1
XXc_8_12_XPU1 Xc_8_12.q Xc_8_12.qb vdd vdd sky130_fd_pr__pfet_01v8 L=0.15 W=0.42 nf=1 m=1
XXc_8_12_XPD1 Xc_8_12.q Xc_8_12.qb vss vss sky130_fd_pr__nfet_01v8 L=0.15 W=0.63 nf=1 m=1
XXc_8_12_XPU2 Xc_8_12.qb Xc_8_12.q vdd vdd sky130_fd_pr__pfet_01v8 L=0.15 W=0.42 nf=1 m=1
XXc_8_12_XPD2 Xc_8_12.qb Xc_8_12.q vss vss sky130_fd_pr__nfet_01v8 L=0.15 W=0.63 nf=1 m=1
XXc_8_12_XPG1 bl12 wl8 Xc_8_12.q vss sky130_fd_pr__nfet_01v8 L=0.15 W=0.42 nf=1 m=1
XXc_8_12_XPG2 blb12 wl8 Xc_8_12.qb vss sky130_fd_pr__nfet_01v8 L=0.15 W=0.42 nf=1 m=1
XXc_8_13_XPU1 Xc_8_13.q Xc_8_13.qb vdd vdd sky130_fd_pr__pfet_01v8 L=0.15 W=0.42 nf=1 m=1
XXc_8_13_XPD1 Xc_8_13.q Xc_8_13.qb vss vss sky130_fd_pr__nfet_01v8 L=0.15 W=0.63 nf=1 m=1
XXc_8_13_XPU2 Xc_8_13.qb Xc_8_13.q vdd vdd sky130_fd_pr__pfet_01v8 L=0.15 W=0.42 nf=1 m=1
XXc_8_13_XPD2 Xc_8_13.qb Xc_8_13.q vss vss sky130_fd_pr__nfet_01v8 L=0.15 W=0.63 nf=1 m=1
XXc_8_13_XPG1 bl13 wl8 Xc_8_13.q vss sky130_fd_pr__nfet_01v8 L=0.15 W=0.42 nf=1 m=1
XXc_8_13_XPG2 blb13 wl8 Xc_8_13.qb vss sky130_fd_pr__nfet_01v8 L=0.15 W=0.42 nf=1 m=1
XXc_8_14_XPU1 Xc_8_14.q Xc_8_14.qb vdd vdd sky130_fd_pr__pfet_01v8 L=0.15 W=0.42 nf=1 m=1
XXc_8_14_XPD1 Xc_8_14.q Xc_8_14.qb vss vss sky130_fd_pr__nfet_01v8 L=0.15 W=0.63 nf=1 m=1
XXc_8_14_XPU2 Xc_8_14.qb Xc_8_14.q vdd vdd sky130_fd_pr__pfet_01v8 L=0.15 W=0.42 nf=1 m=1
XXc_8_14_XPD2 Xc_8_14.qb Xc_8_14.q vss vss sky130_fd_pr__nfet_01v8 L=0.15 W=0.63 nf=1 m=1
XXc_8_14_XPG1 bl14 wl8 Xc_8_14.q vss sky130_fd_pr__nfet_01v8 L=0.15 W=0.42 nf=1 m=1
XXc_8_14_XPG2 blb14 wl8 Xc_8_14.qb vss sky130_fd_pr__nfet_01v8 L=0.15 W=0.42 nf=1 m=1
XXc_8_15_XPU1 Xc_8_15.q Xc_8_15.qb vdd vdd sky130_fd_pr__pfet_01v8 L=0.15 W=0.42 nf=1 m=1
XXc_8_15_XPD1 Xc_8_15.q Xc_8_15.qb vss vss sky130_fd_pr__nfet_01v8 L=0.15 W=0.63 nf=1 m=1
XXc_8_15_XPU2 Xc_8_15.qb Xc_8_15.q vdd vdd sky130_fd_pr__pfet_01v8 L=0.15 W=0.42 nf=1 m=1
XXc_8_15_XPD2 Xc_8_15.qb Xc_8_15.q vss vss sky130_fd_pr__nfet_01v8 L=0.15 W=0.63 nf=1 m=1
XXc_8_15_XPG1 bl15 wl8 Xc_8_15.q vss sky130_fd_pr__nfet_01v8 L=0.15 W=0.42 nf=1 m=1
XXc_8_15_XPG2 blb15 wl8 Xc_8_15.qb vss sky130_fd_pr__nfet_01v8 L=0.15 W=0.42 nf=1 m=1
XXc_9_0_XPU1 Xc_9_0.q Xc_9_0.qb vdd vdd sky130_fd_pr__pfet_01v8 L=0.15 W=0.42 nf=1 m=1
XXc_9_0_XPD1 Xc_9_0.q Xc_9_0.qb vss vss sky130_fd_pr__nfet_01v8 L=0.15 W=0.63 nf=1 m=1
XXc_9_0_XPU2 Xc_9_0.qb Xc_9_0.q vdd vdd sky130_fd_pr__pfet_01v8 L=0.15 W=0.42 nf=1 m=1
XXc_9_0_XPD2 Xc_9_0.qb Xc_9_0.q vss vss sky130_fd_pr__nfet_01v8 L=0.15 W=0.63 nf=1 m=1
XXc_9_0_XPG1 bl0 wl9 Xc_9_0.q vss sky130_fd_pr__nfet_01v8 L=0.15 W=0.42 nf=1 m=1
XXc_9_0_XPG2 blb0 wl9 Xc_9_0.qb vss sky130_fd_pr__nfet_01v8 L=0.15 W=0.42 nf=1 m=1
XXc_9_1_XPU1 Xc_9_1.q Xc_9_1.qb vdd vdd sky130_fd_pr__pfet_01v8 L=0.15 W=0.42 nf=1 m=1
XXc_9_1_XPD1 Xc_9_1.q Xc_9_1.qb vss vss sky130_fd_pr__nfet_01v8 L=0.15 W=0.63 nf=1 m=1
XXc_9_1_XPU2 Xc_9_1.qb Xc_9_1.q vdd vdd sky130_fd_pr__pfet_01v8 L=0.15 W=0.42 nf=1 m=1
XXc_9_1_XPD2 Xc_9_1.qb Xc_9_1.q vss vss sky130_fd_pr__nfet_01v8 L=0.15 W=0.63 nf=1 m=1
XXc_9_1_XPG1 bl1 wl9 Xc_9_1.q vss sky130_fd_pr__nfet_01v8 L=0.15 W=0.42 nf=1 m=1
XXc_9_1_XPG2 blb1 wl9 Xc_9_1.qb vss sky130_fd_pr__nfet_01v8 L=0.15 W=0.42 nf=1 m=1
XXc_9_2_XPU1 Xc_9_2.q Xc_9_2.qb vdd vdd sky130_fd_pr__pfet_01v8 L=0.15 W=0.42 nf=1 m=1
XXc_9_2_XPD1 Xc_9_2.q Xc_9_2.qb vss vss sky130_fd_pr__nfet_01v8 L=0.15 W=0.63 nf=1 m=1
XXc_9_2_XPU2 Xc_9_2.qb Xc_9_2.q vdd vdd sky130_fd_pr__pfet_01v8 L=0.15 W=0.42 nf=1 m=1
XXc_9_2_XPD2 Xc_9_2.qb Xc_9_2.q vss vss sky130_fd_pr__nfet_01v8 L=0.15 W=0.63 nf=1 m=1
XXc_9_2_XPG1 bl2 wl9 Xc_9_2.q vss sky130_fd_pr__nfet_01v8 L=0.15 W=0.42 nf=1 m=1
XXc_9_2_XPG2 blb2 wl9 Xc_9_2.qb vss sky130_fd_pr__nfet_01v8 L=0.15 W=0.42 nf=1 m=1
XXc_9_3_XPU1 Xc_9_3.q Xc_9_3.qb vdd vdd sky130_fd_pr__pfet_01v8 L=0.15 W=0.42 nf=1 m=1
XXc_9_3_XPD1 Xc_9_3.q Xc_9_3.qb vss vss sky130_fd_pr__nfet_01v8 L=0.15 W=0.63 nf=1 m=1
XXc_9_3_XPU2 Xc_9_3.qb Xc_9_3.q vdd vdd sky130_fd_pr__pfet_01v8 L=0.15 W=0.42 nf=1 m=1
XXc_9_3_XPD2 Xc_9_3.qb Xc_9_3.q vss vss sky130_fd_pr__nfet_01v8 L=0.15 W=0.63 nf=1 m=1
XXc_9_3_XPG1 bl3 wl9 Xc_9_3.q vss sky130_fd_pr__nfet_01v8 L=0.15 W=0.42 nf=1 m=1
XXc_9_3_XPG2 blb3 wl9 Xc_9_3.qb vss sky130_fd_pr__nfet_01v8 L=0.15 W=0.42 nf=1 m=1
XXc_9_4_XPU1 Xc_9_4.q Xc_9_4.qb vdd vdd sky130_fd_pr__pfet_01v8 L=0.15 W=0.42 nf=1 m=1
XXc_9_4_XPD1 Xc_9_4.q Xc_9_4.qb vss vss sky130_fd_pr__nfet_01v8 L=0.15 W=0.63 nf=1 m=1
XXc_9_4_XPU2 Xc_9_4.qb Xc_9_4.q vdd vdd sky130_fd_pr__pfet_01v8 L=0.15 W=0.42 nf=1 m=1
XXc_9_4_XPD2 Xc_9_4.qb Xc_9_4.q vss vss sky130_fd_pr__nfet_01v8 L=0.15 W=0.63 nf=1 m=1
XXc_9_4_XPG1 bl4 wl9 Xc_9_4.q vss sky130_fd_pr__nfet_01v8 L=0.15 W=0.42 nf=1 m=1
XXc_9_4_XPG2 blb4 wl9 Xc_9_4.qb vss sky130_fd_pr__nfet_01v8 L=0.15 W=0.42 nf=1 m=1
XXc_9_5_XPU1 Xc_9_5.q Xc_9_5.qb vdd vdd sky130_fd_pr__pfet_01v8 L=0.15 W=0.42 nf=1 m=1
XXc_9_5_XPD1 Xc_9_5.q Xc_9_5.qb vss vss sky130_fd_pr__nfet_01v8 L=0.15 W=0.63 nf=1 m=1
XXc_9_5_XPU2 Xc_9_5.qb Xc_9_5.q vdd vdd sky130_fd_pr__pfet_01v8 L=0.15 W=0.42 nf=1 m=1
XXc_9_5_XPD2 Xc_9_5.qb Xc_9_5.q vss vss sky130_fd_pr__nfet_01v8 L=0.15 W=0.63 nf=1 m=1
XXc_9_5_XPG1 bl5 wl9 Xc_9_5.q vss sky130_fd_pr__nfet_01v8 L=0.15 W=0.42 nf=1 m=1
XXc_9_5_XPG2 blb5 wl9 Xc_9_5.qb vss sky130_fd_pr__nfet_01v8 L=0.15 W=0.42 nf=1 m=1
XXc_9_6_XPU1 Xc_9_6.q Xc_9_6.qb vdd vdd sky130_fd_pr__pfet_01v8 L=0.15 W=0.42 nf=1 m=1
XXc_9_6_XPD1 Xc_9_6.q Xc_9_6.qb vss vss sky130_fd_pr__nfet_01v8 L=0.15 W=0.63 nf=1 m=1
XXc_9_6_XPU2 Xc_9_6.qb Xc_9_6.q vdd vdd sky130_fd_pr__pfet_01v8 L=0.15 W=0.42 nf=1 m=1
XXc_9_6_XPD2 Xc_9_6.qb Xc_9_6.q vss vss sky130_fd_pr__nfet_01v8 L=0.15 W=0.63 nf=1 m=1
XXc_9_6_XPG1 bl6 wl9 Xc_9_6.q vss sky130_fd_pr__nfet_01v8 L=0.15 W=0.42 nf=1 m=1
XXc_9_6_XPG2 blb6 wl9 Xc_9_6.qb vss sky130_fd_pr__nfet_01v8 L=0.15 W=0.42 nf=1 m=1
XXc_9_7_XPU1 Xc_9_7.q Xc_9_7.qb vdd vdd sky130_fd_pr__pfet_01v8 L=0.15 W=0.42 nf=1 m=1
XXc_9_7_XPD1 Xc_9_7.q Xc_9_7.qb vss vss sky130_fd_pr__nfet_01v8 L=0.15 W=0.63 nf=1 m=1
XXc_9_7_XPU2 Xc_9_7.qb Xc_9_7.q vdd vdd sky130_fd_pr__pfet_01v8 L=0.15 W=0.42 nf=1 m=1
XXc_9_7_XPD2 Xc_9_7.qb Xc_9_7.q vss vss sky130_fd_pr__nfet_01v8 L=0.15 W=0.63 nf=1 m=1
XXc_9_7_XPG1 bl7 wl9 Xc_9_7.q vss sky130_fd_pr__nfet_01v8 L=0.15 W=0.42 nf=1 m=1
XXc_9_7_XPG2 blb7 wl9 Xc_9_7.qb vss sky130_fd_pr__nfet_01v8 L=0.15 W=0.42 nf=1 m=1
XXc_9_8_XPU1 Xc_9_8.q Xc_9_8.qb vdd vdd sky130_fd_pr__pfet_01v8 L=0.15 W=0.42 nf=1 m=1
XXc_9_8_XPD1 Xc_9_8.q Xc_9_8.qb vss vss sky130_fd_pr__nfet_01v8 L=0.15 W=0.63 nf=1 m=1
XXc_9_8_XPU2 Xc_9_8.qb Xc_9_8.q vdd vdd sky130_fd_pr__pfet_01v8 L=0.15 W=0.42 nf=1 m=1
XXc_9_8_XPD2 Xc_9_8.qb Xc_9_8.q vss vss sky130_fd_pr__nfet_01v8 L=0.15 W=0.63 nf=1 m=1
XXc_9_8_XPG1 bl8 wl9 Xc_9_8.q vss sky130_fd_pr__nfet_01v8 L=0.15 W=0.42 nf=1 m=1
XXc_9_8_XPG2 blb8 wl9 Xc_9_8.qb vss sky130_fd_pr__nfet_01v8 L=0.15 W=0.42 nf=1 m=1
XXc_9_9_XPU1 Xc_9_9.q Xc_9_9.qb vdd vdd sky130_fd_pr__pfet_01v8 L=0.15 W=0.42 nf=1 m=1
XXc_9_9_XPD1 Xc_9_9.q Xc_9_9.qb vss vss sky130_fd_pr__nfet_01v8 L=0.15 W=0.63 nf=1 m=1
XXc_9_9_XPU2 Xc_9_9.qb Xc_9_9.q vdd vdd sky130_fd_pr__pfet_01v8 L=0.15 W=0.42 nf=1 m=1
XXc_9_9_XPD2 Xc_9_9.qb Xc_9_9.q vss vss sky130_fd_pr__nfet_01v8 L=0.15 W=0.63 nf=1 m=1
XXc_9_9_XPG1 bl9 wl9 Xc_9_9.q vss sky130_fd_pr__nfet_01v8 L=0.15 W=0.42 nf=1 m=1
XXc_9_9_XPG2 blb9 wl9 Xc_9_9.qb vss sky130_fd_pr__nfet_01v8 L=0.15 W=0.42 nf=1 m=1
XXc_9_10_XPU1 Xc_9_10.q Xc_9_10.qb vdd vdd sky130_fd_pr__pfet_01v8 L=0.15 W=0.42 nf=1 m=1
XXc_9_10_XPD1 Xc_9_10.q Xc_9_10.qb vss vss sky130_fd_pr__nfet_01v8 L=0.15 W=0.63 nf=1 m=1
XXc_9_10_XPU2 Xc_9_10.qb Xc_9_10.q vdd vdd sky130_fd_pr__pfet_01v8 L=0.15 W=0.42 nf=1 m=1
XXc_9_10_XPD2 Xc_9_10.qb Xc_9_10.q vss vss sky130_fd_pr__nfet_01v8 L=0.15 W=0.63 nf=1 m=1
XXc_9_10_XPG1 bl10 wl9 Xc_9_10.q vss sky130_fd_pr__nfet_01v8 L=0.15 W=0.42 nf=1 m=1
XXc_9_10_XPG2 blb10 wl9 Xc_9_10.qb vss sky130_fd_pr__nfet_01v8 L=0.15 W=0.42 nf=1 m=1
XXc_9_11_XPU1 Xc_9_11.q Xc_9_11.qb vdd vdd sky130_fd_pr__pfet_01v8 L=0.15 W=0.42 nf=1 m=1
XXc_9_11_XPD1 Xc_9_11.q Xc_9_11.qb vss vss sky130_fd_pr__nfet_01v8 L=0.15 W=0.63 nf=1 m=1
XXc_9_11_XPU2 Xc_9_11.qb Xc_9_11.q vdd vdd sky130_fd_pr__pfet_01v8 L=0.15 W=0.42 nf=1 m=1
XXc_9_11_XPD2 Xc_9_11.qb Xc_9_11.q vss vss sky130_fd_pr__nfet_01v8 L=0.15 W=0.63 nf=1 m=1
XXc_9_11_XPG1 bl11 wl9 Xc_9_11.q vss sky130_fd_pr__nfet_01v8 L=0.15 W=0.42 nf=1 m=1
XXc_9_11_XPG2 blb11 wl9 Xc_9_11.qb vss sky130_fd_pr__nfet_01v8 L=0.15 W=0.42 nf=1 m=1
XXc_9_12_XPU1 Xc_9_12.q Xc_9_12.qb vdd vdd sky130_fd_pr__pfet_01v8 L=0.15 W=0.42 nf=1 m=1
XXc_9_12_XPD1 Xc_9_12.q Xc_9_12.qb vss vss sky130_fd_pr__nfet_01v8 L=0.15 W=0.63 nf=1 m=1
XXc_9_12_XPU2 Xc_9_12.qb Xc_9_12.q vdd vdd sky130_fd_pr__pfet_01v8 L=0.15 W=0.42 nf=1 m=1
XXc_9_12_XPD2 Xc_9_12.qb Xc_9_12.q vss vss sky130_fd_pr__nfet_01v8 L=0.15 W=0.63 nf=1 m=1
XXc_9_12_XPG1 bl12 wl9 Xc_9_12.q vss sky130_fd_pr__nfet_01v8 L=0.15 W=0.42 nf=1 m=1
XXc_9_12_XPG2 blb12 wl9 Xc_9_12.qb vss sky130_fd_pr__nfet_01v8 L=0.15 W=0.42 nf=1 m=1
XXc_9_13_XPU1 Xc_9_13.q Xc_9_13.qb vdd vdd sky130_fd_pr__pfet_01v8 L=0.15 W=0.42 nf=1 m=1
XXc_9_13_XPD1 Xc_9_13.q Xc_9_13.qb vss vss sky130_fd_pr__nfet_01v8 L=0.15 W=0.63 nf=1 m=1
XXc_9_13_XPU2 Xc_9_13.qb Xc_9_13.q vdd vdd sky130_fd_pr__pfet_01v8 L=0.15 W=0.42 nf=1 m=1
XXc_9_13_XPD2 Xc_9_13.qb Xc_9_13.q vss vss sky130_fd_pr__nfet_01v8 L=0.15 W=0.63 nf=1 m=1
XXc_9_13_XPG1 bl13 wl9 Xc_9_13.q vss sky130_fd_pr__nfet_01v8 L=0.15 W=0.42 nf=1 m=1
XXc_9_13_XPG2 blb13 wl9 Xc_9_13.qb vss sky130_fd_pr__nfet_01v8 L=0.15 W=0.42 nf=1 m=1
XXc_9_14_XPU1 Xc_9_14.q Xc_9_14.qb vdd vdd sky130_fd_pr__pfet_01v8 L=0.15 W=0.42 nf=1 m=1
XXc_9_14_XPD1 Xc_9_14.q Xc_9_14.qb vss vss sky130_fd_pr__nfet_01v8 L=0.15 W=0.63 nf=1 m=1
XXc_9_14_XPU2 Xc_9_14.qb Xc_9_14.q vdd vdd sky130_fd_pr__pfet_01v8 L=0.15 W=0.42 nf=1 m=1
XXc_9_14_XPD2 Xc_9_14.qb Xc_9_14.q vss vss sky130_fd_pr__nfet_01v8 L=0.15 W=0.63 nf=1 m=1
XXc_9_14_XPG1 bl14 wl9 Xc_9_14.q vss sky130_fd_pr__nfet_01v8 L=0.15 W=0.42 nf=1 m=1
XXc_9_14_XPG2 blb14 wl9 Xc_9_14.qb vss sky130_fd_pr__nfet_01v8 L=0.15 W=0.42 nf=1 m=1
XXc_9_15_XPU1 Xc_9_15.q Xc_9_15.qb vdd vdd sky130_fd_pr__pfet_01v8 L=0.15 W=0.42 nf=1 m=1
XXc_9_15_XPD1 Xc_9_15.q Xc_9_15.qb vss vss sky130_fd_pr__nfet_01v8 L=0.15 W=0.63 nf=1 m=1
XXc_9_15_XPU2 Xc_9_15.qb Xc_9_15.q vdd vdd sky130_fd_pr__pfet_01v8 L=0.15 W=0.42 nf=1 m=1
XXc_9_15_XPD2 Xc_9_15.qb Xc_9_15.q vss vss sky130_fd_pr__nfet_01v8 L=0.15 W=0.63 nf=1 m=1
XXc_9_15_XPG1 bl15 wl9 Xc_9_15.q vss sky130_fd_pr__nfet_01v8 L=0.15 W=0.42 nf=1 m=1
XXc_9_15_XPG2 blb15 wl9 Xc_9_15.qb vss sky130_fd_pr__nfet_01v8 L=0.15 W=0.42 nf=1 m=1
XXc_10_0_XPU1 Xc_10_0.q Xc_10_0.qb vdd vdd sky130_fd_pr__pfet_01v8 L=0.15 W=0.42 nf=1 m=1
XXc_10_0_XPD1 Xc_10_0.q Xc_10_0.qb vss vss sky130_fd_pr__nfet_01v8 L=0.15 W=0.63 nf=1 m=1
XXc_10_0_XPU2 Xc_10_0.qb Xc_10_0.q vdd vdd sky130_fd_pr__pfet_01v8 L=0.15 W=0.42 nf=1 m=1
XXc_10_0_XPD2 Xc_10_0.qb Xc_10_0.q vss vss sky130_fd_pr__nfet_01v8 L=0.15 W=0.63 nf=1 m=1
XXc_10_0_XPG1 bl0 wl10 Xc_10_0.q vss sky130_fd_pr__nfet_01v8 L=0.15 W=0.42 nf=1 m=1
XXc_10_0_XPG2 blb0 wl10 Xc_10_0.qb vss sky130_fd_pr__nfet_01v8 L=0.15 W=0.42 nf=1 m=1
XXc_10_1_XPU1 Xc_10_1.q Xc_10_1.qb vdd vdd sky130_fd_pr__pfet_01v8 L=0.15 W=0.42 nf=1 m=1
XXc_10_1_XPD1 Xc_10_1.q Xc_10_1.qb vss vss sky130_fd_pr__nfet_01v8 L=0.15 W=0.63 nf=1 m=1
XXc_10_1_XPU2 Xc_10_1.qb Xc_10_1.q vdd vdd sky130_fd_pr__pfet_01v8 L=0.15 W=0.42 nf=1 m=1
XXc_10_1_XPD2 Xc_10_1.qb Xc_10_1.q vss vss sky130_fd_pr__nfet_01v8 L=0.15 W=0.63 nf=1 m=1
XXc_10_1_XPG1 bl1 wl10 Xc_10_1.q vss sky130_fd_pr__nfet_01v8 L=0.15 W=0.42 nf=1 m=1
XXc_10_1_XPG2 blb1 wl10 Xc_10_1.qb vss sky130_fd_pr__nfet_01v8 L=0.15 W=0.42 nf=1 m=1
XXc_10_2_XPU1 Xc_10_2.q Xc_10_2.qb vdd vdd sky130_fd_pr__pfet_01v8 L=0.15 W=0.42 nf=1 m=1
XXc_10_2_XPD1 Xc_10_2.q Xc_10_2.qb vss vss sky130_fd_pr__nfet_01v8 L=0.15 W=0.63 nf=1 m=1
XXc_10_2_XPU2 Xc_10_2.qb Xc_10_2.q vdd vdd sky130_fd_pr__pfet_01v8 L=0.15 W=0.42 nf=1 m=1
XXc_10_2_XPD2 Xc_10_2.qb Xc_10_2.q vss vss sky130_fd_pr__nfet_01v8 L=0.15 W=0.63 nf=1 m=1
XXc_10_2_XPG1 bl2 wl10 Xc_10_2.q vss sky130_fd_pr__nfet_01v8 L=0.15 W=0.42 nf=1 m=1
XXc_10_2_XPG2 blb2 wl10 Xc_10_2.qb vss sky130_fd_pr__nfet_01v8 L=0.15 W=0.42 nf=1 m=1
XXc_10_3_XPU1 Xc_10_3.q Xc_10_3.qb vdd vdd sky130_fd_pr__pfet_01v8 L=0.15 W=0.42 nf=1 m=1
XXc_10_3_XPD1 Xc_10_3.q Xc_10_3.qb vss vss sky130_fd_pr__nfet_01v8 L=0.15 W=0.63 nf=1 m=1
XXc_10_3_XPU2 Xc_10_3.qb Xc_10_3.q vdd vdd sky130_fd_pr__pfet_01v8 L=0.15 W=0.42 nf=1 m=1
XXc_10_3_XPD2 Xc_10_3.qb Xc_10_3.q vss vss sky130_fd_pr__nfet_01v8 L=0.15 W=0.63 nf=1 m=1
XXc_10_3_XPG1 bl3 wl10 Xc_10_3.q vss sky130_fd_pr__nfet_01v8 L=0.15 W=0.42 nf=1 m=1
XXc_10_3_XPG2 blb3 wl10 Xc_10_3.qb vss sky130_fd_pr__nfet_01v8 L=0.15 W=0.42 nf=1 m=1
XXc_10_4_XPU1 Xc_10_4.q Xc_10_4.qb vdd vdd sky130_fd_pr__pfet_01v8 L=0.15 W=0.42 nf=1 m=1
XXc_10_4_XPD1 Xc_10_4.q Xc_10_4.qb vss vss sky130_fd_pr__nfet_01v8 L=0.15 W=0.63 nf=1 m=1
XXc_10_4_XPU2 Xc_10_4.qb Xc_10_4.q vdd vdd sky130_fd_pr__pfet_01v8 L=0.15 W=0.42 nf=1 m=1
XXc_10_4_XPD2 Xc_10_4.qb Xc_10_4.q vss vss sky130_fd_pr__nfet_01v8 L=0.15 W=0.63 nf=1 m=1
XXc_10_4_XPG1 bl4 wl10 Xc_10_4.q vss sky130_fd_pr__nfet_01v8 L=0.15 W=0.42 nf=1 m=1
XXc_10_4_XPG2 blb4 wl10 Xc_10_4.qb vss sky130_fd_pr__nfet_01v8 L=0.15 W=0.42 nf=1 m=1
XXc_10_5_XPU1 Xc_10_5.q Xc_10_5.qb vdd vdd sky130_fd_pr__pfet_01v8 L=0.15 W=0.42 nf=1 m=1
XXc_10_5_XPD1 Xc_10_5.q Xc_10_5.qb vss vss sky130_fd_pr__nfet_01v8 L=0.15 W=0.63 nf=1 m=1
XXc_10_5_XPU2 Xc_10_5.qb Xc_10_5.q vdd vdd sky130_fd_pr__pfet_01v8 L=0.15 W=0.42 nf=1 m=1
XXc_10_5_XPD2 Xc_10_5.qb Xc_10_5.q vss vss sky130_fd_pr__nfet_01v8 L=0.15 W=0.63 nf=1 m=1
XXc_10_5_XPG1 bl5 wl10 Xc_10_5.q vss sky130_fd_pr__nfet_01v8 L=0.15 W=0.42 nf=1 m=1
XXc_10_5_XPG2 blb5 wl10 Xc_10_5.qb vss sky130_fd_pr__nfet_01v8 L=0.15 W=0.42 nf=1 m=1
XXc_10_6_XPU1 Xc_10_6.q Xc_10_6.qb vdd vdd sky130_fd_pr__pfet_01v8 L=0.15 W=0.42 nf=1 m=1
XXc_10_6_XPD1 Xc_10_6.q Xc_10_6.qb vss vss sky130_fd_pr__nfet_01v8 L=0.15 W=0.63 nf=1 m=1
XXc_10_6_XPU2 Xc_10_6.qb Xc_10_6.q vdd vdd sky130_fd_pr__pfet_01v8 L=0.15 W=0.42 nf=1 m=1
XXc_10_6_XPD2 Xc_10_6.qb Xc_10_6.q vss vss sky130_fd_pr__nfet_01v8 L=0.15 W=0.63 nf=1 m=1
XXc_10_6_XPG1 bl6 wl10 Xc_10_6.q vss sky130_fd_pr__nfet_01v8 L=0.15 W=0.42 nf=1 m=1
XXc_10_6_XPG2 blb6 wl10 Xc_10_6.qb vss sky130_fd_pr__nfet_01v8 L=0.15 W=0.42 nf=1 m=1
XXc_10_7_XPU1 Xc_10_7.q Xc_10_7.qb vdd vdd sky130_fd_pr__pfet_01v8 L=0.15 W=0.42 nf=1 m=1
XXc_10_7_XPD1 Xc_10_7.q Xc_10_7.qb vss vss sky130_fd_pr__nfet_01v8 L=0.15 W=0.63 nf=1 m=1
XXc_10_7_XPU2 Xc_10_7.qb Xc_10_7.q vdd vdd sky130_fd_pr__pfet_01v8 L=0.15 W=0.42 nf=1 m=1
XXc_10_7_XPD2 Xc_10_7.qb Xc_10_7.q vss vss sky130_fd_pr__nfet_01v8 L=0.15 W=0.63 nf=1 m=1
XXc_10_7_XPG1 bl7 wl10 Xc_10_7.q vss sky130_fd_pr__nfet_01v8 L=0.15 W=0.42 nf=1 m=1
XXc_10_7_XPG2 blb7 wl10 Xc_10_7.qb vss sky130_fd_pr__nfet_01v8 L=0.15 W=0.42 nf=1 m=1
XXc_10_8_XPU1 Xc_10_8.q Xc_10_8.qb vdd vdd sky130_fd_pr__pfet_01v8 L=0.15 W=0.42 nf=1 m=1
XXc_10_8_XPD1 Xc_10_8.q Xc_10_8.qb vss vss sky130_fd_pr__nfet_01v8 L=0.15 W=0.63 nf=1 m=1
XXc_10_8_XPU2 Xc_10_8.qb Xc_10_8.q vdd vdd sky130_fd_pr__pfet_01v8 L=0.15 W=0.42 nf=1 m=1
XXc_10_8_XPD2 Xc_10_8.qb Xc_10_8.q vss vss sky130_fd_pr__nfet_01v8 L=0.15 W=0.63 nf=1 m=1
XXc_10_8_XPG1 bl8 wl10 Xc_10_8.q vss sky130_fd_pr__nfet_01v8 L=0.15 W=0.42 nf=1 m=1
XXc_10_8_XPG2 blb8 wl10 Xc_10_8.qb vss sky130_fd_pr__nfet_01v8 L=0.15 W=0.42 nf=1 m=1
XXc_10_9_XPU1 Xc_10_9.q Xc_10_9.qb vdd vdd sky130_fd_pr__pfet_01v8 L=0.15 W=0.42 nf=1 m=1
XXc_10_9_XPD1 Xc_10_9.q Xc_10_9.qb vss vss sky130_fd_pr__nfet_01v8 L=0.15 W=0.63 nf=1 m=1
XXc_10_9_XPU2 Xc_10_9.qb Xc_10_9.q vdd vdd sky130_fd_pr__pfet_01v8 L=0.15 W=0.42 nf=1 m=1
XXc_10_9_XPD2 Xc_10_9.qb Xc_10_9.q vss vss sky130_fd_pr__nfet_01v8 L=0.15 W=0.63 nf=1 m=1
XXc_10_9_XPG1 bl9 wl10 Xc_10_9.q vss sky130_fd_pr__nfet_01v8 L=0.15 W=0.42 nf=1 m=1
XXc_10_9_XPG2 blb9 wl10 Xc_10_9.qb vss sky130_fd_pr__nfet_01v8 L=0.15 W=0.42 nf=1 m=1
XXc_10_10_XPU1 Xc_10_10.q Xc_10_10.qb vdd vdd sky130_fd_pr__pfet_01v8 L=0.15 W=0.42 nf=1 m=1
XXc_10_10_XPD1 Xc_10_10.q Xc_10_10.qb vss vss sky130_fd_pr__nfet_01v8 L=0.15 W=0.63 nf=1 m=1
XXc_10_10_XPU2 Xc_10_10.qb Xc_10_10.q vdd vdd sky130_fd_pr__pfet_01v8 L=0.15 W=0.42 nf=1 m=1
XXc_10_10_XPD2 Xc_10_10.qb Xc_10_10.q vss vss sky130_fd_pr__nfet_01v8 L=0.15 W=0.63 nf=1 m=1
XXc_10_10_XPG1 bl10 wl10 Xc_10_10.q vss sky130_fd_pr__nfet_01v8 L=0.15 W=0.42 nf=1 m=1
XXc_10_10_XPG2 blb10 wl10 Xc_10_10.qb vss sky130_fd_pr__nfet_01v8 L=0.15 W=0.42 nf=1 m=1
XXc_10_11_XPU1 Xc_10_11.q Xc_10_11.qb vdd vdd sky130_fd_pr__pfet_01v8 L=0.15 W=0.42 nf=1 m=1
XXc_10_11_XPD1 Xc_10_11.q Xc_10_11.qb vss vss sky130_fd_pr__nfet_01v8 L=0.15 W=0.63 nf=1 m=1
XXc_10_11_XPU2 Xc_10_11.qb Xc_10_11.q vdd vdd sky130_fd_pr__pfet_01v8 L=0.15 W=0.42 nf=1 m=1
XXc_10_11_XPD2 Xc_10_11.qb Xc_10_11.q vss vss sky130_fd_pr__nfet_01v8 L=0.15 W=0.63 nf=1 m=1
XXc_10_11_XPG1 bl11 wl10 Xc_10_11.q vss sky130_fd_pr__nfet_01v8 L=0.15 W=0.42 nf=1 m=1
XXc_10_11_XPG2 blb11 wl10 Xc_10_11.qb vss sky130_fd_pr__nfet_01v8 L=0.15 W=0.42 nf=1 m=1
XXc_10_12_XPU1 Xc_10_12.q Xc_10_12.qb vdd vdd sky130_fd_pr__pfet_01v8 L=0.15 W=0.42 nf=1 m=1
XXc_10_12_XPD1 Xc_10_12.q Xc_10_12.qb vss vss sky130_fd_pr__nfet_01v8 L=0.15 W=0.63 nf=1 m=1
XXc_10_12_XPU2 Xc_10_12.qb Xc_10_12.q vdd vdd sky130_fd_pr__pfet_01v8 L=0.15 W=0.42 nf=1 m=1
XXc_10_12_XPD2 Xc_10_12.qb Xc_10_12.q vss vss sky130_fd_pr__nfet_01v8 L=0.15 W=0.63 nf=1 m=1
XXc_10_12_XPG1 bl12 wl10 Xc_10_12.q vss sky130_fd_pr__nfet_01v8 L=0.15 W=0.42 nf=1 m=1
XXc_10_12_XPG2 blb12 wl10 Xc_10_12.qb vss sky130_fd_pr__nfet_01v8 L=0.15 W=0.42 nf=1 m=1
XXc_10_13_XPU1 Xc_10_13.q Xc_10_13.qb vdd vdd sky130_fd_pr__pfet_01v8 L=0.15 W=0.42 nf=1 m=1
XXc_10_13_XPD1 Xc_10_13.q Xc_10_13.qb vss vss sky130_fd_pr__nfet_01v8 L=0.15 W=0.63 nf=1 m=1
XXc_10_13_XPU2 Xc_10_13.qb Xc_10_13.q vdd vdd sky130_fd_pr__pfet_01v8 L=0.15 W=0.42 nf=1 m=1
XXc_10_13_XPD2 Xc_10_13.qb Xc_10_13.q vss vss sky130_fd_pr__nfet_01v8 L=0.15 W=0.63 nf=1 m=1
XXc_10_13_XPG1 bl13 wl10 Xc_10_13.q vss sky130_fd_pr__nfet_01v8 L=0.15 W=0.42 nf=1 m=1
XXc_10_13_XPG2 blb13 wl10 Xc_10_13.qb vss sky130_fd_pr__nfet_01v8 L=0.15 W=0.42 nf=1 m=1
XXc_10_14_XPU1 Xc_10_14.q Xc_10_14.qb vdd vdd sky130_fd_pr__pfet_01v8 L=0.15 W=0.42 nf=1 m=1
XXc_10_14_XPD1 Xc_10_14.q Xc_10_14.qb vss vss sky130_fd_pr__nfet_01v8 L=0.15 W=0.63 nf=1 m=1
XXc_10_14_XPU2 Xc_10_14.qb Xc_10_14.q vdd vdd sky130_fd_pr__pfet_01v8 L=0.15 W=0.42 nf=1 m=1
XXc_10_14_XPD2 Xc_10_14.qb Xc_10_14.q vss vss sky130_fd_pr__nfet_01v8 L=0.15 W=0.63 nf=1 m=1
XXc_10_14_XPG1 bl14 wl10 Xc_10_14.q vss sky130_fd_pr__nfet_01v8 L=0.15 W=0.42 nf=1 m=1
XXc_10_14_XPG2 blb14 wl10 Xc_10_14.qb vss sky130_fd_pr__nfet_01v8 L=0.15 W=0.42 nf=1 m=1
XXc_10_15_XPU1 Xc_10_15.q Xc_10_15.qb vdd vdd sky130_fd_pr__pfet_01v8 L=0.15 W=0.42 nf=1 m=1
XXc_10_15_XPD1 Xc_10_15.q Xc_10_15.qb vss vss sky130_fd_pr__nfet_01v8 L=0.15 W=0.63 nf=1 m=1
XXc_10_15_XPU2 Xc_10_15.qb Xc_10_15.q vdd vdd sky130_fd_pr__pfet_01v8 L=0.15 W=0.42 nf=1 m=1
XXc_10_15_XPD2 Xc_10_15.qb Xc_10_15.q vss vss sky130_fd_pr__nfet_01v8 L=0.15 W=0.63 nf=1 m=1
XXc_10_15_XPG1 bl15 wl10 Xc_10_15.q vss sky130_fd_pr__nfet_01v8 L=0.15 W=0.42 nf=1 m=1
XXc_10_15_XPG2 blb15 wl10 Xc_10_15.qb vss sky130_fd_pr__nfet_01v8 L=0.15 W=0.42 nf=1 m=1
XXc_11_0_XPU1 Xc_11_0.q Xc_11_0.qb vdd vdd sky130_fd_pr__pfet_01v8 L=0.15 W=0.42 nf=1 m=1
XXc_11_0_XPD1 Xc_11_0.q Xc_11_0.qb vss vss sky130_fd_pr__nfet_01v8 L=0.15 W=0.63 nf=1 m=1
XXc_11_0_XPU2 Xc_11_0.qb Xc_11_0.q vdd vdd sky130_fd_pr__pfet_01v8 L=0.15 W=0.42 nf=1 m=1
XXc_11_0_XPD2 Xc_11_0.qb Xc_11_0.q vss vss sky130_fd_pr__nfet_01v8 L=0.15 W=0.63 nf=1 m=1
XXc_11_0_XPG1 bl0 wl11 Xc_11_0.q vss sky130_fd_pr__nfet_01v8 L=0.15 W=0.42 nf=1 m=1
XXc_11_0_XPG2 blb0 wl11 Xc_11_0.qb vss sky130_fd_pr__nfet_01v8 L=0.15 W=0.42 nf=1 m=1
XXc_11_1_XPU1 Xc_11_1.q Xc_11_1.qb vdd vdd sky130_fd_pr__pfet_01v8 L=0.15 W=0.42 nf=1 m=1
XXc_11_1_XPD1 Xc_11_1.q Xc_11_1.qb vss vss sky130_fd_pr__nfet_01v8 L=0.15 W=0.63 nf=1 m=1
XXc_11_1_XPU2 Xc_11_1.qb Xc_11_1.q vdd vdd sky130_fd_pr__pfet_01v8 L=0.15 W=0.42 nf=1 m=1
XXc_11_1_XPD2 Xc_11_1.qb Xc_11_1.q vss vss sky130_fd_pr__nfet_01v8 L=0.15 W=0.63 nf=1 m=1
XXc_11_1_XPG1 bl1 wl11 Xc_11_1.q vss sky130_fd_pr__nfet_01v8 L=0.15 W=0.42 nf=1 m=1
XXc_11_1_XPG2 blb1 wl11 Xc_11_1.qb vss sky130_fd_pr__nfet_01v8 L=0.15 W=0.42 nf=1 m=1
XXc_11_2_XPU1 Xc_11_2.q Xc_11_2.qb vdd vdd sky130_fd_pr__pfet_01v8 L=0.15 W=0.42 nf=1 m=1
XXc_11_2_XPD1 Xc_11_2.q Xc_11_2.qb vss vss sky130_fd_pr__nfet_01v8 L=0.15 W=0.63 nf=1 m=1
XXc_11_2_XPU2 Xc_11_2.qb Xc_11_2.q vdd vdd sky130_fd_pr__pfet_01v8 L=0.15 W=0.42 nf=1 m=1
XXc_11_2_XPD2 Xc_11_2.qb Xc_11_2.q vss vss sky130_fd_pr__nfet_01v8 L=0.15 W=0.63 nf=1 m=1
XXc_11_2_XPG1 bl2 wl11 Xc_11_2.q vss sky130_fd_pr__nfet_01v8 L=0.15 W=0.42 nf=1 m=1
XXc_11_2_XPG2 blb2 wl11 Xc_11_2.qb vss sky130_fd_pr__nfet_01v8 L=0.15 W=0.42 nf=1 m=1
XXc_11_3_XPU1 Xc_11_3.q Xc_11_3.qb vdd vdd sky130_fd_pr__pfet_01v8 L=0.15 W=0.42 nf=1 m=1
XXc_11_3_XPD1 Xc_11_3.q Xc_11_3.qb vss vss sky130_fd_pr__nfet_01v8 L=0.15 W=0.63 nf=1 m=1
XXc_11_3_XPU2 Xc_11_3.qb Xc_11_3.q vdd vdd sky130_fd_pr__pfet_01v8 L=0.15 W=0.42 nf=1 m=1
XXc_11_3_XPD2 Xc_11_3.qb Xc_11_3.q vss vss sky130_fd_pr__nfet_01v8 L=0.15 W=0.63 nf=1 m=1
XXc_11_3_XPG1 bl3 wl11 Xc_11_3.q vss sky130_fd_pr__nfet_01v8 L=0.15 W=0.42 nf=1 m=1
XXc_11_3_XPG2 blb3 wl11 Xc_11_3.qb vss sky130_fd_pr__nfet_01v8 L=0.15 W=0.42 nf=1 m=1
XXc_11_4_XPU1 Xc_11_4.q Xc_11_4.qb vdd vdd sky130_fd_pr__pfet_01v8 L=0.15 W=0.42 nf=1 m=1
XXc_11_4_XPD1 Xc_11_4.q Xc_11_4.qb vss vss sky130_fd_pr__nfet_01v8 L=0.15 W=0.63 nf=1 m=1
XXc_11_4_XPU2 Xc_11_4.qb Xc_11_4.q vdd vdd sky130_fd_pr__pfet_01v8 L=0.15 W=0.42 nf=1 m=1
XXc_11_4_XPD2 Xc_11_4.qb Xc_11_4.q vss vss sky130_fd_pr__nfet_01v8 L=0.15 W=0.63 nf=1 m=1
XXc_11_4_XPG1 bl4 wl11 Xc_11_4.q vss sky130_fd_pr__nfet_01v8 L=0.15 W=0.42 nf=1 m=1
XXc_11_4_XPG2 blb4 wl11 Xc_11_4.qb vss sky130_fd_pr__nfet_01v8 L=0.15 W=0.42 nf=1 m=1
XXc_11_5_XPU1 Xc_11_5.q Xc_11_5.qb vdd vdd sky130_fd_pr__pfet_01v8 L=0.15 W=0.42 nf=1 m=1
XXc_11_5_XPD1 Xc_11_5.q Xc_11_5.qb vss vss sky130_fd_pr__nfet_01v8 L=0.15 W=0.63 nf=1 m=1
XXc_11_5_XPU2 Xc_11_5.qb Xc_11_5.q vdd vdd sky130_fd_pr__pfet_01v8 L=0.15 W=0.42 nf=1 m=1
XXc_11_5_XPD2 Xc_11_5.qb Xc_11_5.q vss vss sky130_fd_pr__nfet_01v8 L=0.15 W=0.63 nf=1 m=1
XXc_11_5_XPG1 bl5 wl11 Xc_11_5.q vss sky130_fd_pr__nfet_01v8 L=0.15 W=0.42 nf=1 m=1
XXc_11_5_XPG2 blb5 wl11 Xc_11_5.qb vss sky130_fd_pr__nfet_01v8 L=0.15 W=0.42 nf=1 m=1
XXc_11_6_XPU1 Xc_11_6.q Xc_11_6.qb vdd vdd sky130_fd_pr__pfet_01v8 L=0.15 W=0.42 nf=1 m=1
XXc_11_6_XPD1 Xc_11_6.q Xc_11_6.qb vss vss sky130_fd_pr__nfet_01v8 L=0.15 W=0.63 nf=1 m=1
XXc_11_6_XPU2 Xc_11_6.qb Xc_11_6.q vdd vdd sky130_fd_pr__pfet_01v8 L=0.15 W=0.42 nf=1 m=1
XXc_11_6_XPD2 Xc_11_6.qb Xc_11_6.q vss vss sky130_fd_pr__nfet_01v8 L=0.15 W=0.63 nf=1 m=1
XXc_11_6_XPG1 bl6 wl11 Xc_11_6.q vss sky130_fd_pr__nfet_01v8 L=0.15 W=0.42 nf=1 m=1
XXc_11_6_XPG2 blb6 wl11 Xc_11_6.qb vss sky130_fd_pr__nfet_01v8 L=0.15 W=0.42 nf=1 m=1
XXc_11_7_XPU1 Xc_11_7.q Xc_11_7.qb vdd vdd sky130_fd_pr__pfet_01v8 L=0.15 W=0.42 nf=1 m=1
XXc_11_7_XPD1 Xc_11_7.q Xc_11_7.qb vss vss sky130_fd_pr__nfet_01v8 L=0.15 W=0.63 nf=1 m=1
XXc_11_7_XPU2 Xc_11_7.qb Xc_11_7.q vdd vdd sky130_fd_pr__pfet_01v8 L=0.15 W=0.42 nf=1 m=1
XXc_11_7_XPD2 Xc_11_7.qb Xc_11_7.q vss vss sky130_fd_pr__nfet_01v8 L=0.15 W=0.63 nf=1 m=1
XXc_11_7_XPG1 bl7 wl11 Xc_11_7.q vss sky130_fd_pr__nfet_01v8 L=0.15 W=0.42 nf=1 m=1
XXc_11_7_XPG2 blb7 wl11 Xc_11_7.qb vss sky130_fd_pr__nfet_01v8 L=0.15 W=0.42 nf=1 m=1
XXc_11_8_XPU1 Xc_11_8.q Xc_11_8.qb vdd vdd sky130_fd_pr__pfet_01v8 L=0.15 W=0.42 nf=1 m=1
XXc_11_8_XPD1 Xc_11_8.q Xc_11_8.qb vss vss sky130_fd_pr__nfet_01v8 L=0.15 W=0.63 nf=1 m=1
XXc_11_8_XPU2 Xc_11_8.qb Xc_11_8.q vdd vdd sky130_fd_pr__pfet_01v8 L=0.15 W=0.42 nf=1 m=1
XXc_11_8_XPD2 Xc_11_8.qb Xc_11_8.q vss vss sky130_fd_pr__nfet_01v8 L=0.15 W=0.63 nf=1 m=1
XXc_11_8_XPG1 bl8 wl11 Xc_11_8.q vss sky130_fd_pr__nfet_01v8 L=0.15 W=0.42 nf=1 m=1
XXc_11_8_XPG2 blb8 wl11 Xc_11_8.qb vss sky130_fd_pr__nfet_01v8 L=0.15 W=0.42 nf=1 m=1
XXc_11_9_XPU1 Xc_11_9.q Xc_11_9.qb vdd vdd sky130_fd_pr__pfet_01v8 L=0.15 W=0.42 nf=1 m=1
XXc_11_9_XPD1 Xc_11_9.q Xc_11_9.qb vss vss sky130_fd_pr__nfet_01v8 L=0.15 W=0.63 nf=1 m=1
XXc_11_9_XPU2 Xc_11_9.qb Xc_11_9.q vdd vdd sky130_fd_pr__pfet_01v8 L=0.15 W=0.42 nf=1 m=1
XXc_11_9_XPD2 Xc_11_9.qb Xc_11_9.q vss vss sky130_fd_pr__nfet_01v8 L=0.15 W=0.63 nf=1 m=1
XXc_11_9_XPG1 bl9 wl11 Xc_11_9.q vss sky130_fd_pr__nfet_01v8 L=0.15 W=0.42 nf=1 m=1
XXc_11_9_XPG2 blb9 wl11 Xc_11_9.qb vss sky130_fd_pr__nfet_01v8 L=0.15 W=0.42 nf=1 m=1
XXc_11_10_XPU1 Xc_11_10.q Xc_11_10.qb vdd vdd sky130_fd_pr__pfet_01v8 L=0.15 W=0.42 nf=1 m=1
XXc_11_10_XPD1 Xc_11_10.q Xc_11_10.qb vss vss sky130_fd_pr__nfet_01v8 L=0.15 W=0.63 nf=1 m=1
XXc_11_10_XPU2 Xc_11_10.qb Xc_11_10.q vdd vdd sky130_fd_pr__pfet_01v8 L=0.15 W=0.42 nf=1 m=1
XXc_11_10_XPD2 Xc_11_10.qb Xc_11_10.q vss vss sky130_fd_pr__nfet_01v8 L=0.15 W=0.63 nf=1 m=1
XXc_11_10_XPG1 bl10 wl11 Xc_11_10.q vss sky130_fd_pr__nfet_01v8 L=0.15 W=0.42 nf=1 m=1
XXc_11_10_XPG2 blb10 wl11 Xc_11_10.qb vss sky130_fd_pr__nfet_01v8 L=0.15 W=0.42 nf=1 m=1
XXc_11_11_XPU1 Xc_11_11.q Xc_11_11.qb vdd vdd sky130_fd_pr__pfet_01v8 L=0.15 W=0.42 nf=1 m=1
XXc_11_11_XPD1 Xc_11_11.q Xc_11_11.qb vss vss sky130_fd_pr__nfet_01v8 L=0.15 W=0.63 nf=1 m=1
XXc_11_11_XPU2 Xc_11_11.qb Xc_11_11.q vdd vdd sky130_fd_pr__pfet_01v8 L=0.15 W=0.42 nf=1 m=1
XXc_11_11_XPD2 Xc_11_11.qb Xc_11_11.q vss vss sky130_fd_pr__nfet_01v8 L=0.15 W=0.63 nf=1 m=1
XXc_11_11_XPG1 bl11 wl11 Xc_11_11.q vss sky130_fd_pr__nfet_01v8 L=0.15 W=0.42 nf=1 m=1
XXc_11_11_XPG2 blb11 wl11 Xc_11_11.qb vss sky130_fd_pr__nfet_01v8 L=0.15 W=0.42 nf=1 m=1
XXc_11_12_XPU1 Xc_11_12.q Xc_11_12.qb vdd vdd sky130_fd_pr__pfet_01v8 L=0.15 W=0.42 nf=1 m=1
XXc_11_12_XPD1 Xc_11_12.q Xc_11_12.qb vss vss sky130_fd_pr__nfet_01v8 L=0.15 W=0.63 nf=1 m=1
XXc_11_12_XPU2 Xc_11_12.qb Xc_11_12.q vdd vdd sky130_fd_pr__pfet_01v8 L=0.15 W=0.42 nf=1 m=1
XXc_11_12_XPD2 Xc_11_12.qb Xc_11_12.q vss vss sky130_fd_pr__nfet_01v8 L=0.15 W=0.63 nf=1 m=1
XXc_11_12_XPG1 bl12 wl11 Xc_11_12.q vss sky130_fd_pr__nfet_01v8 L=0.15 W=0.42 nf=1 m=1
XXc_11_12_XPG2 blb12 wl11 Xc_11_12.qb vss sky130_fd_pr__nfet_01v8 L=0.15 W=0.42 nf=1 m=1
XXc_11_13_XPU1 Xc_11_13.q Xc_11_13.qb vdd vdd sky130_fd_pr__pfet_01v8 L=0.15 W=0.42 nf=1 m=1
XXc_11_13_XPD1 Xc_11_13.q Xc_11_13.qb vss vss sky130_fd_pr__nfet_01v8 L=0.15 W=0.63 nf=1 m=1
XXc_11_13_XPU2 Xc_11_13.qb Xc_11_13.q vdd vdd sky130_fd_pr__pfet_01v8 L=0.15 W=0.42 nf=1 m=1
XXc_11_13_XPD2 Xc_11_13.qb Xc_11_13.q vss vss sky130_fd_pr__nfet_01v8 L=0.15 W=0.63 nf=1 m=1
XXc_11_13_XPG1 bl13 wl11 Xc_11_13.q vss sky130_fd_pr__nfet_01v8 L=0.15 W=0.42 nf=1 m=1
XXc_11_13_XPG2 blb13 wl11 Xc_11_13.qb vss sky130_fd_pr__nfet_01v8 L=0.15 W=0.42 nf=1 m=1
XXc_11_14_XPU1 Xc_11_14.q Xc_11_14.qb vdd vdd sky130_fd_pr__pfet_01v8 L=0.15 W=0.42 nf=1 m=1
XXc_11_14_XPD1 Xc_11_14.q Xc_11_14.qb vss vss sky130_fd_pr__nfet_01v8 L=0.15 W=0.63 nf=1 m=1
XXc_11_14_XPU2 Xc_11_14.qb Xc_11_14.q vdd vdd sky130_fd_pr__pfet_01v8 L=0.15 W=0.42 nf=1 m=1
XXc_11_14_XPD2 Xc_11_14.qb Xc_11_14.q vss vss sky130_fd_pr__nfet_01v8 L=0.15 W=0.63 nf=1 m=1
XXc_11_14_XPG1 bl14 wl11 Xc_11_14.q vss sky130_fd_pr__nfet_01v8 L=0.15 W=0.42 nf=1 m=1
XXc_11_14_XPG2 blb14 wl11 Xc_11_14.qb vss sky130_fd_pr__nfet_01v8 L=0.15 W=0.42 nf=1 m=1
XXc_11_15_XPU1 Xc_11_15.q Xc_11_15.qb vdd vdd sky130_fd_pr__pfet_01v8 L=0.15 W=0.42 nf=1 m=1
XXc_11_15_XPD1 Xc_11_15.q Xc_11_15.qb vss vss sky130_fd_pr__nfet_01v8 L=0.15 W=0.63 nf=1 m=1
XXc_11_15_XPU2 Xc_11_15.qb Xc_11_15.q vdd vdd sky130_fd_pr__pfet_01v8 L=0.15 W=0.42 nf=1 m=1
XXc_11_15_XPD2 Xc_11_15.qb Xc_11_15.q vss vss sky130_fd_pr__nfet_01v8 L=0.15 W=0.63 nf=1 m=1
XXc_11_15_XPG1 bl15 wl11 Xc_11_15.q vss sky130_fd_pr__nfet_01v8 L=0.15 W=0.42 nf=1 m=1
XXc_11_15_XPG2 blb15 wl11 Xc_11_15.qb vss sky130_fd_pr__nfet_01v8 L=0.15 W=0.42 nf=1 m=1
XXc_12_0_XPU1 Xc_12_0.q Xc_12_0.qb vdd vdd sky130_fd_pr__pfet_01v8 L=0.15 W=0.42 nf=1 m=1
XXc_12_0_XPD1 Xc_12_0.q Xc_12_0.qb vss vss sky130_fd_pr__nfet_01v8 L=0.15 W=0.63 nf=1 m=1
XXc_12_0_XPU2 Xc_12_0.qb Xc_12_0.q vdd vdd sky130_fd_pr__pfet_01v8 L=0.15 W=0.42 nf=1 m=1
XXc_12_0_XPD2 Xc_12_0.qb Xc_12_0.q vss vss sky130_fd_pr__nfet_01v8 L=0.15 W=0.63 nf=1 m=1
XXc_12_0_XPG1 bl0 wl12 Xc_12_0.q vss sky130_fd_pr__nfet_01v8 L=0.15 W=0.42 nf=1 m=1
XXc_12_0_XPG2 blb0 wl12 Xc_12_0.qb vss sky130_fd_pr__nfet_01v8 L=0.15 W=0.42 nf=1 m=1
XXc_12_1_XPU1 Xc_12_1.q Xc_12_1.qb vdd vdd sky130_fd_pr__pfet_01v8 L=0.15 W=0.42 nf=1 m=1
XXc_12_1_XPD1 Xc_12_1.q Xc_12_1.qb vss vss sky130_fd_pr__nfet_01v8 L=0.15 W=0.63 nf=1 m=1
XXc_12_1_XPU2 Xc_12_1.qb Xc_12_1.q vdd vdd sky130_fd_pr__pfet_01v8 L=0.15 W=0.42 nf=1 m=1
XXc_12_1_XPD2 Xc_12_1.qb Xc_12_1.q vss vss sky130_fd_pr__nfet_01v8 L=0.15 W=0.63 nf=1 m=1
XXc_12_1_XPG1 bl1 wl12 Xc_12_1.q vss sky130_fd_pr__nfet_01v8 L=0.15 W=0.42 nf=1 m=1
XXc_12_1_XPG2 blb1 wl12 Xc_12_1.qb vss sky130_fd_pr__nfet_01v8 L=0.15 W=0.42 nf=1 m=1
XXc_12_2_XPU1 Xc_12_2.q Xc_12_2.qb vdd vdd sky130_fd_pr__pfet_01v8 L=0.15 W=0.42 nf=1 m=1
XXc_12_2_XPD1 Xc_12_2.q Xc_12_2.qb vss vss sky130_fd_pr__nfet_01v8 L=0.15 W=0.63 nf=1 m=1
XXc_12_2_XPU2 Xc_12_2.qb Xc_12_2.q vdd vdd sky130_fd_pr__pfet_01v8 L=0.15 W=0.42 nf=1 m=1
XXc_12_2_XPD2 Xc_12_2.qb Xc_12_2.q vss vss sky130_fd_pr__nfet_01v8 L=0.15 W=0.63 nf=1 m=1
XXc_12_2_XPG1 bl2 wl12 Xc_12_2.q vss sky130_fd_pr__nfet_01v8 L=0.15 W=0.42 nf=1 m=1
XXc_12_2_XPG2 blb2 wl12 Xc_12_2.qb vss sky130_fd_pr__nfet_01v8 L=0.15 W=0.42 nf=1 m=1
XXc_12_3_XPU1 Xc_12_3.q Xc_12_3.qb vdd vdd sky130_fd_pr__pfet_01v8 L=0.15 W=0.42 nf=1 m=1
XXc_12_3_XPD1 Xc_12_3.q Xc_12_3.qb vss vss sky130_fd_pr__nfet_01v8 L=0.15 W=0.63 nf=1 m=1
XXc_12_3_XPU2 Xc_12_3.qb Xc_12_3.q vdd vdd sky130_fd_pr__pfet_01v8 L=0.15 W=0.42 nf=1 m=1
XXc_12_3_XPD2 Xc_12_3.qb Xc_12_3.q vss vss sky130_fd_pr__nfet_01v8 L=0.15 W=0.63 nf=1 m=1
XXc_12_3_XPG1 bl3 wl12 Xc_12_3.q vss sky130_fd_pr__nfet_01v8 L=0.15 W=0.42 nf=1 m=1
XXc_12_3_XPG2 blb3 wl12 Xc_12_3.qb vss sky130_fd_pr__nfet_01v8 L=0.15 W=0.42 nf=1 m=1
XXc_12_4_XPU1 Xc_12_4.q Xc_12_4.qb vdd vdd sky130_fd_pr__pfet_01v8 L=0.15 W=0.42 nf=1 m=1
XXc_12_4_XPD1 Xc_12_4.q Xc_12_4.qb vss vss sky130_fd_pr__nfet_01v8 L=0.15 W=0.63 nf=1 m=1
XXc_12_4_XPU2 Xc_12_4.qb Xc_12_4.q vdd vdd sky130_fd_pr__pfet_01v8 L=0.15 W=0.42 nf=1 m=1
XXc_12_4_XPD2 Xc_12_4.qb Xc_12_4.q vss vss sky130_fd_pr__nfet_01v8 L=0.15 W=0.63 nf=1 m=1
XXc_12_4_XPG1 bl4 wl12 Xc_12_4.q vss sky130_fd_pr__nfet_01v8 L=0.15 W=0.42 nf=1 m=1
XXc_12_4_XPG2 blb4 wl12 Xc_12_4.qb vss sky130_fd_pr__nfet_01v8 L=0.15 W=0.42 nf=1 m=1
XXc_12_5_XPU1 Xc_12_5.q Xc_12_5.qb vdd vdd sky130_fd_pr__pfet_01v8 L=0.15 W=0.42 nf=1 m=1
XXc_12_5_XPD1 Xc_12_5.q Xc_12_5.qb vss vss sky130_fd_pr__nfet_01v8 L=0.15 W=0.63 nf=1 m=1
XXc_12_5_XPU2 Xc_12_5.qb Xc_12_5.q vdd vdd sky130_fd_pr__pfet_01v8 L=0.15 W=0.42 nf=1 m=1
XXc_12_5_XPD2 Xc_12_5.qb Xc_12_5.q vss vss sky130_fd_pr__nfet_01v8 L=0.15 W=0.63 nf=1 m=1
XXc_12_5_XPG1 bl5 wl12 Xc_12_5.q vss sky130_fd_pr__nfet_01v8 L=0.15 W=0.42 nf=1 m=1
XXc_12_5_XPG2 blb5 wl12 Xc_12_5.qb vss sky130_fd_pr__nfet_01v8 L=0.15 W=0.42 nf=1 m=1
XXc_12_6_XPU1 Xc_12_6.q Xc_12_6.qb vdd vdd sky130_fd_pr__pfet_01v8 L=0.15 W=0.42 nf=1 m=1
XXc_12_6_XPD1 Xc_12_6.q Xc_12_6.qb vss vss sky130_fd_pr__nfet_01v8 L=0.15 W=0.63 nf=1 m=1
XXc_12_6_XPU2 Xc_12_6.qb Xc_12_6.q vdd vdd sky130_fd_pr__pfet_01v8 L=0.15 W=0.42 nf=1 m=1
XXc_12_6_XPD2 Xc_12_6.qb Xc_12_6.q vss vss sky130_fd_pr__nfet_01v8 L=0.15 W=0.63 nf=1 m=1
XXc_12_6_XPG1 bl6 wl12 Xc_12_6.q vss sky130_fd_pr__nfet_01v8 L=0.15 W=0.42 nf=1 m=1
XXc_12_6_XPG2 blb6 wl12 Xc_12_6.qb vss sky130_fd_pr__nfet_01v8 L=0.15 W=0.42 nf=1 m=1
XXc_12_7_XPU1 Xc_12_7.q Xc_12_7.qb vdd vdd sky130_fd_pr__pfet_01v8 L=0.15 W=0.42 nf=1 m=1
XXc_12_7_XPD1 Xc_12_7.q Xc_12_7.qb vss vss sky130_fd_pr__nfet_01v8 L=0.15 W=0.63 nf=1 m=1
XXc_12_7_XPU2 Xc_12_7.qb Xc_12_7.q vdd vdd sky130_fd_pr__pfet_01v8 L=0.15 W=0.42 nf=1 m=1
XXc_12_7_XPD2 Xc_12_7.qb Xc_12_7.q vss vss sky130_fd_pr__nfet_01v8 L=0.15 W=0.63 nf=1 m=1
XXc_12_7_XPG1 bl7 wl12 Xc_12_7.q vss sky130_fd_pr__nfet_01v8 L=0.15 W=0.42 nf=1 m=1
XXc_12_7_XPG2 blb7 wl12 Xc_12_7.qb vss sky130_fd_pr__nfet_01v8 L=0.15 W=0.42 nf=1 m=1
XXc_12_8_XPU1 Xc_12_8.q Xc_12_8.qb vdd vdd sky130_fd_pr__pfet_01v8 L=0.15 W=0.42 nf=1 m=1
XXc_12_8_XPD1 Xc_12_8.q Xc_12_8.qb vss vss sky130_fd_pr__nfet_01v8 L=0.15 W=0.63 nf=1 m=1
XXc_12_8_XPU2 Xc_12_8.qb Xc_12_8.q vdd vdd sky130_fd_pr__pfet_01v8 L=0.15 W=0.42 nf=1 m=1
XXc_12_8_XPD2 Xc_12_8.qb Xc_12_8.q vss vss sky130_fd_pr__nfet_01v8 L=0.15 W=0.63 nf=1 m=1
XXc_12_8_XPG1 bl8 wl12 Xc_12_8.q vss sky130_fd_pr__nfet_01v8 L=0.15 W=0.42 nf=1 m=1
XXc_12_8_XPG2 blb8 wl12 Xc_12_8.qb vss sky130_fd_pr__nfet_01v8 L=0.15 W=0.42 nf=1 m=1
XXc_12_9_XPU1 Xc_12_9.q Xc_12_9.qb vdd vdd sky130_fd_pr__pfet_01v8 L=0.15 W=0.42 nf=1 m=1
XXc_12_9_XPD1 Xc_12_9.q Xc_12_9.qb vss vss sky130_fd_pr__nfet_01v8 L=0.15 W=0.63 nf=1 m=1
XXc_12_9_XPU2 Xc_12_9.qb Xc_12_9.q vdd vdd sky130_fd_pr__pfet_01v8 L=0.15 W=0.42 nf=1 m=1
XXc_12_9_XPD2 Xc_12_9.qb Xc_12_9.q vss vss sky130_fd_pr__nfet_01v8 L=0.15 W=0.63 nf=1 m=1
XXc_12_9_XPG1 bl9 wl12 Xc_12_9.q vss sky130_fd_pr__nfet_01v8 L=0.15 W=0.42 nf=1 m=1
XXc_12_9_XPG2 blb9 wl12 Xc_12_9.qb vss sky130_fd_pr__nfet_01v8 L=0.15 W=0.42 nf=1 m=1
XXc_12_10_XPU1 Xc_12_10.q Xc_12_10.qb vdd vdd sky130_fd_pr__pfet_01v8 L=0.15 W=0.42 nf=1 m=1
XXc_12_10_XPD1 Xc_12_10.q Xc_12_10.qb vss vss sky130_fd_pr__nfet_01v8 L=0.15 W=0.63 nf=1 m=1
XXc_12_10_XPU2 Xc_12_10.qb Xc_12_10.q vdd vdd sky130_fd_pr__pfet_01v8 L=0.15 W=0.42 nf=1 m=1
XXc_12_10_XPD2 Xc_12_10.qb Xc_12_10.q vss vss sky130_fd_pr__nfet_01v8 L=0.15 W=0.63 nf=1 m=1
XXc_12_10_XPG1 bl10 wl12 Xc_12_10.q vss sky130_fd_pr__nfet_01v8 L=0.15 W=0.42 nf=1 m=1
XXc_12_10_XPG2 blb10 wl12 Xc_12_10.qb vss sky130_fd_pr__nfet_01v8 L=0.15 W=0.42 nf=1 m=1
XXc_12_11_XPU1 Xc_12_11.q Xc_12_11.qb vdd vdd sky130_fd_pr__pfet_01v8 L=0.15 W=0.42 nf=1 m=1
XXc_12_11_XPD1 Xc_12_11.q Xc_12_11.qb vss vss sky130_fd_pr__nfet_01v8 L=0.15 W=0.63 nf=1 m=1
XXc_12_11_XPU2 Xc_12_11.qb Xc_12_11.q vdd vdd sky130_fd_pr__pfet_01v8 L=0.15 W=0.42 nf=1 m=1
XXc_12_11_XPD2 Xc_12_11.qb Xc_12_11.q vss vss sky130_fd_pr__nfet_01v8 L=0.15 W=0.63 nf=1 m=1
XXc_12_11_XPG1 bl11 wl12 Xc_12_11.q vss sky130_fd_pr__nfet_01v8 L=0.15 W=0.42 nf=1 m=1
XXc_12_11_XPG2 blb11 wl12 Xc_12_11.qb vss sky130_fd_pr__nfet_01v8 L=0.15 W=0.42 nf=1 m=1
XXc_12_12_XPU1 Xc_12_12.q Xc_12_12.qb vdd vdd sky130_fd_pr__pfet_01v8 L=0.15 W=0.42 nf=1 m=1
XXc_12_12_XPD1 Xc_12_12.q Xc_12_12.qb vss vss sky130_fd_pr__nfet_01v8 L=0.15 W=0.63 nf=1 m=1
XXc_12_12_XPU2 Xc_12_12.qb Xc_12_12.q vdd vdd sky130_fd_pr__pfet_01v8 L=0.15 W=0.42 nf=1 m=1
XXc_12_12_XPD2 Xc_12_12.qb Xc_12_12.q vss vss sky130_fd_pr__nfet_01v8 L=0.15 W=0.63 nf=1 m=1
XXc_12_12_XPG1 bl12 wl12 Xc_12_12.q vss sky130_fd_pr__nfet_01v8 L=0.15 W=0.42 nf=1 m=1
XXc_12_12_XPG2 blb12 wl12 Xc_12_12.qb vss sky130_fd_pr__nfet_01v8 L=0.15 W=0.42 nf=1 m=1
XXc_12_13_XPU1 Xc_12_13.q Xc_12_13.qb vdd vdd sky130_fd_pr__pfet_01v8 L=0.15 W=0.42 nf=1 m=1
XXc_12_13_XPD1 Xc_12_13.q Xc_12_13.qb vss vss sky130_fd_pr__nfet_01v8 L=0.15 W=0.63 nf=1 m=1
XXc_12_13_XPU2 Xc_12_13.qb Xc_12_13.q vdd vdd sky130_fd_pr__pfet_01v8 L=0.15 W=0.42 nf=1 m=1
XXc_12_13_XPD2 Xc_12_13.qb Xc_12_13.q vss vss sky130_fd_pr__nfet_01v8 L=0.15 W=0.63 nf=1 m=1
XXc_12_13_XPG1 bl13 wl12 Xc_12_13.q vss sky130_fd_pr__nfet_01v8 L=0.15 W=0.42 nf=1 m=1
XXc_12_13_XPG2 blb13 wl12 Xc_12_13.qb vss sky130_fd_pr__nfet_01v8 L=0.15 W=0.42 nf=1 m=1
XXc_12_14_XPU1 Xc_12_14.q Xc_12_14.qb vdd vdd sky130_fd_pr__pfet_01v8 L=0.15 W=0.42 nf=1 m=1
XXc_12_14_XPD1 Xc_12_14.q Xc_12_14.qb vss vss sky130_fd_pr__nfet_01v8 L=0.15 W=0.63 nf=1 m=1
XXc_12_14_XPU2 Xc_12_14.qb Xc_12_14.q vdd vdd sky130_fd_pr__pfet_01v8 L=0.15 W=0.42 nf=1 m=1
XXc_12_14_XPD2 Xc_12_14.qb Xc_12_14.q vss vss sky130_fd_pr__nfet_01v8 L=0.15 W=0.63 nf=1 m=1
XXc_12_14_XPG1 bl14 wl12 Xc_12_14.q vss sky130_fd_pr__nfet_01v8 L=0.15 W=0.42 nf=1 m=1
XXc_12_14_XPG2 blb14 wl12 Xc_12_14.qb vss sky130_fd_pr__nfet_01v8 L=0.15 W=0.42 nf=1 m=1
XXc_12_15_XPU1 Xc_12_15.q Xc_12_15.qb vdd vdd sky130_fd_pr__pfet_01v8 L=0.15 W=0.42 nf=1 m=1
XXc_12_15_XPD1 Xc_12_15.q Xc_12_15.qb vss vss sky130_fd_pr__nfet_01v8 L=0.15 W=0.63 nf=1 m=1
XXc_12_15_XPU2 Xc_12_15.qb Xc_12_15.q vdd vdd sky130_fd_pr__pfet_01v8 L=0.15 W=0.42 nf=1 m=1
XXc_12_15_XPD2 Xc_12_15.qb Xc_12_15.q vss vss sky130_fd_pr__nfet_01v8 L=0.15 W=0.63 nf=1 m=1
XXc_12_15_XPG1 bl15 wl12 Xc_12_15.q vss sky130_fd_pr__nfet_01v8 L=0.15 W=0.42 nf=1 m=1
XXc_12_15_XPG2 blb15 wl12 Xc_12_15.qb vss sky130_fd_pr__nfet_01v8 L=0.15 W=0.42 nf=1 m=1
XXc_13_0_XPU1 Xc_13_0.q Xc_13_0.qb vdd vdd sky130_fd_pr__pfet_01v8 L=0.15 W=0.42 nf=1 m=1
XXc_13_0_XPD1 Xc_13_0.q Xc_13_0.qb vss vss sky130_fd_pr__nfet_01v8 L=0.15 W=0.63 nf=1 m=1
XXc_13_0_XPU2 Xc_13_0.qb Xc_13_0.q vdd vdd sky130_fd_pr__pfet_01v8 L=0.15 W=0.42 nf=1 m=1
XXc_13_0_XPD2 Xc_13_0.qb Xc_13_0.q vss vss sky130_fd_pr__nfet_01v8 L=0.15 W=0.63 nf=1 m=1
XXc_13_0_XPG1 bl0 wl13 Xc_13_0.q vss sky130_fd_pr__nfet_01v8 L=0.15 W=0.42 nf=1 m=1
XXc_13_0_XPG2 blb0 wl13 Xc_13_0.qb vss sky130_fd_pr__nfet_01v8 L=0.15 W=0.42 nf=1 m=1
XXc_13_1_XPU1 Xc_13_1.q Xc_13_1.qb vdd vdd sky130_fd_pr__pfet_01v8 L=0.15 W=0.42 nf=1 m=1
XXc_13_1_XPD1 Xc_13_1.q Xc_13_1.qb vss vss sky130_fd_pr__nfet_01v8 L=0.15 W=0.63 nf=1 m=1
XXc_13_1_XPU2 Xc_13_1.qb Xc_13_1.q vdd vdd sky130_fd_pr__pfet_01v8 L=0.15 W=0.42 nf=1 m=1
XXc_13_1_XPD2 Xc_13_1.qb Xc_13_1.q vss vss sky130_fd_pr__nfet_01v8 L=0.15 W=0.63 nf=1 m=1
XXc_13_1_XPG1 bl1 wl13 Xc_13_1.q vss sky130_fd_pr__nfet_01v8 L=0.15 W=0.42 nf=1 m=1
XXc_13_1_XPG2 blb1 wl13 Xc_13_1.qb vss sky130_fd_pr__nfet_01v8 L=0.15 W=0.42 nf=1 m=1
XXc_13_2_XPU1 Xc_13_2.q Xc_13_2.qb vdd vdd sky130_fd_pr__pfet_01v8 L=0.15 W=0.42 nf=1 m=1
XXc_13_2_XPD1 Xc_13_2.q Xc_13_2.qb vss vss sky130_fd_pr__nfet_01v8 L=0.15 W=0.63 nf=1 m=1
XXc_13_2_XPU2 Xc_13_2.qb Xc_13_2.q vdd vdd sky130_fd_pr__pfet_01v8 L=0.15 W=0.42 nf=1 m=1
XXc_13_2_XPD2 Xc_13_2.qb Xc_13_2.q vss vss sky130_fd_pr__nfet_01v8 L=0.15 W=0.63 nf=1 m=1
XXc_13_2_XPG1 bl2 wl13 Xc_13_2.q vss sky130_fd_pr__nfet_01v8 L=0.15 W=0.42 nf=1 m=1
XXc_13_2_XPG2 blb2 wl13 Xc_13_2.qb vss sky130_fd_pr__nfet_01v8 L=0.15 W=0.42 nf=1 m=1
XXc_13_3_XPU1 Xc_13_3.q Xc_13_3.qb vdd vdd sky130_fd_pr__pfet_01v8 L=0.15 W=0.42 nf=1 m=1
XXc_13_3_XPD1 Xc_13_3.q Xc_13_3.qb vss vss sky130_fd_pr__nfet_01v8 L=0.15 W=0.63 nf=1 m=1
XXc_13_3_XPU2 Xc_13_3.qb Xc_13_3.q vdd vdd sky130_fd_pr__pfet_01v8 L=0.15 W=0.42 nf=1 m=1
XXc_13_3_XPD2 Xc_13_3.qb Xc_13_3.q vss vss sky130_fd_pr__nfet_01v8 L=0.15 W=0.63 nf=1 m=1
XXc_13_3_XPG1 bl3 wl13 Xc_13_3.q vss sky130_fd_pr__nfet_01v8 L=0.15 W=0.42 nf=1 m=1
XXc_13_3_XPG2 blb3 wl13 Xc_13_3.qb vss sky130_fd_pr__nfet_01v8 L=0.15 W=0.42 nf=1 m=1
XXc_13_4_XPU1 Xc_13_4.q Xc_13_4.qb vdd vdd sky130_fd_pr__pfet_01v8 L=0.15 W=0.42 nf=1 m=1
XXc_13_4_XPD1 Xc_13_4.q Xc_13_4.qb vss vss sky130_fd_pr__nfet_01v8 L=0.15 W=0.63 nf=1 m=1
XXc_13_4_XPU2 Xc_13_4.qb Xc_13_4.q vdd vdd sky130_fd_pr__pfet_01v8 L=0.15 W=0.42 nf=1 m=1
XXc_13_4_XPD2 Xc_13_4.qb Xc_13_4.q vss vss sky130_fd_pr__nfet_01v8 L=0.15 W=0.63 nf=1 m=1
XXc_13_4_XPG1 bl4 wl13 Xc_13_4.q vss sky130_fd_pr__nfet_01v8 L=0.15 W=0.42 nf=1 m=1
XXc_13_4_XPG2 blb4 wl13 Xc_13_4.qb vss sky130_fd_pr__nfet_01v8 L=0.15 W=0.42 nf=1 m=1
XXc_13_5_XPU1 Xc_13_5.q Xc_13_5.qb vdd vdd sky130_fd_pr__pfet_01v8 L=0.15 W=0.42 nf=1 m=1
XXc_13_5_XPD1 Xc_13_5.q Xc_13_5.qb vss vss sky130_fd_pr__nfet_01v8 L=0.15 W=0.63 nf=1 m=1
XXc_13_5_XPU2 Xc_13_5.qb Xc_13_5.q vdd vdd sky130_fd_pr__pfet_01v8 L=0.15 W=0.42 nf=1 m=1
XXc_13_5_XPD2 Xc_13_5.qb Xc_13_5.q vss vss sky130_fd_pr__nfet_01v8 L=0.15 W=0.63 nf=1 m=1
XXc_13_5_XPG1 bl5 wl13 Xc_13_5.q vss sky130_fd_pr__nfet_01v8 L=0.15 W=0.42 nf=1 m=1
XXc_13_5_XPG2 blb5 wl13 Xc_13_5.qb vss sky130_fd_pr__nfet_01v8 L=0.15 W=0.42 nf=1 m=1
XXc_13_6_XPU1 Xc_13_6.q Xc_13_6.qb vdd vdd sky130_fd_pr__pfet_01v8 L=0.15 W=0.42 nf=1 m=1
XXc_13_6_XPD1 Xc_13_6.q Xc_13_6.qb vss vss sky130_fd_pr__nfet_01v8 L=0.15 W=0.63 nf=1 m=1
XXc_13_6_XPU2 Xc_13_6.qb Xc_13_6.q vdd vdd sky130_fd_pr__pfet_01v8 L=0.15 W=0.42 nf=1 m=1
XXc_13_6_XPD2 Xc_13_6.qb Xc_13_6.q vss vss sky130_fd_pr__nfet_01v8 L=0.15 W=0.63 nf=1 m=1
XXc_13_6_XPG1 bl6 wl13 Xc_13_6.q vss sky130_fd_pr__nfet_01v8 L=0.15 W=0.42 nf=1 m=1
XXc_13_6_XPG2 blb6 wl13 Xc_13_6.qb vss sky130_fd_pr__nfet_01v8 L=0.15 W=0.42 nf=1 m=1
XXc_13_7_XPU1 Xc_13_7.q Xc_13_7.qb vdd vdd sky130_fd_pr__pfet_01v8 L=0.15 W=0.42 nf=1 m=1
XXc_13_7_XPD1 Xc_13_7.q Xc_13_7.qb vss vss sky130_fd_pr__nfet_01v8 L=0.15 W=0.63 nf=1 m=1
XXc_13_7_XPU2 Xc_13_7.qb Xc_13_7.q vdd vdd sky130_fd_pr__pfet_01v8 L=0.15 W=0.42 nf=1 m=1
XXc_13_7_XPD2 Xc_13_7.qb Xc_13_7.q vss vss sky130_fd_pr__nfet_01v8 L=0.15 W=0.63 nf=1 m=1
XXc_13_7_XPG1 bl7 wl13 Xc_13_7.q vss sky130_fd_pr__nfet_01v8 L=0.15 W=0.42 nf=1 m=1
XXc_13_7_XPG2 blb7 wl13 Xc_13_7.qb vss sky130_fd_pr__nfet_01v8 L=0.15 W=0.42 nf=1 m=1
XXc_13_8_XPU1 Xc_13_8.q Xc_13_8.qb vdd vdd sky130_fd_pr__pfet_01v8 L=0.15 W=0.42 nf=1 m=1
XXc_13_8_XPD1 Xc_13_8.q Xc_13_8.qb vss vss sky130_fd_pr__nfet_01v8 L=0.15 W=0.63 nf=1 m=1
XXc_13_8_XPU2 Xc_13_8.qb Xc_13_8.q vdd vdd sky130_fd_pr__pfet_01v8 L=0.15 W=0.42 nf=1 m=1
XXc_13_8_XPD2 Xc_13_8.qb Xc_13_8.q vss vss sky130_fd_pr__nfet_01v8 L=0.15 W=0.63 nf=1 m=1
XXc_13_8_XPG1 bl8 wl13 Xc_13_8.q vss sky130_fd_pr__nfet_01v8 L=0.15 W=0.42 nf=1 m=1
XXc_13_8_XPG2 blb8 wl13 Xc_13_8.qb vss sky130_fd_pr__nfet_01v8 L=0.15 W=0.42 nf=1 m=1
XXc_13_9_XPU1 Xc_13_9.q Xc_13_9.qb vdd vdd sky130_fd_pr__pfet_01v8 L=0.15 W=0.42 nf=1 m=1
XXc_13_9_XPD1 Xc_13_9.q Xc_13_9.qb vss vss sky130_fd_pr__nfet_01v8 L=0.15 W=0.63 nf=1 m=1
XXc_13_9_XPU2 Xc_13_9.qb Xc_13_9.q vdd vdd sky130_fd_pr__pfet_01v8 L=0.15 W=0.42 nf=1 m=1
XXc_13_9_XPD2 Xc_13_9.qb Xc_13_9.q vss vss sky130_fd_pr__nfet_01v8 L=0.15 W=0.63 nf=1 m=1
XXc_13_9_XPG1 bl9 wl13 Xc_13_9.q vss sky130_fd_pr__nfet_01v8 L=0.15 W=0.42 nf=1 m=1
XXc_13_9_XPG2 blb9 wl13 Xc_13_9.qb vss sky130_fd_pr__nfet_01v8 L=0.15 W=0.42 nf=1 m=1
XXc_13_10_XPU1 Xc_13_10.q Xc_13_10.qb vdd vdd sky130_fd_pr__pfet_01v8 L=0.15 W=0.42 nf=1 m=1
XXc_13_10_XPD1 Xc_13_10.q Xc_13_10.qb vss vss sky130_fd_pr__nfet_01v8 L=0.15 W=0.63 nf=1 m=1
XXc_13_10_XPU2 Xc_13_10.qb Xc_13_10.q vdd vdd sky130_fd_pr__pfet_01v8 L=0.15 W=0.42 nf=1 m=1
XXc_13_10_XPD2 Xc_13_10.qb Xc_13_10.q vss vss sky130_fd_pr__nfet_01v8 L=0.15 W=0.63 nf=1 m=1
XXc_13_10_XPG1 bl10 wl13 Xc_13_10.q vss sky130_fd_pr__nfet_01v8 L=0.15 W=0.42 nf=1 m=1
XXc_13_10_XPG2 blb10 wl13 Xc_13_10.qb vss sky130_fd_pr__nfet_01v8 L=0.15 W=0.42 nf=1 m=1
XXc_13_11_XPU1 Xc_13_11.q Xc_13_11.qb vdd vdd sky130_fd_pr__pfet_01v8 L=0.15 W=0.42 nf=1 m=1
XXc_13_11_XPD1 Xc_13_11.q Xc_13_11.qb vss vss sky130_fd_pr__nfet_01v8 L=0.15 W=0.63 nf=1 m=1
XXc_13_11_XPU2 Xc_13_11.qb Xc_13_11.q vdd vdd sky130_fd_pr__pfet_01v8 L=0.15 W=0.42 nf=1 m=1
XXc_13_11_XPD2 Xc_13_11.qb Xc_13_11.q vss vss sky130_fd_pr__nfet_01v8 L=0.15 W=0.63 nf=1 m=1
XXc_13_11_XPG1 bl11 wl13 Xc_13_11.q vss sky130_fd_pr__nfet_01v8 L=0.15 W=0.42 nf=1 m=1
XXc_13_11_XPG2 blb11 wl13 Xc_13_11.qb vss sky130_fd_pr__nfet_01v8 L=0.15 W=0.42 nf=1 m=1
XXc_13_12_XPU1 Xc_13_12.q Xc_13_12.qb vdd vdd sky130_fd_pr__pfet_01v8 L=0.15 W=0.42 nf=1 m=1
XXc_13_12_XPD1 Xc_13_12.q Xc_13_12.qb vss vss sky130_fd_pr__nfet_01v8 L=0.15 W=0.63 nf=1 m=1
XXc_13_12_XPU2 Xc_13_12.qb Xc_13_12.q vdd vdd sky130_fd_pr__pfet_01v8 L=0.15 W=0.42 nf=1 m=1
XXc_13_12_XPD2 Xc_13_12.qb Xc_13_12.q vss vss sky130_fd_pr__nfet_01v8 L=0.15 W=0.63 nf=1 m=1
XXc_13_12_XPG1 bl12 wl13 Xc_13_12.q vss sky130_fd_pr__nfet_01v8 L=0.15 W=0.42 nf=1 m=1
XXc_13_12_XPG2 blb12 wl13 Xc_13_12.qb vss sky130_fd_pr__nfet_01v8 L=0.15 W=0.42 nf=1 m=1
XXc_13_13_XPU1 Xc_13_13.q Xc_13_13.qb vdd vdd sky130_fd_pr__pfet_01v8 L=0.15 W=0.42 nf=1 m=1
XXc_13_13_XPD1 Xc_13_13.q Xc_13_13.qb vss vss sky130_fd_pr__nfet_01v8 L=0.15 W=0.63 nf=1 m=1
XXc_13_13_XPU2 Xc_13_13.qb Xc_13_13.q vdd vdd sky130_fd_pr__pfet_01v8 L=0.15 W=0.42 nf=1 m=1
XXc_13_13_XPD2 Xc_13_13.qb Xc_13_13.q vss vss sky130_fd_pr__nfet_01v8 L=0.15 W=0.63 nf=1 m=1
XXc_13_13_XPG1 bl13 wl13 Xc_13_13.q vss sky130_fd_pr__nfet_01v8 L=0.15 W=0.42 nf=1 m=1
XXc_13_13_XPG2 blb13 wl13 Xc_13_13.qb vss sky130_fd_pr__nfet_01v8 L=0.15 W=0.42 nf=1 m=1
XXc_13_14_XPU1 Xc_13_14.q Xc_13_14.qb vdd vdd sky130_fd_pr__pfet_01v8 L=0.15 W=0.42 nf=1 m=1
XXc_13_14_XPD1 Xc_13_14.q Xc_13_14.qb vss vss sky130_fd_pr__nfet_01v8 L=0.15 W=0.63 nf=1 m=1
XXc_13_14_XPU2 Xc_13_14.qb Xc_13_14.q vdd vdd sky130_fd_pr__pfet_01v8 L=0.15 W=0.42 nf=1 m=1
XXc_13_14_XPD2 Xc_13_14.qb Xc_13_14.q vss vss sky130_fd_pr__nfet_01v8 L=0.15 W=0.63 nf=1 m=1
XXc_13_14_XPG1 bl14 wl13 Xc_13_14.q vss sky130_fd_pr__nfet_01v8 L=0.15 W=0.42 nf=1 m=1
XXc_13_14_XPG2 blb14 wl13 Xc_13_14.qb vss sky130_fd_pr__nfet_01v8 L=0.15 W=0.42 nf=1 m=1
XXc_13_15_XPU1 Xc_13_15.q Xc_13_15.qb vdd vdd sky130_fd_pr__pfet_01v8 L=0.15 W=0.42 nf=1 m=1
XXc_13_15_XPD1 Xc_13_15.q Xc_13_15.qb vss vss sky130_fd_pr__nfet_01v8 L=0.15 W=0.63 nf=1 m=1
XXc_13_15_XPU2 Xc_13_15.qb Xc_13_15.q vdd vdd sky130_fd_pr__pfet_01v8 L=0.15 W=0.42 nf=1 m=1
XXc_13_15_XPD2 Xc_13_15.qb Xc_13_15.q vss vss sky130_fd_pr__nfet_01v8 L=0.15 W=0.63 nf=1 m=1
XXc_13_15_XPG1 bl15 wl13 Xc_13_15.q vss sky130_fd_pr__nfet_01v8 L=0.15 W=0.42 nf=1 m=1
XXc_13_15_XPG2 blb15 wl13 Xc_13_15.qb vss sky130_fd_pr__nfet_01v8 L=0.15 W=0.42 nf=1 m=1
XXc_14_0_XPU1 Xc_14_0.q Xc_14_0.qb vdd vdd sky130_fd_pr__pfet_01v8 L=0.15 W=0.42 nf=1 m=1
XXc_14_0_XPD1 Xc_14_0.q Xc_14_0.qb vss vss sky130_fd_pr__nfet_01v8 L=0.15 W=0.63 nf=1 m=1
XXc_14_0_XPU2 Xc_14_0.qb Xc_14_0.q vdd vdd sky130_fd_pr__pfet_01v8 L=0.15 W=0.42 nf=1 m=1
XXc_14_0_XPD2 Xc_14_0.qb Xc_14_0.q vss vss sky130_fd_pr__nfet_01v8 L=0.15 W=0.63 nf=1 m=1
XXc_14_0_XPG1 bl0 wl14 Xc_14_0.q vss sky130_fd_pr__nfet_01v8 L=0.15 W=0.42 nf=1 m=1
XXc_14_0_XPG2 blb0 wl14 Xc_14_0.qb vss sky130_fd_pr__nfet_01v8 L=0.15 W=0.42 nf=1 m=1
XXc_14_1_XPU1 Xc_14_1.q Xc_14_1.qb vdd vdd sky130_fd_pr__pfet_01v8 L=0.15 W=0.42 nf=1 m=1
XXc_14_1_XPD1 Xc_14_1.q Xc_14_1.qb vss vss sky130_fd_pr__nfet_01v8 L=0.15 W=0.63 nf=1 m=1
XXc_14_1_XPU2 Xc_14_1.qb Xc_14_1.q vdd vdd sky130_fd_pr__pfet_01v8 L=0.15 W=0.42 nf=1 m=1
XXc_14_1_XPD2 Xc_14_1.qb Xc_14_1.q vss vss sky130_fd_pr__nfet_01v8 L=0.15 W=0.63 nf=1 m=1
XXc_14_1_XPG1 bl1 wl14 Xc_14_1.q vss sky130_fd_pr__nfet_01v8 L=0.15 W=0.42 nf=1 m=1
XXc_14_1_XPG2 blb1 wl14 Xc_14_1.qb vss sky130_fd_pr__nfet_01v8 L=0.15 W=0.42 nf=1 m=1
XXc_14_2_XPU1 Xc_14_2.q Xc_14_2.qb vdd vdd sky130_fd_pr__pfet_01v8 L=0.15 W=0.42 nf=1 m=1
XXc_14_2_XPD1 Xc_14_2.q Xc_14_2.qb vss vss sky130_fd_pr__nfet_01v8 L=0.15 W=0.63 nf=1 m=1
XXc_14_2_XPU2 Xc_14_2.qb Xc_14_2.q vdd vdd sky130_fd_pr__pfet_01v8 L=0.15 W=0.42 nf=1 m=1
XXc_14_2_XPD2 Xc_14_2.qb Xc_14_2.q vss vss sky130_fd_pr__nfet_01v8 L=0.15 W=0.63 nf=1 m=1
XXc_14_2_XPG1 bl2 wl14 Xc_14_2.q vss sky130_fd_pr__nfet_01v8 L=0.15 W=0.42 nf=1 m=1
XXc_14_2_XPG2 blb2 wl14 Xc_14_2.qb vss sky130_fd_pr__nfet_01v8 L=0.15 W=0.42 nf=1 m=1
XXc_14_3_XPU1 Xc_14_3.q Xc_14_3.qb vdd vdd sky130_fd_pr__pfet_01v8 L=0.15 W=0.42 nf=1 m=1
XXc_14_3_XPD1 Xc_14_3.q Xc_14_3.qb vss vss sky130_fd_pr__nfet_01v8 L=0.15 W=0.63 nf=1 m=1
XXc_14_3_XPU2 Xc_14_3.qb Xc_14_3.q vdd vdd sky130_fd_pr__pfet_01v8 L=0.15 W=0.42 nf=1 m=1
XXc_14_3_XPD2 Xc_14_3.qb Xc_14_3.q vss vss sky130_fd_pr__nfet_01v8 L=0.15 W=0.63 nf=1 m=1
XXc_14_3_XPG1 bl3 wl14 Xc_14_3.q vss sky130_fd_pr__nfet_01v8 L=0.15 W=0.42 nf=1 m=1
XXc_14_3_XPG2 blb3 wl14 Xc_14_3.qb vss sky130_fd_pr__nfet_01v8 L=0.15 W=0.42 nf=1 m=1
XXc_14_4_XPU1 Xc_14_4.q Xc_14_4.qb vdd vdd sky130_fd_pr__pfet_01v8 L=0.15 W=0.42 nf=1 m=1
XXc_14_4_XPD1 Xc_14_4.q Xc_14_4.qb vss vss sky130_fd_pr__nfet_01v8 L=0.15 W=0.63 nf=1 m=1
XXc_14_4_XPU2 Xc_14_4.qb Xc_14_4.q vdd vdd sky130_fd_pr__pfet_01v8 L=0.15 W=0.42 nf=1 m=1
XXc_14_4_XPD2 Xc_14_4.qb Xc_14_4.q vss vss sky130_fd_pr__nfet_01v8 L=0.15 W=0.63 nf=1 m=1
XXc_14_4_XPG1 bl4 wl14 Xc_14_4.q vss sky130_fd_pr__nfet_01v8 L=0.15 W=0.42 nf=1 m=1
XXc_14_4_XPG2 blb4 wl14 Xc_14_4.qb vss sky130_fd_pr__nfet_01v8 L=0.15 W=0.42 nf=1 m=1
XXc_14_5_XPU1 Xc_14_5.q Xc_14_5.qb vdd vdd sky130_fd_pr__pfet_01v8 L=0.15 W=0.42 nf=1 m=1
XXc_14_5_XPD1 Xc_14_5.q Xc_14_5.qb vss vss sky130_fd_pr__nfet_01v8 L=0.15 W=0.63 nf=1 m=1
XXc_14_5_XPU2 Xc_14_5.qb Xc_14_5.q vdd vdd sky130_fd_pr__pfet_01v8 L=0.15 W=0.42 nf=1 m=1
XXc_14_5_XPD2 Xc_14_5.qb Xc_14_5.q vss vss sky130_fd_pr__nfet_01v8 L=0.15 W=0.63 nf=1 m=1
XXc_14_5_XPG1 bl5 wl14 Xc_14_5.q vss sky130_fd_pr__nfet_01v8 L=0.15 W=0.42 nf=1 m=1
XXc_14_5_XPG2 blb5 wl14 Xc_14_5.qb vss sky130_fd_pr__nfet_01v8 L=0.15 W=0.42 nf=1 m=1
XXc_14_6_XPU1 Xc_14_6.q Xc_14_6.qb vdd vdd sky130_fd_pr__pfet_01v8 L=0.15 W=0.42 nf=1 m=1
XXc_14_6_XPD1 Xc_14_6.q Xc_14_6.qb vss vss sky130_fd_pr__nfet_01v8 L=0.15 W=0.63 nf=1 m=1
XXc_14_6_XPU2 Xc_14_6.qb Xc_14_6.q vdd vdd sky130_fd_pr__pfet_01v8 L=0.15 W=0.42 nf=1 m=1
XXc_14_6_XPD2 Xc_14_6.qb Xc_14_6.q vss vss sky130_fd_pr__nfet_01v8 L=0.15 W=0.63 nf=1 m=1
XXc_14_6_XPG1 bl6 wl14 Xc_14_6.q vss sky130_fd_pr__nfet_01v8 L=0.15 W=0.42 nf=1 m=1
XXc_14_6_XPG2 blb6 wl14 Xc_14_6.qb vss sky130_fd_pr__nfet_01v8 L=0.15 W=0.42 nf=1 m=1
XXc_14_7_XPU1 Xc_14_7.q Xc_14_7.qb vdd vdd sky130_fd_pr__pfet_01v8 L=0.15 W=0.42 nf=1 m=1
XXc_14_7_XPD1 Xc_14_7.q Xc_14_7.qb vss vss sky130_fd_pr__nfet_01v8 L=0.15 W=0.63 nf=1 m=1
XXc_14_7_XPU2 Xc_14_7.qb Xc_14_7.q vdd vdd sky130_fd_pr__pfet_01v8 L=0.15 W=0.42 nf=1 m=1
XXc_14_7_XPD2 Xc_14_7.qb Xc_14_7.q vss vss sky130_fd_pr__nfet_01v8 L=0.15 W=0.63 nf=1 m=1
XXc_14_7_XPG1 bl7 wl14 Xc_14_7.q vss sky130_fd_pr__nfet_01v8 L=0.15 W=0.42 nf=1 m=1
XXc_14_7_XPG2 blb7 wl14 Xc_14_7.qb vss sky130_fd_pr__nfet_01v8 L=0.15 W=0.42 nf=1 m=1
XXc_14_8_XPU1 Xc_14_8.q Xc_14_8.qb vdd vdd sky130_fd_pr__pfet_01v8 L=0.15 W=0.42 nf=1 m=1
XXc_14_8_XPD1 Xc_14_8.q Xc_14_8.qb vss vss sky130_fd_pr__nfet_01v8 L=0.15 W=0.63 nf=1 m=1
XXc_14_8_XPU2 Xc_14_8.qb Xc_14_8.q vdd vdd sky130_fd_pr__pfet_01v8 L=0.15 W=0.42 nf=1 m=1
XXc_14_8_XPD2 Xc_14_8.qb Xc_14_8.q vss vss sky130_fd_pr__nfet_01v8 L=0.15 W=0.63 nf=1 m=1
XXc_14_8_XPG1 bl8 wl14 Xc_14_8.q vss sky130_fd_pr__nfet_01v8 L=0.15 W=0.42 nf=1 m=1
XXc_14_8_XPG2 blb8 wl14 Xc_14_8.qb vss sky130_fd_pr__nfet_01v8 L=0.15 W=0.42 nf=1 m=1
XXc_14_9_XPU1 Xc_14_9.q Xc_14_9.qb vdd vdd sky130_fd_pr__pfet_01v8 L=0.15 W=0.42 nf=1 m=1
XXc_14_9_XPD1 Xc_14_9.q Xc_14_9.qb vss vss sky130_fd_pr__nfet_01v8 L=0.15 W=0.63 nf=1 m=1
XXc_14_9_XPU2 Xc_14_9.qb Xc_14_9.q vdd vdd sky130_fd_pr__pfet_01v8 L=0.15 W=0.42 nf=1 m=1
XXc_14_9_XPD2 Xc_14_9.qb Xc_14_9.q vss vss sky130_fd_pr__nfet_01v8 L=0.15 W=0.63 nf=1 m=1
XXc_14_9_XPG1 bl9 wl14 Xc_14_9.q vss sky130_fd_pr__nfet_01v8 L=0.15 W=0.42 nf=1 m=1
XXc_14_9_XPG2 blb9 wl14 Xc_14_9.qb vss sky130_fd_pr__nfet_01v8 L=0.15 W=0.42 nf=1 m=1
XXc_14_10_XPU1 Xc_14_10.q Xc_14_10.qb vdd vdd sky130_fd_pr__pfet_01v8 L=0.15 W=0.42 nf=1 m=1
XXc_14_10_XPD1 Xc_14_10.q Xc_14_10.qb vss vss sky130_fd_pr__nfet_01v8 L=0.15 W=0.63 nf=1 m=1
XXc_14_10_XPU2 Xc_14_10.qb Xc_14_10.q vdd vdd sky130_fd_pr__pfet_01v8 L=0.15 W=0.42 nf=1 m=1
XXc_14_10_XPD2 Xc_14_10.qb Xc_14_10.q vss vss sky130_fd_pr__nfet_01v8 L=0.15 W=0.63 nf=1 m=1
XXc_14_10_XPG1 bl10 wl14 Xc_14_10.q vss sky130_fd_pr__nfet_01v8 L=0.15 W=0.42 nf=1 m=1
XXc_14_10_XPG2 blb10 wl14 Xc_14_10.qb vss sky130_fd_pr__nfet_01v8 L=0.15 W=0.42 nf=1 m=1
XXc_14_11_XPU1 Xc_14_11.q Xc_14_11.qb vdd vdd sky130_fd_pr__pfet_01v8 L=0.15 W=0.42 nf=1 m=1
XXc_14_11_XPD1 Xc_14_11.q Xc_14_11.qb vss vss sky130_fd_pr__nfet_01v8 L=0.15 W=0.63 nf=1 m=1
XXc_14_11_XPU2 Xc_14_11.qb Xc_14_11.q vdd vdd sky130_fd_pr__pfet_01v8 L=0.15 W=0.42 nf=1 m=1
XXc_14_11_XPD2 Xc_14_11.qb Xc_14_11.q vss vss sky130_fd_pr__nfet_01v8 L=0.15 W=0.63 nf=1 m=1
XXc_14_11_XPG1 bl11 wl14 Xc_14_11.q vss sky130_fd_pr__nfet_01v8 L=0.15 W=0.42 nf=1 m=1
XXc_14_11_XPG2 blb11 wl14 Xc_14_11.qb vss sky130_fd_pr__nfet_01v8 L=0.15 W=0.42 nf=1 m=1
XXc_14_12_XPU1 Xc_14_12.q Xc_14_12.qb vdd vdd sky130_fd_pr__pfet_01v8 L=0.15 W=0.42 nf=1 m=1
XXc_14_12_XPD1 Xc_14_12.q Xc_14_12.qb vss vss sky130_fd_pr__nfet_01v8 L=0.15 W=0.63 nf=1 m=1
XXc_14_12_XPU2 Xc_14_12.qb Xc_14_12.q vdd vdd sky130_fd_pr__pfet_01v8 L=0.15 W=0.42 nf=1 m=1
XXc_14_12_XPD2 Xc_14_12.qb Xc_14_12.q vss vss sky130_fd_pr__nfet_01v8 L=0.15 W=0.63 nf=1 m=1
XXc_14_12_XPG1 bl12 wl14 Xc_14_12.q vss sky130_fd_pr__nfet_01v8 L=0.15 W=0.42 nf=1 m=1
XXc_14_12_XPG2 blb12 wl14 Xc_14_12.qb vss sky130_fd_pr__nfet_01v8 L=0.15 W=0.42 nf=1 m=1
XXc_14_13_XPU1 Xc_14_13.q Xc_14_13.qb vdd vdd sky130_fd_pr__pfet_01v8 L=0.15 W=0.42 nf=1 m=1
XXc_14_13_XPD1 Xc_14_13.q Xc_14_13.qb vss vss sky130_fd_pr__nfet_01v8 L=0.15 W=0.63 nf=1 m=1
XXc_14_13_XPU2 Xc_14_13.qb Xc_14_13.q vdd vdd sky130_fd_pr__pfet_01v8 L=0.15 W=0.42 nf=1 m=1
XXc_14_13_XPD2 Xc_14_13.qb Xc_14_13.q vss vss sky130_fd_pr__nfet_01v8 L=0.15 W=0.63 nf=1 m=1
XXc_14_13_XPG1 bl13 wl14 Xc_14_13.q vss sky130_fd_pr__nfet_01v8 L=0.15 W=0.42 nf=1 m=1
XXc_14_13_XPG2 blb13 wl14 Xc_14_13.qb vss sky130_fd_pr__nfet_01v8 L=0.15 W=0.42 nf=1 m=1
XXc_14_14_XPU1 Xc_14_14.q Xc_14_14.qb vdd vdd sky130_fd_pr__pfet_01v8 L=0.15 W=0.42 nf=1 m=1
XXc_14_14_XPD1 Xc_14_14.q Xc_14_14.qb vss vss sky130_fd_pr__nfet_01v8 L=0.15 W=0.63 nf=1 m=1
XXc_14_14_XPU2 Xc_14_14.qb Xc_14_14.q vdd vdd sky130_fd_pr__pfet_01v8 L=0.15 W=0.42 nf=1 m=1
XXc_14_14_XPD2 Xc_14_14.qb Xc_14_14.q vss vss sky130_fd_pr__nfet_01v8 L=0.15 W=0.63 nf=1 m=1
XXc_14_14_XPG1 bl14 wl14 Xc_14_14.q vss sky130_fd_pr__nfet_01v8 L=0.15 W=0.42 nf=1 m=1
XXc_14_14_XPG2 blb14 wl14 Xc_14_14.qb vss sky130_fd_pr__nfet_01v8 L=0.15 W=0.42 nf=1 m=1
XXc_14_15_XPU1 Xc_14_15.q Xc_14_15.qb vdd vdd sky130_fd_pr__pfet_01v8 L=0.15 W=0.42 nf=1 m=1
XXc_14_15_XPD1 Xc_14_15.q Xc_14_15.qb vss vss sky130_fd_pr__nfet_01v8 L=0.15 W=0.63 nf=1 m=1
XXc_14_15_XPU2 Xc_14_15.qb Xc_14_15.q vdd vdd sky130_fd_pr__pfet_01v8 L=0.15 W=0.42 nf=1 m=1
XXc_14_15_XPD2 Xc_14_15.qb Xc_14_15.q vss vss sky130_fd_pr__nfet_01v8 L=0.15 W=0.63 nf=1 m=1
XXc_14_15_XPG1 bl15 wl14 Xc_14_15.q vss sky130_fd_pr__nfet_01v8 L=0.15 W=0.42 nf=1 m=1
XXc_14_15_XPG2 blb15 wl14 Xc_14_15.qb vss sky130_fd_pr__nfet_01v8 L=0.15 W=0.42 nf=1 m=1
XXc_15_0_XPU1 Xc_15_0.q Xc_15_0.qb vdd vdd sky130_fd_pr__pfet_01v8 L=0.15 W=0.42 nf=1 m=1
XXc_15_0_XPD1 Xc_15_0.q Xc_15_0.qb vss vss sky130_fd_pr__nfet_01v8 L=0.15 W=0.63 nf=1 m=1
XXc_15_0_XPU2 Xc_15_0.qb Xc_15_0.q vdd vdd sky130_fd_pr__pfet_01v8 L=0.15 W=0.42 nf=1 m=1
XXc_15_0_XPD2 Xc_15_0.qb Xc_15_0.q vss vss sky130_fd_pr__nfet_01v8 L=0.15 W=0.63 nf=1 m=1
XXc_15_0_XPG1 bl0 wl15 Xc_15_0.q vss sky130_fd_pr__nfet_01v8 L=0.15 W=0.42 nf=1 m=1
XXc_15_0_XPG2 blb0 wl15 Xc_15_0.qb vss sky130_fd_pr__nfet_01v8 L=0.15 W=0.42 nf=1 m=1
XXc_15_1_XPU1 Xc_15_1.q Xc_15_1.qb vdd vdd sky130_fd_pr__pfet_01v8 L=0.15 W=0.42 nf=1 m=1
XXc_15_1_XPD1 Xc_15_1.q Xc_15_1.qb vss vss sky130_fd_pr__nfet_01v8 L=0.15 W=0.63 nf=1 m=1
XXc_15_1_XPU2 Xc_15_1.qb Xc_15_1.q vdd vdd sky130_fd_pr__pfet_01v8 L=0.15 W=0.42 nf=1 m=1
XXc_15_1_XPD2 Xc_15_1.qb Xc_15_1.q vss vss sky130_fd_pr__nfet_01v8 L=0.15 W=0.63 nf=1 m=1
XXc_15_1_XPG1 bl1 wl15 Xc_15_1.q vss sky130_fd_pr__nfet_01v8 L=0.15 W=0.42 nf=1 m=1
XXc_15_1_XPG2 blb1 wl15 Xc_15_1.qb vss sky130_fd_pr__nfet_01v8 L=0.15 W=0.42 nf=1 m=1
XXc_15_2_XPU1 Xc_15_2.q Xc_15_2.qb vdd vdd sky130_fd_pr__pfet_01v8 L=0.15 W=0.42 nf=1 m=1
XXc_15_2_XPD1 Xc_15_2.q Xc_15_2.qb vss vss sky130_fd_pr__nfet_01v8 L=0.15 W=0.63 nf=1 m=1
XXc_15_2_XPU2 Xc_15_2.qb Xc_15_2.q vdd vdd sky130_fd_pr__pfet_01v8 L=0.15 W=0.42 nf=1 m=1
XXc_15_2_XPD2 Xc_15_2.qb Xc_15_2.q vss vss sky130_fd_pr__nfet_01v8 L=0.15 W=0.63 nf=1 m=1
XXc_15_2_XPG1 bl2 wl15 Xc_15_2.q vss sky130_fd_pr__nfet_01v8 L=0.15 W=0.42 nf=1 m=1
XXc_15_2_XPG2 blb2 wl15 Xc_15_2.qb vss sky130_fd_pr__nfet_01v8 L=0.15 W=0.42 nf=1 m=1
XXc_15_3_XPU1 Xc_15_3.q Xc_15_3.qb vdd vdd sky130_fd_pr__pfet_01v8 L=0.15 W=0.42 nf=1 m=1
XXc_15_3_XPD1 Xc_15_3.q Xc_15_3.qb vss vss sky130_fd_pr__nfet_01v8 L=0.15 W=0.63 nf=1 m=1
XXc_15_3_XPU2 Xc_15_3.qb Xc_15_3.q vdd vdd sky130_fd_pr__pfet_01v8 L=0.15 W=0.42 nf=1 m=1
XXc_15_3_XPD2 Xc_15_3.qb Xc_15_3.q vss vss sky130_fd_pr__nfet_01v8 L=0.15 W=0.63 nf=1 m=1
XXc_15_3_XPG1 bl3 wl15 Xc_15_3.q vss sky130_fd_pr__nfet_01v8 L=0.15 W=0.42 nf=1 m=1
XXc_15_3_XPG2 blb3 wl15 Xc_15_3.qb vss sky130_fd_pr__nfet_01v8 L=0.15 W=0.42 nf=1 m=1
XXc_15_4_XPU1 Xc_15_4.q Xc_15_4.qb vdd vdd sky130_fd_pr__pfet_01v8 L=0.15 W=0.42 nf=1 m=1
XXc_15_4_XPD1 Xc_15_4.q Xc_15_4.qb vss vss sky130_fd_pr__nfet_01v8 L=0.15 W=0.63 nf=1 m=1
XXc_15_4_XPU2 Xc_15_4.qb Xc_15_4.q vdd vdd sky130_fd_pr__pfet_01v8 L=0.15 W=0.42 nf=1 m=1
XXc_15_4_XPD2 Xc_15_4.qb Xc_15_4.q vss vss sky130_fd_pr__nfet_01v8 L=0.15 W=0.63 nf=1 m=1
XXc_15_4_XPG1 bl4 wl15 Xc_15_4.q vss sky130_fd_pr__nfet_01v8 L=0.15 W=0.42 nf=1 m=1
XXc_15_4_XPG2 blb4 wl15 Xc_15_4.qb vss sky130_fd_pr__nfet_01v8 L=0.15 W=0.42 nf=1 m=1
XXc_15_5_XPU1 Xc_15_5.q Xc_15_5.qb vdd vdd sky130_fd_pr__pfet_01v8 L=0.15 W=0.42 nf=1 m=1
XXc_15_5_XPD1 Xc_15_5.q Xc_15_5.qb vss vss sky130_fd_pr__nfet_01v8 L=0.15 W=0.63 nf=1 m=1
XXc_15_5_XPU2 Xc_15_5.qb Xc_15_5.q vdd vdd sky130_fd_pr__pfet_01v8 L=0.15 W=0.42 nf=1 m=1
XXc_15_5_XPD2 Xc_15_5.qb Xc_15_5.q vss vss sky130_fd_pr__nfet_01v8 L=0.15 W=0.63 nf=1 m=1
XXc_15_5_XPG1 bl5 wl15 Xc_15_5.q vss sky130_fd_pr__nfet_01v8 L=0.15 W=0.42 nf=1 m=1
XXc_15_5_XPG2 blb5 wl15 Xc_15_5.qb vss sky130_fd_pr__nfet_01v8 L=0.15 W=0.42 nf=1 m=1
XXc_15_6_XPU1 Xc_15_6.q Xc_15_6.qb vdd vdd sky130_fd_pr__pfet_01v8 L=0.15 W=0.42 nf=1 m=1
XXc_15_6_XPD1 Xc_15_6.q Xc_15_6.qb vss vss sky130_fd_pr__nfet_01v8 L=0.15 W=0.63 nf=1 m=1
XXc_15_6_XPU2 Xc_15_6.qb Xc_15_6.q vdd vdd sky130_fd_pr__pfet_01v8 L=0.15 W=0.42 nf=1 m=1
XXc_15_6_XPD2 Xc_15_6.qb Xc_15_6.q vss vss sky130_fd_pr__nfet_01v8 L=0.15 W=0.63 nf=1 m=1
XXc_15_6_XPG1 bl6 wl15 Xc_15_6.q vss sky130_fd_pr__nfet_01v8 L=0.15 W=0.42 nf=1 m=1
XXc_15_6_XPG2 blb6 wl15 Xc_15_6.qb vss sky130_fd_pr__nfet_01v8 L=0.15 W=0.42 nf=1 m=1
XXc_15_7_XPU1 Xc_15_7.q Xc_15_7.qb vdd vdd sky130_fd_pr__pfet_01v8 L=0.15 W=0.42 nf=1 m=1
XXc_15_7_XPD1 Xc_15_7.q Xc_15_7.qb vss vss sky130_fd_pr__nfet_01v8 L=0.15 W=0.63 nf=1 m=1
XXc_15_7_XPU2 Xc_15_7.qb Xc_15_7.q vdd vdd sky130_fd_pr__pfet_01v8 L=0.15 W=0.42 nf=1 m=1
XXc_15_7_XPD2 Xc_15_7.qb Xc_15_7.q vss vss sky130_fd_pr__nfet_01v8 L=0.15 W=0.63 nf=1 m=1
XXc_15_7_XPG1 bl7 wl15 Xc_15_7.q vss sky130_fd_pr__nfet_01v8 L=0.15 W=0.42 nf=1 m=1
XXc_15_7_XPG2 blb7 wl15 Xc_15_7.qb vss sky130_fd_pr__nfet_01v8 L=0.15 W=0.42 nf=1 m=1
XXc_15_8_XPU1 Xc_15_8.q Xc_15_8.qb vdd vdd sky130_fd_pr__pfet_01v8 L=0.15 W=0.42 nf=1 m=1
XXc_15_8_XPD1 Xc_15_8.q Xc_15_8.qb vss vss sky130_fd_pr__nfet_01v8 L=0.15 W=0.63 nf=1 m=1
XXc_15_8_XPU2 Xc_15_8.qb Xc_15_8.q vdd vdd sky130_fd_pr__pfet_01v8 L=0.15 W=0.42 nf=1 m=1
XXc_15_8_XPD2 Xc_15_8.qb Xc_15_8.q vss vss sky130_fd_pr__nfet_01v8 L=0.15 W=0.63 nf=1 m=1
XXc_15_8_XPG1 bl8 wl15 Xc_15_8.q vss sky130_fd_pr__nfet_01v8 L=0.15 W=0.42 nf=1 m=1
XXc_15_8_XPG2 blb8 wl15 Xc_15_8.qb vss sky130_fd_pr__nfet_01v8 L=0.15 W=0.42 nf=1 m=1
XXc_15_9_XPU1 Xc_15_9.q Xc_15_9.qb vdd vdd sky130_fd_pr__pfet_01v8 L=0.15 W=0.42 nf=1 m=1
XXc_15_9_XPD1 Xc_15_9.q Xc_15_9.qb vss vss sky130_fd_pr__nfet_01v8 L=0.15 W=0.63 nf=1 m=1
XXc_15_9_XPU2 Xc_15_9.qb Xc_15_9.q vdd vdd sky130_fd_pr__pfet_01v8 L=0.15 W=0.42 nf=1 m=1
XXc_15_9_XPD2 Xc_15_9.qb Xc_15_9.q vss vss sky130_fd_pr__nfet_01v8 L=0.15 W=0.63 nf=1 m=1
XXc_15_9_XPG1 bl9 wl15 Xc_15_9.q vss sky130_fd_pr__nfet_01v8 L=0.15 W=0.42 nf=1 m=1
XXc_15_9_XPG2 blb9 wl15 Xc_15_9.qb vss sky130_fd_pr__nfet_01v8 L=0.15 W=0.42 nf=1 m=1
XXc_15_10_XPU1 Xc_15_10.q Xc_15_10.qb vdd vdd sky130_fd_pr__pfet_01v8 L=0.15 W=0.42 nf=1 m=1
XXc_15_10_XPD1 Xc_15_10.q Xc_15_10.qb vss vss sky130_fd_pr__nfet_01v8 L=0.15 W=0.63 nf=1 m=1
XXc_15_10_XPU2 Xc_15_10.qb Xc_15_10.q vdd vdd sky130_fd_pr__pfet_01v8 L=0.15 W=0.42 nf=1 m=1
XXc_15_10_XPD2 Xc_15_10.qb Xc_15_10.q vss vss sky130_fd_pr__nfet_01v8 L=0.15 W=0.63 nf=1 m=1
XXc_15_10_XPG1 bl10 wl15 Xc_15_10.q vss sky130_fd_pr__nfet_01v8 L=0.15 W=0.42 nf=1 m=1
XXc_15_10_XPG2 blb10 wl15 Xc_15_10.qb vss sky130_fd_pr__nfet_01v8 L=0.15 W=0.42 nf=1 m=1
XXc_15_11_XPU1 Xc_15_11.q Xc_15_11.qb vdd vdd sky130_fd_pr__pfet_01v8 L=0.15 W=0.42 nf=1 m=1
XXc_15_11_XPD1 Xc_15_11.q Xc_15_11.qb vss vss sky130_fd_pr__nfet_01v8 L=0.15 W=0.63 nf=1 m=1
XXc_15_11_XPU2 Xc_15_11.qb Xc_15_11.q vdd vdd sky130_fd_pr__pfet_01v8 L=0.15 W=0.42 nf=1 m=1
XXc_15_11_XPD2 Xc_15_11.qb Xc_15_11.q vss vss sky130_fd_pr__nfet_01v8 L=0.15 W=0.63 nf=1 m=1
XXc_15_11_XPG1 bl11 wl15 Xc_15_11.q vss sky130_fd_pr__nfet_01v8 L=0.15 W=0.42 nf=1 m=1
XXc_15_11_XPG2 blb11 wl15 Xc_15_11.qb vss sky130_fd_pr__nfet_01v8 L=0.15 W=0.42 nf=1 m=1
XXc_15_12_XPU1 Xc_15_12.q Xc_15_12.qb vdd vdd sky130_fd_pr__pfet_01v8 L=0.15 W=0.42 nf=1 m=1
XXc_15_12_XPD1 Xc_15_12.q Xc_15_12.qb vss vss sky130_fd_pr__nfet_01v8 L=0.15 W=0.63 nf=1 m=1
XXc_15_12_XPU2 Xc_15_12.qb Xc_15_12.q vdd vdd sky130_fd_pr__pfet_01v8 L=0.15 W=0.42 nf=1 m=1
XXc_15_12_XPD2 Xc_15_12.qb Xc_15_12.q vss vss sky130_fd_pr__nfet_01v8 L=0.15 W=0.63 nf=1 m=1
XXc_15_12_XPG1 bl12 wl15 Xc_15_12.q vss sky130_fd_pr__nfet_01v8 L=0.15 W=0.42 nf=1 m=1
XXc_15_12_XPG2 blb12 wl15 Xc_15_12.qb vss sky130_fd_pr__nfet_01v8 L=0.15 W=0.42 nf=1 m=1
XXc_15_13_XPU1 Xc_15_13.q Xc_15_13.qb vdd vdd sky130_fd_pr__pfet_01v8 L=0.15 W=0.42 nf=1 m=1
XXc_15_13_XPD1 Xc_15_13.q Xc_15_13.qb vss vss sky130_fd_pr__nfet_01v8 L=0.15 W=0.63 nf=1 m=1
XXc_15_13_XPU2 Xc_15_13.qb Xc_15_13.q vdd vdd sky130_fd_pr__pfet_01v8 L=0.15 W=0.42 nf=1 m=1
XXc_15_13_XPD2 Xc_15_13.qb Xc_15_13.q vss vss sky130_fd_pr__nfet_01v8 L=0.15 W=0.63 nf=1 m=1
XXc_15_13_XPG1 bl13 wl15 Xc_15_13.q vss sky130_fd_pr__nfet_01v8 L=0.15 W=0.42 nf=1 m=1
XXc_15_13_XPG2 blb13 wl15 Xc_15_13.qb vss sky130_fd_pr__nfet_01v8 L=0.15 W=0.42 nf=1 m=1
XXc_15_14_XPU1 Xc_15_14.q Xc_15_14.qb vdd vdd sky130_fd_pr__pfet_01v8 L=0.15 W=0.42 nf=1 m=1
XXc_15_14_XPD1 Xc_15_14.q Xc_15_14.qb vss vss sky130_fd_pr__nfet_01v8 L=0.15 W=0.63 nf=1 m=1
XXc_15_14_XPU2 Xc_15_14.qb Xc_15_14.q vdd vdd sky130_fd_pr__pfet_01v8 L=0.15 W=0.42 nf=1 m=1
XXc_15_14_XPD2 Xc_15_14.qb Xc_15_14.q vss vss sky130_fd_pr__nfet_01v8 L=0.15 W=0.63 nf=1 m=1
XXc_15_14_XPG1 bl14 wl15 Xc_15_14.q vss sky130_fd_pr__nfet_01v8 L=0.15 W=0.42 nf=1 m=1
XXc_15_14_XPG2 blb14 wl15 Xc_15_14.qb vss sky130_fd_pr__nfet_01v8 L=0.15 W=0.42 nf=1 m=1
XXc_15_15_XPU1 Xc_15_15.q Xc_15_15.qb vdd vdd sky130_fd_pr__pfet_01v8 L=0.15 W=0.42 nf=1 m=1
XXc_15_15_XPD1 Xc_15_15.q Xc_15_15.qb vss vss sky130_fd_pr__nfet_01v8 L=0.15 W=0.63 nf=1 m=1
XXc_15_15_XPU2 Xc_15_15.qb Xc_15_15.q vdd vdd sky130_fd_pr__pfet_01v8 L=0.15 W=0.42 nf=1 m=1
XXc_15_15_XPD2 Xc_15_15.qb Xc_15_15.q vss vss sky130_fd_pr__nfet_01v8 L=0.15 W=0.63 nf=1 m=1
XXc_15_15_XPG1 bl15 wl15 Xc_15_15.q vss sky130_fd_pr__nfet_01v8 L=0.15 W=0.42 nf=1 m=1
XXc_15_15_XPG2 blb15 wl15 Xc_15_15.qb vss sky130_fd_pr__nfet_01v8 L=0.15 W=0.42 nf=1 m=1
XXpre0_XP1 bl0 pcb vdd vdd sky130_fd_pr__pfet_01v8 L=0.15 W=0.84 nf=1 m=1
XXpre0_XP2 blb0 pcb vdd vdd sky130_fd_pr__pfet_01v8 L=0.15 W=0.84 nf=1 m=1
XXpre0_XP3 bl0 pcb blb0 vdd sky130_fd_pr__pfet_01v8 L=0.15 W=0.42 nf=1 m=1
XXmux0_XN1 bl0 csel0 dl vss sky130_fd_pr__nfet_01v8 L=0.15 W=0.84 nf=1 m=1
XXmux0_XN2 blb0 csel0 dlb vss sky130_fd_pr__nfet_01v8 L=0.15 W=0.84 nf=1 m=1
XXpre1_XP1 bl1 pcb vdd vdd sky130_fd_pr__pfet_01v8 L=0.15 W=0.84 nf=1 m=1
XXpre1_XP2 blb1 pcb vdd vdd sky130_fd_pr__pfet_01v8 L=0.15 W=0.84 nf=1 m=1
XXpre1_XP3 bl1 pcb blb1 vdd sky130_fd_pr__pfet_01v8 L=0.15 W=0.42 nf=1 m=1
XXmux1_XN1 bl1 csel1 dl vss sky130_fd_pr__nfet_01v8 L=0.15 W=0.84 nf=1 m=1
XXmux1_XN2 blb1 csel1 dlb vss sky130_fd_pr__nfet_01v8 L=0.15 W=0.84 nf=1 m=1
XXpre2_XP1 bl2 pcb vdd vdd sky130_fd_pr__pfet_01v8 L=0.15 W=0.84 nf=1 m=1
XXpre2_XP2 blb2 pcb vdd vdd sky130_fd_pr__pfet_01v8 L=0.15 W=0.84 nf=1 m=1
XXpre2_XP3 bl2 pcb blb2 vdd sky130_fd_pr__pfet_01v8 L=0.15 W=0.42 nf=1 m=1
XXmux2_XN1 bl2 csel2 dl vss sky130_fd_pr__nfet_01v8 L=0.15 W=0.84 nf=1 m=1
XXmux2_XN2 blb2 csel2 dlb vss sky130_fd_pr__nfet_01v8 L=0.15 W=0.84 nf=1 m=1
XXpre3_XP1 bl3 pcb vdd vdd sky130_fd_pr__pfet_01v8 L=0.15 W=0.84 nf=1 m=1
XXpre3_XP2 blb3 pcb vdd vdd sky130_fd_pr__pfet_01v8 L=0.15 W=0.84 nf=1 m=1
XXpre3_XP3 bl3 pcb blb3 vdd sky130_fd_pr__pfet_01v8 L=0.15 W=0.42 nf=1 m=1
XXmux3_XN1 bl3 csel3 dl vss sky130_fd_pr__nfet_01v8 L=0.15 W=0.84 nf=1 m=1
XXmux3_XN2 blb3 csel3 dlb vss sky130_fd_pr__nfet_01v8 L=0.15 W=0.84 nf=1 m=1
XXpre4_XP1 bl4 pcb vdd vdd sky130_fd_pr__pfet_01v8 L=0.15 W=0.84 nf=1 m=1
XXpre4_XP2 blb4 pcb vdd vdd sky130_fd_pr__pfet_01v8 L=0.15 W=0.84 nf=1 m=1
XXpre4_XP3 bl4 pcb blb4 vdd sky130_fd_pr__pfet_01v8 L=0.15 W=0.42 nf=1 m=1
XXmux4_XN1 bl4 csel4 dl vss sky130_fd_pr__nfet_01v8 L=0.15 W=0.84 nf=1 m=1
XXmux4_XN2 blb4 csel4 dlb vss sky130_fd_pr__nfet_01v8 L=0.15 W=0.84 nf=1 m=1
XXpre5_XP1 bl5 pcb vdd vdd sky130_fd_pr__pfet_01v8 L=0.15 W=0.84 nf=1 m=1
XXpre5_XP2 blb5 pcb vdd vdd sky130_fd_pr__pfet_01v8 L=0.15 W=0.84 nf=1 m=1
XXpre5_XP3 bl5 pcb blb5 vdd sky130_fd_pr__pfet_01v8 L=0.15 W=0.42 nf=1 m=1
XXmux5_XN1 bl5 csel5 dl vss sky130_fd_pr__nfet_01v8 L=0.15 W=0.84 nf=1 m=1
XXmux5_XN2 blb5 csel5 dlb vss sky130_fd_pr__nfet_01v8 L=0.15 W=0.84 nf=1 m=1
XXpre6_XP1 bl6 pcb vdd vdd sky130_fd_pr__pfet_01v8 L=0.15 W=0.84 nf=1 m=1
XXpre6_XP2 blb6 pcb vdd vdd sky130_fd_pr__pfet_01v8 L=0.15 W=0.84 nf=1 m=1
XXpre6_XP3 bl6 pcb blb6 vdd sky130_fd_pr__pfet_01v8 L=0.15 W=0.42 nf=1 m=1
XXmux6_XN1 bl6 csel6 dl vss sky130_fd_pr__nfet_01v8 L=0.15 W=0.84 nf=1 m=1
XXmux6_XN2 blb6 csel6 dlb vss sky130_fd_pr__nfet_01v8 L=0.15 W=0.84 nf=1 m=1
XXpre7_XP1 bl7 pcb vdd vdd sky130_fd_pr__pfet_01v8 L=0.15 W=0.84 nf=1 m=1
XXpre7_XP2 blb7 pcb vdd vdd sky130_fd_pr__pfet_01v8 L=0.15 W=0.84 nf=1 m=1
XXpre7_XP3 bl7 pcb blb7 vdd sky130_fd_pr__pfet_01v8 L=0.15 W=0.42 nf=1 m=1
XXmux7_XN1 bl7 csel7 dl vss sky130_fd_pr__nfet_01v8 L=0.15 W=0.84 nf=1 m=1
XXmux7_XN2 blb7 csel7 dlb vss sky130_fd_pr__nfet_01v8 L=0.15 W=0.84 nf=1 m=1
XXpre8_XP1 bl8 pcb vdd vdd sky130_fd_pr__pfet_01v8 L=0.15 W=0.84 nf=1 m=1
XXpre8_XP2 blb8 pcb vdd vdd sky130_fd_pr__pfet_01v8 L=0.15 W=0.84 nf=1 m=1
XXpre8_XP3 bl8 pcb blb8 vdd sky130_fd_pr__pfet_01v8 L=0.15 W=0.42 nf=1 m=1
XXmux8_XN1 bl8 csel8 dl vss sky130_fd_pr__nfet_01v8 L=0.15 W=0.84 nf=1 m=1
XXmux8_XN2 blb8 csel8 dlb vss sky130_fd_pr__nfet_01v8 L=0.15 W=0.84 nf=1 m=1
XXpre9_XP1 bl9 pcb vdd vdd sky130_fd_pr__pfet_01v8 L=0.15 W=0.84 nf=1 m=1
XXpre9_XP2 blb9 pcb vdd vdd sky130_fd_pr__pfet_01v8 L=0.15 W=0.84 nf=1 m=1
XXpre9_XP3 bl9 pcb blb9 vdd sky130_fd_pr__pfet_01v8 L=0.15 W=0.42 nf=1 m=1
XXmux9_XN1 bl9 csel9 dl vss sky130_fd_pr__nfet_01v8 L=0.15 W=0.84 nf=1 m=1
XXmux9_XN2 blb9 csel9 dlb vss sky130_fd_pr__nfet_01v8 L=0.15 W=0.84 nf=1 m=1
XXpre10_XP1 bl10 pcb vdd vdd sky130_fd_pr__pfet_01v8 L=0.15 W=0.84 nf=1 m=1
XXpre10_XP2 blb10 pcb vdd vdd sky130_fd_pr__pfet_01v8 L=0.15 W=0.84 nf=1 m=1
XXpre10_XP3 bl10 pcb blb10 vdd sky130_fd_pr__pfet_01v8 L=0.15 W=0.42 nf=1 m=1
XXmux10_XN1 bl10 csel10 dl vss sky130_fd_pr__nfet_01v8 L=0.15 W=0.84 nf=1 m=1
XXmux10_XN2 blb10 csel10 dlb vss sky130_fd_pr__nfet_01v8 L=0.15 W=0.84 nf=1 m=1
XXpre11_XP1 bl11 pcb vdd vdd sky130_fd_pr__pfet_01v8 L=0.15 W=0.84 nf=1 m=1
XXpre11_XP2 blb11 pcb vdd vdd sky130_fd_pr__pfet_01v8 L=0.15 W=0.84 nf=1 m=1
XXpre11_XP3 bl11 pcb blb11 vdd sky130_fd_pr__pfet_01v8 L=0.15 W=0.42 nf=1 m=1
XXmux11_XN1 bl11 csel11 dl vss sky130_fd_pr__nfet_01v8 L=0.15 W=0.84 nf=1 m=1
XXmux11_XN2 blb11 csel11 dlb vss sky130_fd_pr__nfet_01v8 L=0.15 W=0.84 nf=1 m=1
XXpre12_XP1 bl12 pcb vdd vdd sky130_fd_pr__pfet_01v8 L=0.15 W=0.84 nf=1 m=1
XXpre12_XP2 blb12 pcb vdd vdd sky130_fd_pr__pfet_01v8 L=0.15 W=0.84 nf=1 m=1
XXpre12_XP3 bl12 pcb blb12 vdd sky130_fd_pr__pfet_01v8 L=0.15 W=0.42 nf=1 m=1
XXmux12_XN1 bl12 csel12 dl vss sky130_fd_pr__nfet_01v8 L=0.15 W=0.84 nf=1 m=1
XXmux12_XN2 blb12 csel12 dlb vss sky130_fd_pr__nfet_01v8 L=0.15 W=0.84 nf=1 m=1
XXpre13_XP1 bl13 pcb vdd vdd sky130_fd_pr__pfet_01v8 L=0.15 W=0.84 nf=1 m=1
XXpre13_XP2 blb13 pcb vdd vdd sky130_fd_pr__pfet_01v8 L=0.15 W=0.84 nf=1 m=1
XXpre13_XP3 bl13 pcb blb13 vdd sky130_fd_pr__pfet_01v8 L=0.15 W=0.42 nf=1 m=1
XXmux13_XN1 bl13 csel13 dl vss sky130_fd_pr__nfet_01v8 L=0.15 W=0.84 nf=1 m=1
XXmux13_XN2 blb13 csel13 dlb vss sky130_fd_pr__nfet_01v8 L=0.15 W=0.84 nf=1 m=1
XXpre14_XP1 bl14 pcb vdd vdd sky130_fd_pr__pfet_01v8 L=0.15 W=0.84 nf=1 m=1
XXpre14_XP2 blb14 pcb vdd vdd sky130_fd_pr__pfet_01v8 L=0.15 W=0.84 nf=1 m=1
XXpre14_XP3 bl14 pcb blb14 vdd sky130_fd_pr__pfet_01v8 L=0.15 W=0.42 nf=1 m=1
XXmux14_XN1 bl14 csel14 dl vss sky130_fd_pr__nfet_01v8 L=0.15 W=0.84 nf=1 m=1
XXmux14_XN2 blb14 csel14 dlb vss sky130_fd_pr__nfet_01v8 L=0.15 W=0.84 nf=1 m=1
XXpre15_XP1 bl15 pcb vdd vdd sky130_fd_pr__pfet_01v8 L=0.15 W=0.84 nf=1 m=1
XXpre15_XP2 blb15 pcb vdd vdd sky130_fd_pr__pfet_01v8 L=0.15 W=0.84 nf=1 m=1
XXpre15_XP3 bl15 pcb blb15 vdd sky130_fd_pr__pfet_01v8 L=0.15 W=0.42 nf=1 m=1
XXmux15_XN1 bl15 csel15 dl vss sky130_fd_pr__nfet_01v8 L=0.15 W=0.84 nf=1 m=1
XXmux15_XN2 blb15 csel15 dlb vss sky130_fd_pr__nfet_01v8 L=0.15 W=0.84 nf=1 m=1
XXwe1_XP1 web rwq vdd vdd sky130_fd_pr__pfet_01v8 L=0.15 W=0.84 nf=1 m=1
XXwe1_XP2 web clkb vdd vdd sky130_fd_pr__pfet_01v8 L=0.15 W=0.84 nf=1 m=1
XXwe1_XN1 web rwq Xwe1.n1 vss sky130_fd_pr__nfet_01v8 L=0.15 W=0.84 nf=1 m=1
XXwe1_XN2 Xwe1.n1 clkb vss vss sky130_fd_pr__nfet_01v8 L=0.15 W=0.84 nf=1 m=1
XXwe2_XP we web vdd vdd sky130_fd_pr__pfet_01v8 L=0.15 W=2.52 nf=1 m=1
XXwe2_XN we web vss vss sky130_fd_pr__nfet_01v8 L=0.15 W=1.26 nf=1 m=1
XXrw_XPD1 dl pcb vdd vdd sky130_fd_pr__pfet_01v8 L=0.15 W=1.26 nf=1 m=1
XXrw_XPD2 dlb pcb vdd vdd sky130_fd_pr__pfet_01v8 L=0.15 W=1.26 nf=1 m=1
XXrw_XPE dl pcb dlb vdd sky130_fd_pr__pfet_01v8 L=0.15 W=0.42 nf=1 m=1
XXrw_XW1 dl we Xrw.w1 vss sky130_fd_pr__nfet_01v8 L=0.15 W=1.68 nf=1 m=1
XXrw_XW2 Xrw.w1 dinqb vss vss sky130_fd_pr__nfet_01v8 L=0.15 W=1.68 nf=1 m=1
XXrw_XW3 dlb we Xrw.w2 vss sky130_fd_pr__nfet_01v8 L=0.15 W=1.68 nf=1 m=1
XXrw_XW4 Xrw.w2 dinq vss vss sky130_fd_pr__nfet_01v8 L=0.15 W=1.68 nf=1 m=1
XXrw_XSA_XP rd dl vdd vdd sky130_fd_pr__pfet_01v8 L=0.15 W=1.26 nf=1 m=1
XXrw_XSA_XN rd dl vss vss sky130_fd_pr__nfet_01v8 L=0.15 W=0.42 nf=1 m=1
XXff_out_XCI_XP Xff_out.ckb clk_ff vdd vdd sky130_fd_pr__pfet_01v8 L=0.15 W=0.84 nf=1 m=1
XXff_out_XCI_XN Xff_out.ckb clk_ff vss vss sky130_fd_pr__nfet_01v8 L=0.15 W=0.42 nf=1 m=1
XXff_out_XCI2_XP Xff_out.ck Xff_out.ckb vdd vdd sky130_fd_pr__pfet_01v8 L=0.15 W=0.84 nf=1 m=1
XXff_out_XCI2_XN Xff_out.ck Xff_out.ckb vss vss sky130_fd_pr__nfet_01v8 L=0.15 W=0.42 nf=1 m=1
XXff_out_XT1N rd Xff_out.ckb Xff_out.m1 vss sky130_fd_pr__nfet_01v8 L=0.15 W=0.42 nf=1 m=1
XXff_out_XT1P rd Xff_out.ck Xff_out.m1 vdd sky130_fd_pr__pfet_01v8 L=0.15 W=0.42 nf=1 m=1
XXff_out_XM1_XP Xff_out.m2 Xff_out.m1 vdd vdd sky130_fd_pr__pfet_01v8 L=0.15 W=0.84 nf=1 m=1
XXff_out_XM1_XN Xff_out.m2 Xff_out.m1 vss vss sky130_fd_pr__nfet_01v8 L=0.15 W=0.42 nf=1 m=1
XXff_out_XM2_XP Xff_out.m3 Xff_out.m2 vdd vdd sky130_fd_pr__pfet_01v8 L=0.15 W=0.84 nf=1 m=1
XXff_out_XM2_XN Xff_out.m3 Xff_out.m2 vss vss sky130_fd_pr__nfet_01v8 L=0.15 W=0.42 nf=1 m=1
XXff_out_XT2N Xff_out.m3 Xff_out.ck Xff_out.m1 vss sky130_fd_pr__nfet_01v8 L=0.15 W=0.42 nf=1 m=1
XXff_out_XT2P Xff_out.m3 Xff_out.ckb Xff_out.m1 vdd sky130_fd_pr__pfet_01v8 L=0.15 W=0.42 nf=1 m=1
XXff_out_XT3N Xff_out.m2 Xff_out.ck Xff_out.s1 vss sky130_fd_pr__nfet_01v8 L=0.15 W=0.42 nf=1 m=1
XXff_out_XT3P Xff_out.m2 Xff_out.ckb Xff_out.s1 vdd sky130_fd_pr__pfet_01v8 L=0.15 W=0.42 nf=1 m=1
XXff_out_XS1_XP rdq Xff_out.s1 vdd vdd sky130_fd_pr__pfet_01v8 L=0.15 W=1.26 nf=1 m=1
XXff_out_XS1_XN rdq Xff_out.s1 vss vss sky130_fd_pr__nfet_01v8 L=0.15 W=0.63 nf=1 m=1
XXff_out_XS2_XP rdqb rdq vdd vdd sky130_fd_pr__pfet_01v8 L=0.15 W=0.84 nf=1 m=1
XXff_out_XS2_XN rdqb rdq vss vss sky130_fd_pr__nfet_01v8 L=0.15 W=0.42 nf=1 m=1
XXff_out_XT4N rdqb Xff_out.ckb Xff_out.s1 vss sky130_fd_pr__nfet_01v8 L=0.15 W=0.42 nf=1 m=1
XXff_out_XT4P rdqb Xff_out.ck Xff_out.s1 vdd sky130_fd_pr__pfet_01v8 L=0.15 W=0.42 nf=1 m=1
XXob_X1_XP Xob.n1 rdqb vddio vddio sky130_fd_pr__pfet_01v8 L=0.15 W=0.84 nf=1 m=1
XXob_X1_XN Xob.n1 rdqb vss vss sky130_fd_pr__nfet_01v8 L=0.15 W=0.42 nf=1 m=1
XXob_X2_XP Xob.n2 Xob.n1 vddio vddio sky130_fd_pr__pfet_01v8 L=0.15 W=3.36 nf=1 m=1
XXob_X2_XN Xob.n2 Xob.n1 vss vss sky130_fd_pr__nfet_01v8 L=0.15 W=1.68 nf=1 m=1
XXob_X3_XP Xob.n3 Xob.n2 vddio vddio sky130_fd_pr__pfet_01v8 L=0.15 W=13.44 nf=1 m=1
XXob_X3_XN Xob.n3 Xob.n2 vss vss sky130_fd_pr__nfet_01v8 L=0.15 W=6.72 nf=1 m=1
XXob_XP4_0 Xob.n4 Xob.n3 vddio vddio sky130_fd_pr__pfet_01v8 L=0.15 W=55.0 nf=1 m=1
XXob_XN4_0 Xob.n4 Xob.n3 vss vss sky130_fd_pr__nfet_01v8 L=0.15 W=27.0 nf=1 m=1
XXob_XP5_0 Xob.n5 Xob.n4 vddio vddio sky130_fd_pr__pfet_01v8 L=0.15 W=71.67 nf=1 m=1
XXob_XP5_1 Xob.n5 Xob.n4 vddio vddio sky130_fd_pr__pfet_01v8 L=0.15 W=71.67 nf=1 m=1
XXob_XP5_2 Xob.n5 Xob.n4 vddio vddio sky130_fd_pr__pfet_01v8 L=0.15 W=71.67 nf=1 m=1
XXob_XN5_0 Xob.n5 Xob.n4 vss vss sky130_fd_pr__nfet_01v8 L=0.15 W=54.0 nf=1 m=1
XXob_XN5_1 Xob.n5 Xob.n4 vss vss sky130_fd_pr__nfet_01v8 L=0.15 W=54.0 nf=1 m=1
XXob_XP6_0 Xob.yd Xob.n5 vddio vddio sky130_fd_pr__pfet_01v8 L=0.15 W=86.0 nf=1 m=1
XXob_XP6_1 Xob.yd Xob.n5 vddio vddio sky130_fd_pr__pfet_01v8 L=0.15 W=86.0 nf=1 m=1
XXob_XP6_2 Xob.yd Xob.n5 vddio vddio sky130_fd_pr__pfet_01v8 L=0.15 W=86.0 nf=1 m=1
XXob_XP6_3 Xob.yd Xob.n5 vddio vddio sky130_fd_pr__pfet_01v8 L=0.15 W=86.0 nf=1 m=1
XXob_XP6_4 Xob.yd Xob.n5 vddio vddio sky130_fd_pr__pfet_01v8 L=0.15 W=86.0 nf=1 m=1
XXob_XP6_5 Xob.yd Xob.n5 vddio vddio sky130_fd_pr__pfet_01v8 L=0.15 W=86.0 nf=1 m=1
XXob_XP6_6 Xob.yd Xob.n5 vddio vddio sky130_fd_pr__pfet_01v8 L=0.15 W=86.0 nf=1 m=1
XXob_XP6_7 Xob.yd Xob.n5 vddio vddio sky130_fd_pr__pfet_01v8 L=0.15 W=86.0 nf=1 m=1
XXob_XP6_8 Xob.yd Xob.n5 vddio vddio sky130_fd_pr__pfet_01v8 L=0.15 W=86.0 nf=1 m=1
XXob_XP6_9 Xob.yd Xob.n5 vddio vddio sky130_fd_pr__pfet_01v8 L=0.15 W=86.0 nf=1 m=1
XXob_XN6_0 Xob.yd Xob.n5 vss vss sky130_fd_pr__nfet_01v8 L=0.15 W=86.0 nf=1 m=1
XXob_XN6_1 Xob.yd Xob.n5 vss vss sky130_fd_pr__nfet_01v8 L=0.15 W=86.0 nf=1 m=1
XXob_XN6_2 Xob.yd Xob.n5 vss vss sky130_fd_pr__nfet_01v8 L=0.15 W=86.0 nf=1 m=1
XXob_XN6_3 Xob.yd Xob.n5 vss vss sky130_fd_pr__nfet_01v8 L=0.15 W=86.0 nf=1 m=1
XXob_XN6_4 Xob.yd Xob.n5 vss vss sky130_fd_pr__nfet_01v8 L=0.15 W=86.0 nf=1 m=1
RXob_Rterm Xob.yd dout_pad 20
.ends
