.subckt inbuf pad y vdd vss
XX1_XP n1 pad vdd vdd sky130_fd_pr__pfet_01v8 L=0.15 W=1.68 nf=1 m=1
XX1_XN n1 pad vss vss sky130_fd_pr__nfet_01v8 L=0.15 W=0.84 nf=1 m=1
XX2_XP y n1 vdd vdd sky130_fd_pr__pfet_01v8 L=0.15 W=3.36 nf=1 m=1
XX2_XN y n1 vss vss sky130_fd_pr__nfet_01v8 L=0.15 W=1.68 nf=1 m=1
.ends
