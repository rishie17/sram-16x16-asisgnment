** sch_path: /foss/designs/sram/xschem/tb_bitcell.sch
**.subckt tb_bitcell
xcell bl blb wl vdd 0 bitcell
xpre bl blb pcb vdd precharge
XMw0 bl w0 0 0 sky130_fd_pr__nfet_01v8 L=0.15 W=1.68 nf=1 ad=0.4872 as=0.4872 pd=3.94 ps=3.94 nrd=0.172619047619048
+ nrs=0.172619047619048 sa=0 sb=0 sd=0 mult=1
XMw1 blb w1 0 0 sky130_fd_pr__nfet_01v8 L=0.15 W=1.68 nf=1 ad=0.4872 as=0.4872 pd=3.94 ps=3.94 nrd=0.172619047619048
+ nrs=0.172619047619048 sa=0 sb=0 sd=0 mult=1
Cbl bl 0 50f
Cblb blb 0 50f
Vvdd vdd 0 1.8
Vpcb pcb 0 PWL(0 0 1n 0 1.1n 1.8 3n 1.8 3.1n 0 4n 0 4.1n 1.8 6n 1.8 6.1n 0 7n 0 7.1n 1.8 9n 1.8 9.1n 0 10n 0 10.1n 1.8 12n 1.8
+ 12.1n 0)
Vwl wl 0 PWL(0 0 1.2n 0 1.3n 1.8 2.8n 1.8 2.9n 0 4.2n 0 4.3n 1.8 5.8n 1.8 5.9n 0 7.2n 0 7.3n 1.8 8.8n 1.8 8.9n 0 10.2n 0 10.3n 1.8
+ 11.8n 1.8 11.9n 0)
Vw0 w0 0 PWL(0 0 1.2n 0 1.3n 1.8 2.8n 1.8 2.9n 0)
Vw1 w1 0 PWL(0 0 7.2n 0 7.3n 1.8 8.8n 1.8 8.9n 0)
**** begin user architecture code

.lib /foss/pdks/sky130A/libs.tech/ngspice/sky130.lib.spice tt
.ic v(xcell.q)=1.8 v(xcell.qb)=0
.tran 10p 12n
.control
run
set wr_singlescale
set wr_vecnames
wrdata tb_bitcell.dat v(xcell.q) v(xcell.qb) v(bl) v(blb) v(wl) v(pcb)
.endc

**** end user architecture code
**.ends

* expanding   symbol:  bitcell.sym # of pins=5
** sym_path: /foss/designs/sram/xschem/bitcell.sym
** sch_path: /foss/designs/sram/xschem/bitcell.sch
.subckt bitcell bl blb wl vdd vss
*.iopin bl
*.iopin blb
*.iopin wl
*.iopin vdd
*.iopin vss
XMPU1 q qb vdd vdd sky130_fd_pr__pfet_01v8 L=0.15 W=0.42 nf=1 ad=0.1218 as=0.1218 pd=1.42 ps=1.42 nrd=0.69047619047619
+ nrs=0.69047619047619 sa=0 sb=0 sd=0 mult=1
XMPD1 q qb vss vss sky130_fd_pr__nfet_01v8 L=0.15 W=0.63 nf=1 ad=0.1827 as=0.1827 pd=1.84 ps=1.84 nrd=0.46031746031746
+ nrs=0.46031746031746 sa=0 sb=0 sd=0 mult=1
XMPU2 qb q vdd vdd sky130_fd_pr__pfet_01v8 L=0.15 W=0.42 nf=1 ad=0.1218 as=0.1218 pd=1.42 ps=1.42 nrd=0.69047619047619
+ nrs=0.69047619047619 sa=0 sb=0 sd=0 mult=1
XMPD2 qb q vss vss sky130_fd_pr__nfet_01v8 L=0.15 W=0.63 nf=1 ad=0.1827 as=0.1827 pd=1.84 ps=1.84 nrd=0.46031746031746
+ nrs=0.46031746031746 sa=0 sb=0 sd=0 mult=1
XMPG1 bl wl q vss sky130_fd_pr__nfet_01v8 L=0.15 W=0.42 nf=1 ad=0.1218 as=0.1218 pd=1.42 ps=1.42 nrd=0.69047619047619
+ nrs=0.69047619047619 sa=0 sb=0 sd=0 mult=1
XMPG2 blb wl qb vss sky130_fd_pr__nfet_01v8 L=0.15 W=0.42 nf=1 ad=0.1218 as=0.1218 pd=1.42 ps=1.42 nrd=0.69047619047619
+ nrs=0.69047619047619 sa=0 sb=0 sd=0 mult=1
.ends

* expanding   symbol:  precharge.sym # of pins=4
** sym_path: /foss/designs/sram/xschem/precharge.sym
** sch_path: /foss/designs/sram/xschem/precharge.sch
.subckt precharge bl blb pcb vdd
*.iopin bl
*.iopin blb
*.iopin pcb
*.iopin vdd
XMP1 bl pcb vdd vdd sky130_fd_pr__pfet_01v8 L=0.15 W=0.84 nf=1 ad=0.2436 as=0.2436 pd=2.26 ps=2.26 nrd=0.345238095238095
+ nrs=0.345238095238095 sa=0 sb=0 sd=0 mult=1
XMP2 blb pcb vdd vdd sky130_fd_pr__pfet_01v8 L=0.15 W=0.84 nf=1 ad=0.2436 as=0.2436 pd=2.26 ps=2.26 nrd=0.345238095238095
+ nrs=0.345238095238095 sa=0 sb=0 sd=0 mult=1
XMP3 bl pcb blb vdd sky130_fd_pr__pfet_01v8 L=0.15 W=0.42 nf=1 ad=0.1218 as=0.1218 pd=1.42 ps=1.42 nrd=0.69047619047619
+ nrs=0.69047619047619 sa=0 sb=0 sd=0 mult=1
.ends

.end
