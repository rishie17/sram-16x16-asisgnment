** sch_path: /foss/designs/sram/xschem/inv_wn2p52_wp5p04.sch
.subckt inv_wn2p52_wp5p04 a y vdd vss
*.PININFO a:B y:B vdd:B vss:B
XMP y a vdd vdd sky130_fd_pr__pfet_01v8 L=0.15 W=5.04 nf=1
XMN y a vss vss sky130_fd_pr__nfet_01v8 L=0.15 W=2.52 nf=1
.ends
