** sch_path: /foss/designs/sram/xschem/nand3.sch
.subckt nand3 a b c y vdd vss
*.PININFO a:B b:B c:B y:B vdd:B vss:B
XMP1 y a vdd vdd sky130_fd_pr__pfet_01v8 L=0.15 W=0.84 nf=1
XMP2 y b vdd vdd sky130_fd_pr__pfet_01v8 L=0.15 W=0.84 nf=1
XMP3 y c vdd vdd sky130_fd_pr__pfet_01v8 L=0.15 W=0.84 nf=1
XMN1 y a n1 vss sky130_fd_pr__nfet_01v8 L=0.15 W=1.26 nf=1
XMN2 n1 b n2 vss sky130_fd_pr__nfet_01v8 L=0.15 W=1.26 nf=1
XMN3 n2 c vss vss sky130_fd_pr__nfet_01v8 L=0.15 W=1.26 nf=1
.ends
