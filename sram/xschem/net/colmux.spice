** sch_path: /foss/designs/sram/xschem/colmux.sch
.subckt colmux bl blb dl dlb csel vss
*.PININFO bl:B blb:B dl:B dlb:B csel:B vss:B
XMN1 bl csel dl vss sky130_fd_pr__nfet_01v8 L=0.15 W=0.84 nf=1
XMN2 blb csel dlb vss sky130_fd_pr__nfet_01v8 L=0.15 W=0.84 nf=1
.ends
