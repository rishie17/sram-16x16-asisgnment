** sch_path: /foss/designs/sram/xschem/bitcell.sch
.subckt bitcell bl blb wl vdd vss
*.PININFO bl:B blb:B wl:B vdd:B vss:B
XMPU1 q qb vdd vdd sky130_fd_pr__pfet_01v8 L=0.15 W=0.42 nf=1
XMPD1 q qb vss vss sky130_fd_pr__nfet_01v8 L=0.15 W=0.63 nf=1
XMPU2 qb q vdd vdd sky130_fd_pr__pfet_01v8 L=0.15 W=0.42 nf=1
XMPD2 qb q vss vss sky130_fd_pr__nfet_01v8 L=0.15 W=0.63 nf=1
XMPG1 bl wl q vss sky130_fd_pr__nfet_01v8 L=0.15 W=0.42 nf=1
XMPG2 blb wl qb vss sky130_fd_pr__nfet_01v8 L=0.15 W=0.42 nf=1
.ends
