** sch_path: /foss/designs/sram/xschem/rwckt.sch
.subckt rwckt dl dlb we din dinb pcb rd vdd vss
*.PININFO dl:B dlb:B we:B din:B dinb:B pcb:B rd:B vdd:B vss:B
XMPD1 dl pcb vdd vdd sky130_fd_pr__pfet_01v8 L=0.15 W=1.26 nf=1
XMPD2 dlb pcb vdd vdd sky130_fd_pr__pfet_01v8 L=0.15 W=1.26 nf=1
XMPE dl pcb dlb vdd sky130_fd_pr__pfet_01v8 L=0.15 W=0.42 nf=1
XMW1 dl we w1 vss sky130_fd_pr__nfet_01v8 L=0.15 W=1.68 nf=1
XMW2 w1 dinb vss vss sky130_fd_pr__nfet_01v8 L=0.15 W=1.68 nf=1
XMW3 dlb we w2 vss sky130_fd_pr__nfet_01v8 L=0.15 W=1.68 nf=1
XMW4 w2 din vss vss sky130_fd_pr__nfet_01v8 L=0.15 W=1.68 nf=1
XSA dl rd vdd vss inv_wp1p26
.ends

* expanding   symbol:  inv_wp1p26.sym # of pins=4
** sym_path: /foss/designs/sram/xschem/inv_wp1p26.sym
** sch_path: /foss/designs/sram/xschem/inv_wp1p26.sch
.subckt inv_wp1p26 a y vdd vss
*.PININFO a:B y:B vdd:B vss:B
XMP y a vdd vdd sky130_fd_pr__pfet_01v8 L=0.15 W=1.26 nf=1
XMN y a vss vss sky130_fd_pr__nfet_01v8 L=0.15 W=0.42 nf=1
.ends
