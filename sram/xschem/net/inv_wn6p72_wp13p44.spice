** sch_path: /foss/designs/sram/xschem/inv_wn6p72_wp13p44.sch
.subckt inv_wn6p72_wp13p44 a y vdd vss
*.PININFO a:B y:B vdd:B vss:B
XMP y a vdd vdd sky130_fd_pr__pfet_01v8 L=0.15 W=13.44 nf=1
XMN y a vss vss sky130_fd_pr__nfet_01v8 L=0.15 W=6.72 nf=1
.ends
