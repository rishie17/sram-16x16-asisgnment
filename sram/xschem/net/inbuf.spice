** sch_path: /foss/designs/sram/xschem/inbuf.sch
.subckt inbuf pad y vdd vss
*.PININFO pad:B y:B vdd:B vss:B
X1 pad n1 vdd vss inv_wn0p84_wp1p68
X2 n1 y vdd vss inv_wn1p68_wp3p36
.ends

* expanding   symbol:  inv_wn0p84_wp1p68.sym # of pins=4
** sym_path: /foss/designs/sram/xschem/inv_wn0p84_wp1p68.sym
** sch_path: /foss/designs/sram/xschem/inv_wn0p84_wp1p68.sch
.subckt inv_wn0p84_wp1p68 a y vdd vss
*.PININFO a:B y:B vdd:B vss:B
XMP y a vdd vdd sky130_fd_pr__pfet_01v8 L=0.15 W=1.68 nf=1
XMN y a vss vss sky130_fd_pr__nfet_01v8 L=0.15 W=0.84 nf=1
.ends

* expanding   symbol:  inv_wn1p68_wp3p36.sym # of pins=4
** sym_path: /foss/designs/sram/xschem/inv_wn1p68_wp3p36.sym
** sch_path: /foss/designs/sram/xschem/inv_wn1p68_wp3p36.sch
.subckt inv_wn1p68_wp3p36 a y vdd vss
*.PININFO a:B y:B vdd:B vss:B
XMP y a vdd vdd sky130_fd_pr__pfet_01v8 L=0.15 W=3.36 nf=1
XMN y a vss vss sky130_fd_pr__nfet_01v8 L=0.15 W=1.68 nf=1
.ends
