** sch_path: /foss/designs/sram/xschem/nand2.sch
.subckt nand2 a b y vdd vss
*.PININFO a:B b:B y:B vdd:B vss:B
XMP1 y a vdd vdd sky130_fd_pr__pfet_01v8 L=0.15 W=0.84 nf=1
XMP2 y b vdd vdd sky130_fd_pr__pfet_01v8 L=0.15 W=0.84 nf=1
XMN1 y a n1 vss sky130_fd_pr__nfet_01v8 L=0.15 W=0.84 nf=1
XMN2 n1 b vss vss sky130_fd_pr__nfet_01v8 L=0.15 W=0.84 nf=1
.ends
