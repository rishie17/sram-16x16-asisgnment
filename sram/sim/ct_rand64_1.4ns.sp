* SRAM256 testbench: rand64, T=1.400 ns
.lib /foss/pdks/sky130A/libs.tech/ngspice/sky130.lib.spice tt
.include /foss/designs/sram/cells/cells.sp
* ===== 256x1 SRAM core + I/O (generated by gen_sram.py) =====
.subckt sram256 CLK ADDR RW DIN DOUT vdd vddio vss
Xpad_CLK CLK clk_pad vddio vss bondpad
Xib_CLK clk_pad clk_in vdd vss inbuf
Xpad_ADDR ADDR addr_pad vddio vss bondpad
Xib_ADDR addr_pad addr_in vdd vss inbuf
Xpad_RW RW rw_pad vddio vss bondpad
Xib_RW rw_pad rw_in vdd vss inbuf
Xpad_DIN DIN din_pad vddio vss bondpad
Xib_DIN din_pad din_in vdd vss inbuf
Xpad_DOUT DOUT dout_pad vddio vss bondpad
* --- clock distribution: root buffer + 3 balanced branches
Xck_r1 clk_in ckr_b vdd vss inv wn=1.68 wp=3.36
Xck_r2 ckr_b ckr vdd vss inv wn=3.36 wp=6.72
Xck_a1 ckr cka_b vdd vss inv wn=0.84 wp=1.68
Xck_a2 cka_b clk_ff vdd vss inv wn=1.68 wp=3.36
Xck_b1 ckr ckb1 vdd vss inv wn=0.84 wp=1.68
Xck_b2 ckb1 ckb2 vdd vss inv wn=1.26 wp=2.52
Xck_b3 ckb2 clkb vdd vss inv wn=2.52 wp=5.04
Xck_d1 ckr d1 vdd vss inv
Xck_d2 d1 d2 vdd vss inv
Xck_d3 d2 d3 vdd vss inv
Xck_d4 d3 d4 vdd vss inv
Xck_d5 d4 d5 vdd vss inv
Xck_d6 d5 d6 vdd vss inv
Xck_d7 d6 d7 vdd vss inv
Xck_d8 d7 ckd vdd vss inv
Xck_c1 ckr ckd pc0 vdd vss nand2 wn=1.68 wp=1.68
Xck_c2 pc0 pc1 vdd vss inv wn=0.84 wp=1.68
Xck_c3 pc1 pcb vdd vss inv wn=2.52 wp=5.04
* --- serial address shift register (a0 = newest bit, a7 = oldest = MSB)
Xff_a0 addr_in clk_ff_s1 a0 ab0 vdd vss dff
Xff_a1 a0 clk_ff_s2 a1 ab1 vdd vss dff
Xff_a2 a1 clk_ff_s3 a2 ab2 vdd vss dff
Xff_a3 a2 clk_ff_s4 a3 ab3 vdd vss dff
Xff_a4 a3 clk_ff_s5 a4 ab4 vdd vss dff
Xff_a5 a4 clk_ff_s6 a5 ab5 vdd vss dff
Xff_a6 a5 clk_ff_s7 a6 ab6 vdd vss dff
Xff_a7 a6 clk_ff_s8 a7 ab7 vdd vss dff
Xff_rw rw_in clk_ff_s9 rwq rwqb vdd vss dff
Xff_din din_in clk_ff_s10 dinq dinqb vdd vss dff
Xpd_rh0 ab7 ab6 rhb0 vdd vss nand2
Xpi_rh0 rhb0 rh0 vdd vss inv wn=0.84 wp=1.68
Xpd_rh1 ab7 a6 rhb1 vdd vss nand2
Xpi_rh1 rhb1 rh1 vdd vss inv wn=0.84 wp=1.68
Xpd_rh2 a7 ab6 rhb2 vdd vss nand2
Xpi_rh2 rhb2 rh2 vdd vss inv wn=0.84 wp=1.68
Xpd_rh3 a7 a6 rhb3 vdd vss nand2
Xpi_rh3 rhb3 rh3 vdd vss inv wn=0.84 wp=1.68
Xpd_rl0 ab5 ab4 rlb0 vdd vss nand2
Xpi_rl0 rlb0 rl0 vdd vss inv wn=0.84 wp=1.68
Xpd_rl1 ab5 a4 rlb1 vdd vss nand2
Xpi_rl1 rlb1 rl1 vdd vss inv wn=0.84 wp=1.68
Xpd_rl2 a5 ab4 rlb2 vdd vss nand2
Xpi_rl2 rlb2 rl2 vdd vss inv wn=0.84 wp=1.68
Xpd_rl3 a5 a4 rlb3 vdd vss nand2
Xpi_rl3 rlb3 rl3 vdd vss inv wn=0.84 wp=1.68
Xpd_ch0 ab3 ab2 chb0 vdd vss nand2
Xpi_ch0 chb0 ch0 vdd vss inv wn=0.84 wp=1.68
Xpd_ch1 ab3 a2 chb1 vdd vss nand2
Xpi_ch1 chb1 ch1 vdd vss inv wn=0.84 wp=1.68
Xpd_ch2 a3 ab2 chb2 vdd vss nand2
Xpi_ch2 chb2 ch2 vdd vss inv wn=0.84 wp=1.68
Xpd_ch3 a3 a2 chb3 vdd vss nand2
Xpi_ch3 chb3 ch3 vdd vss inv wn=0.84 wp=1.68
Xpd_cl0 ab1 ab0 clb0 vdd vss nand2
Xpi_cl0 clb0 cl0 vdd vss inv wn=0.84 wp=1.68
Xpd_cl1 ab1 a0 clb1 vdd vss nand2
Xpi_cl1 clb1 cl1 vdd vss inv wn=0.84 wp=1.68
Xpd_cl2 a1 ab0 clb2 vdd vss nand2
Xpi_cl2 clb2 cl2 vdd vss inv wn=0.84 wp=1.68
Xpd_cl3 a1 a0 clb3 vdd vss nand2
Xpi_cl3 clb3 cl3 vdd vss inv wn=0.84 wp=1.68
* --- row decoder: WL_r = rh & rl & clkb
Xrd0 rh0 rl0 clkb_s0 wlb0 vdd vss nand3
Xwd0 wlb0 wl0 vdd vss inv wn=0.84 wp=1.68
Cwl0 wl0 vss 4f
Xrd1 rh0 rl1 clkb_s1 wlb1 vdd vss nand3
Xwd1 wlb1 wl1 vdd vss inv wn=0.84 wp=1.68
Cwl1 wl1 vss 4f
Xrd2 rh0 rl2 clkb_s2 wlb2 vdd vss nand3
Xwd2 wlb2 wl2 vdd vss inv wn=0.84 wp=1.68
Cwl2 wl2 vss 4f
Xrd3 rh0 rl3 clkb_s3 wlb3 vdd vss nand3
Xwd3 wlb3 wl3 vdd vss inv wn=0.84 wp=1.68
Cwl3 wl3 vss 4f
Xrd4 rh1 rl0 clkb_s4 wlb4 vdd vss nand3
Xwd4 wlb4 wl4 vdd vss inv wn=0.84 wp=1.68
Cwl4 wl4 vss 4f
Xrd5 rh1 rl1 clkb_s5 wlb5 vdd vss nand3
Xwd5 wlb5 wl5 vdd vss inv wn=0.84 wp=1.68
Cwl5 wl5 vss 4f
Xrd6 rh1 rl2 clkb_s6 wlb6 vdd vss nand3
Xwd6 wlb6 wl6 vdd vss inv wn=0.84 wp=1.68
Cwl6 wl6 vss 4f
Xrd7 rh1 rl3 clkb_s7 wlb7 vdd vss nand3
Xwd7 wlb7 wl7 vdd vss inv wn=0.84 wp=1.68
Cwl7 wl7 vss 4f
Xrd8 rh2 rl0 clkb_s8 wlb8 vdd vss nand3
Xwd8 wlb8 wl8 vdd vss inv wn=0.84 wp=1.68
Cwl8 wl8 vss 4f
Xrd9 rh2 rl1 clkb_s9 wlb9 vdd vss nand3
Xwd9 wlb9 wl9 vdd vss inv wn=0.84 wp=1.68
Cwl9 wl9 vss 4f
Xrd10 rh2 rl2 clkb_s10 wlb10 vdd vss nand3
Xwd10 wlb10 wl10 vdd vss inv wn=0.84 wp=1.68
Cwl10 wl10 vss 4f
Xrd11 rh2 rl3 clkb_s11 wlb11 vdd vss nand3
Xwd11 wlb11 wl11 vdd vss inv wn=0.84 wp=1.68
Cwl11 wl11 vss 4f
Xrd12 rh3 rl0 clkb_s12 wlb12 vdd vss nand3
Xwd12 wlb12 wl12 vdd vss inv wn=0.84 wp=1.68
Cwl12 wl12 vss 4f
Xrd13 rh3 rl1 clkb_s13 wlb13 vdd vss nand3
Xwd13 wlb13 wl13 vdd vss inv wn=0.84 wp=1.68
Cwl13 wl13 vss 4f
Xrd14 rh3 rl2 clkb_s14 wlb14 vdd vss nand3
Xwd14 wlb14 wl14 vdd vss inv wn=0.84 wp=1.68
Cwl14 wl14 vss 4f
Xrd15 rh3 rl3 clkb_s15 wlb15 vdd vss nand3
Xwd15 wlb15 wl15 vdd vss inv wn=0.84 wp=1.68
Cwl15 wl15 vss 4f
* --- column decoder
Xcd0 ch0 cl0 cselb0 vdd vss nand2
Xcs0 cselb0 csel0 vdd vss inv wn=0.84 wp=1.68
Xcd1 ch0 cl1 cselb1 vdd vss nand2
Xcs1 cselb1 csel1 vdd vss inv wn=0.84 wp=1.68
Xcd2 ch0 cl2 cselb2 vdd vss nand2
Xcs2 cselb2 csel2 vdd vss inv wn=0.84 wp=1.68
Xcd3 ch0 cl3 cselb3 vdd vss nand2
Xcs3 cselb3 csel3 vdd vss inv wn=0.84 wp=1.68
Xcd4 ch1 cl0 cselb4 vdd vss nand2
Xcs4 cselb4 csel4 vdd vss inv wn=0.84 wp=1.68
Xcd5 ch1 cl1 cselb5 vdd vss nand2
Xcs5 cselb5 csel5 vdd vss inv wn=0.84 wp=1.68
Xcd6 ch1 cl2 cselb6 vdd vss nand2
Xcs6 cselb6 csel6 vdd vss inv wn=0.84 wp=1.68
Xcd7 ch1 cl3 cselb7 vdd vss nand2
Xcs7 cselb7 csel7 vdd vss inv wn=0.84 wp=1.68
Xcd8 ch2 cl0 cselb8 vdd vss nand2
Xcs8 cselb8 csel8 vdd vss inv wn=0.84 wp=1.68
Xcd9 ch2 cl1 cselb9 vdd vss nand2
Xcs9 cselb9 csel9 vdd vss inv wn=0.84 wp=1.68
Xcd10 ch2 cl2 cselb10 vdd vss nand2
Xcs10 cselb10 csel10 vdd vss inv wn=0.84 wp=1.68
Xcd11 ch2 cl3 cselb11 vdd vss nand2
Xcs11 cselb11 csel11 vdd vss inv wn=0.84 wp=1.68
Xcd12 ch3 cl0 cselb12 vdd vss nand2
Xcs12 cselb12 csel12 vdd vss inv wn=0.84 wp=1.68
Xcd13 ch3 cl1 cselb13 vdd vss nand2
Xcs13 cselb13 csel13 vdd vss inv wn=0.84 wp=1.68
Xcd14 ch3 cl2 cselb14 vdd vss nand2
Xcs14 cselb14 csel14 vdd vss inv wn=0.84 wp=1.68
Xcd15 ch3 cl3 cselb15 vdd vss nand2
Xcs15 cselb15 csel15 vdd vss inv wn=0.84 wp=1.68
* --- 16x16 bit-cell array
Xc_0_0 bl0 blb0 wl0 vdd vss bitcell
Xc_0_1 bl1 blb1 wl0 vdd vss bitcell
Xc_0_2 bl2 blb2 wl0 vdd vss bitcell
Xc_0_3 bl3 blb3 wl0 vdd vss bitcell
Xc_0_4 bl4 blb4 wl0 vdd vss bitcell
Xc_0_5 bl5 blb5 wl0 vdd vss bitcell
Xc_0_6 bl6 blb6 wl0 vdd vss bitcell
Xc_0_7 bl7 blb7 wl0 vdd vss bitcell
Xc_0_8 bl8 blb8 wl0 vdd vss bitcell
Xc_0_9 bl9 blb9 wl0 vdd vss bitcell
Xc_0_10 bl10 blb10 wl0 vdd vss bitcell
Xc_0_11 bl11 blb11 wl0 vdd vss bitcell
Xc_0_12 bl12 blb12 wl0 vdd vss bitcell
Xc_0_13 bl13 blb13 wl0 vdd vss bitcell
Xc_0_14 bl14 blb14 wl0 vdd vss bitcell
Xc_0_15 bl15 blb15 wl0 vdd vss bitcell
Xc_1_0 bl0 blb0 wl1 vdd vss bitcell
Xc_1_1 bl1 blb1 wl1 vdd vss bitcell
Xc_1_2 bl2 blb2 wl1 vdd vss bitcell
Xc_1_3 bl3 blb3 wl1 vdd vss bitcell
Xc_1_4 bl4 blb4 wl1 vdd vss bitcell
Xc_1_5 bl5 blb5 wl1 vdd vss bitcell
Xc_1_6 bl6 blb6 wl1 vdd vss bitcell
Xc_1_7 bl7 blb7 wl1 vdd vss bitcell
Xc_1_8 bl8 blb8 wl1 vdd vss bitcell
Xc_1_9 bl9 blb9 wl1 vdd vss bitcell
Xc_1_10 bl10 blb10 wl1 vdd vss bitcell
Xc_1_11 bl11 blb11 wl1 vdd vss bitcell
Xc_1_12 bl12 blb12 wl1 vdd vss bitcell
Xc_1_13 bl13 blb13 wl1 vdd vss bitcell
Xc_1_14 bl14 blb14 wl1 vdd vss bitcell
Xc_1_15 bl15 blb15 wl1 vdd vss bitcell
Xc_2_0 bl0 blb0 wl2 vdd vss bitcell
Xc_2_1 bl1 blb1 wl2 vdd vss bitcell
Xc_2_2 bl2 blb2 wl2 vdd vss bitcell
Xc_2_3 bl3 blb3 wl2 vdd vss bitcell
Xc_2_4 bl4 blb4 wl2 vdd vss bitcell
Xc_2_5 bl5 blb5 wl2 vdd vss bitcell
Xc_2_6 bl6 blb6 wl2 vdd vss bitcell
Xc_2_7 bl7 blb7 wl2 vdd vss bitcell
Xc_2_8 bl8 blb8 wl2 vdd vss bitcell
Xc_2_9 bl9 blb9 wl2 vdd vss bitcell
Xc_2_10 bl10 blb10 wl2 vdd vss bitcell
Xc_2_11 bl11 blb11 wl2 vdd vss bitcell
Xc_2_12 bl12 blb12 wl2 vdd vss bitcell
Xc_2_13 bl13 blb13 wl2 vdd vss bitcell
Xc_2_14 bl14 blb14 wl2 vdd vss bitcell
Xc_2_15 bl15 blb15 wl2 vdd vss bitcell
Xc_3_0 bl0 blb0 wl3 vdd vss bitcell
Xc_3_1 bl1 blb1 wl3 vdd vss bitcell
Xc_3_2 bl2 blb2 wl3 vdd vss bitcell
Xc_3_3 bl3 blb3 wl3 vdd vss bitcell
Xc_3_4 bl4 blb4 wl3 vdd vss bitcell
Xc_3_5 bl5 blb5 wl3 vdd vss bitcell
Xc_3_6 bl6 blb6 wl3 vdd vss bitcell
Xc_3_7 bl7 blb7 wl3 vdd vss bitcell
Xc_3_8 bl8 blb8 wl3 vdd vss bitcell
Xc_3_9 bl9 blb9 wl3 vdd vss bitcell
Xc_3_10 bl10 blb10 wl3 vdd vss bitcell
Xc_3_11 bl11 blb11 wl3 vdd vss bitcell
Xc_3_12 bl12 blb12 wl3 vdd vss bitcell
Xc_3_13 bl13 blb13 wl3 vdd vss bitcell
Xc_3_14 bl14 blb14 wl3 vdd vss bitcell
Xc_3_15 bl15 blb15 wl3 vdd vss bitcell
Xc_4_0 bl0 blb0 wl4 vdd vss bitcell
Xc_4_1 bl1 blb1 wl4 vdd vss bitcell
Xc_4_2 bl2 blb2 wl4 vdd vss bitcell
Xc_4_3 bl3 blb3 wl4 vdd vss bitcell
Xc_4_4 bl4 blb4 wl4 vdd vss bitcell
Xc_4_5 bl5 blb5 wl4 vdd vss bitcell
Xc_4_6 bl6 blb6 wl4 vdd vss bitcell
Xc_4_7 bl7 blb7 wl4 vdd vss bitcell
Xc_4_8 bl8 blb8 wl4 vdd vss bitcell
Xc_4_9 bl9 blb9 wl4 vdd vss bitcell
Xc_4_10 bl10 blb10 wl4 vdd vss bitcell
Xc_4_11 bl11 blb11 wl4 vdd vss bitcell
Xc_4_12 bl12 blb12 wl4 vdd vss bitcell
Xc_4_13 bl13 blb13 wl4 vdd vss bitcell
Xc_4_14 bl14 blb14 wl4 vdd vss bitcell
Xc_4_15 bl15 blb15 wl4 vdd vss bitcell
Xc_5_0 bl0 blb0 wl5 vdd vss bitcell
Xc_5_1 bl1 blb1 wl5 vdd vss bitcell
Xc_5_2 bl2 blb2 wl5 vdd vss bitcell
Xc_5_3 bl3 blb3 wl5 vdd vss bitcell
Xc_5_4 bl4 blb4 wl5 vdd vss bitcell
Xc_5_5 bl5 blb5 wl5 vdd vss bitcell
Xc_5_6 bl6 blb6 wl5 vdd vss bitcell
Xc_5_7 bl7 blb7 wl5 vdd vss bitcell
Xc_5_8 bl8 blb8 wl5 vdd vss bitcell
Xc_5_9 bl9 blb9 wl5 vdd vss bitcell
Xc_5_10 bl10 blb10 wl5 vdd vss bitcell
Xc_5_11 bl11 blb11 wl5 vdd vss bitcell
Xc_5_12 bl12 blb12 wl5 vdd vss bitcell
Xc_5_13 bl13 blb13 wl5 vdd vss bitcell
Xc_5_14 bl14 blb14 wl5 vdd vss bitcell
Xc_5_15 bl15 blb15 wl5 vdd vss bitcell
Xc_6_0 bl0 blb0 wl6 vdd vss bitcell
Xc_6_1 bl1 blb1 wl6 vdd vss bitcell
Xc_6_2 bl2 blb2 wl6 vdd vss bitcell
Xc_6_3 bl3 blb3 wl6 vdd vss bitcell
Xc_6_4 bl4 blb4 wl6 vdd vss bitcell
Xc_6_5 bl5 blb5 wl6 vdd vss bitcell
Xc_6_6 bl6 blb6 wl6 vdd vss bitcell
Xc_6_7 bl7 blb7 wl6 vdd vss bitcell
Xc_6_8 bl8 blb8 wl6 vdd vss bitcell
Xc_6_9 bl9 blb9 wl6 vdd vss bitcell
Xc_6_10 bl10 blb10 wl6 vdd vss bitcell
Xc_6_11 bl11 blb11 wl6 vdd vss bitcell
Xc_6_12 bl12 blb12 wl6 vdd vss bitcell
Xc_6_13 bl13 blb13 wl6 vdd vss bitcell
Xc_6_14 bl14 blb14 wl6 vdd vss bitcell
Xc_6_15 bl15 blb15 wl6 vdd vss bitcell
Xc_7_0 bl0 blb0 wl7 vdd vss bitcell
Xc_7_1 bl1 blb1 wl7 vdd vss bitcell
Xc_7_2 bl2 blb2 wl7 vdd vss bitcell
Xc_7_3 bl3 blb3 wl7 vdd vss bitcell
Xc_7_4 bl4 blb4 wl7 vdd vss bitcell
Xc_7_5 bl5 blb5 wl7 vdd vss bitcell
Xc_7_6 bl6 blb6 wl7 vdd vss bitcell
Xc_7_7 bl7 blb7 wl7 vdd vss bitcell
Xc_7_8 bl8 blb8 wl7 vdd vss bitcell
Xc_7_9 bl9 blb9 wl7 vdd vss bitcell
Xc_7_10 bl10 blb10 wl7 vdd vss bitcell
Xc_7_11 bl11 blb11 wl7 vdd vss bitcell
Xc_7_12 bl12 blb12 wl7 vdd vss bitcell
Xc_7_13 bl13 blb13 wl7 vdd vss bitcell
Xc_7_14 bl14 blb14 wl7 vdd vss bitcell
Xc_7_15 bl15 blb15 wl7 vdd vss bitcell
Xc_8_0 bl0 blb0 wl8 vdd vss bitcell
Xc_8_1 bl1 blb1 wl8 vdd vss bitcell
Xc_8_2 bl2 blb2 wl8 vdd vss bitcell
Xc_8_3 bl3 blb3 wl8 vdd vss bitcell
Xc_8_4 bl4 blb4 wl8 vdd vss bitcell
Xc_8_5 bl5 blb5 wl8 vdd vss bitcell
Xc_8_6 bl6 blb6 wl8 vdd vss bitcell
Xc_8_7 bl7 blb7 wl8 vdd vss bitcell
Xc_8_8 bl8 blb8 wl8 vdd vss bitcell
Xc_8_9 bl9 blb9 wl8 vdd vss bitcell
Xc_8_10 bl10 blb10 wl8 vdd vss bitcell
Xc_8_11 bl11 blb11 wl8 vdd vss bitcell
Xc_8_12 bl12 blb12 wl8 vdd vss bitcell
Xc_8_13 bl13 blb13 wl8 vdd vss bitcell
Xc_8_14 bl14 blb14 wl8 vdd vss bitcell
Xc_8_15 bl15 blb15 wl8 vdd vss bitcell
Xc_9_0 bl0 blb0 wl9 vdd vss bitcell
Xc_9_1 bl1 blb1 wl9 vdd vss bitcell
Xc_9_2 bl2 blb2 wl9 vdd vss bitcell
Xc_9_3 bl3 blb3 wl9 vdd vss bitcell
Xc_9_4 bl4 blb4 wl9 vdd vss bitcell
Xc_9_5 bl5 blb5 wl9 vdd vss bitcell
Xc_9_6 bl6 blb6 wl9 vdd vss bitcell
Xc_9_7 bl7 blb7 wl9 vdd vss bitcell
Xc_9_8 bl8 blb8 wl9 vdd vss bitcell
Xc_9_9 bl9 blb9 wl9 vdd vss bitcell
Xc_9_10 bl10 blb10 wl9 vdd vss bitcell
Xc_9_11 bl11 blb11 wl9 vdd vss bitcell
Xc_9_12 bl12 blb12 wl9 vdd vss bitcell
Xc_9_13 bl13 blb13 wl9 vdd vss bitcell
Xc_9_14 bl14 blb14 wl9 vdd vss bitcell
Xc_9_15 bl15 blb15 wl9 vdd vss bitcell
Xc_10_0 bl0 blb0 wl10 vdd vss bitcell
Xc_10_1 bl1 blb1 wl10 vdd vss bitcell
Xc_10_2 bl2 blb2 wl10 vdd vss bitcell
Xc_10_3 bl3 blb3 wl10 vdd vss bitcell
Xc_10_4 bl4 blb4 wl10 vdd vss bitcell
Xc_10_5 bl5 blb5 wl10 vdd vss bitcell
Xc_10_6 bl6 blb6 wl10 vdd vss bitcell
Xc_10_7 bl7 blb7 wl10 vdd vss bitcell
Xc_10_8 bl8 blb8 wl10 vdd vss bitcell
Xc_10_9 bl9 blb9 wl10 vdd vss bitcell
Xc_10_10 bl10 blb10 wl10 vdd vss bitcell
Xc_10_11 bl11 blb11 wl10 vdd vss bitcell
Xc_10_12 bl12 blb12 wl10 vdd vss bitcell
Xc_10_13 bl13 blb13 wl10 vdd vss bitcell
Xc_10_14 bl14 blb14 wl10 vdd vss bitcell
Xc_10_15 bl15 blb15 wl10 vdd vss bitcell
Xc_11_0 bl0 blb0 wl11 vdd vss bitcell
Xc_11_1 bl1 blb1 wl11 vdd vss bitcell
Xc_11_2 bl2 blb2 wl11 vdd vss bitcell
Xc_11_3 bl3 blb3 wl11 vdd vss bitcell
Xc_11_4 bl4 blb4 wl11 vdd vss bitcell
Xc_11_5 bl5 blb5 wl11 vdd vss bitcell
Xc_11_6 bl6 blb6 wl11 vdd vss bitcell
Xc_11_7 bl7 blb7 wl11 vdd vss bitcell
Xc_11_8 bl8 blb8 wl11 vdd vss bitcell
Xc_11_9 bl9 blb9 wl11 vdd vss bitcell
Xc_11_10 bl10 blb10 wl11 vdd vss bitcell
Xc_11_11 bl11 blb11 wl11 vdd vss bitcell
Xc_11_12 bl12 blb12 wl11 vdd vss bitcell
Xc_11_13 bl13 blb13 wl11 vdd vss bitcell
Xc_11_14 bl14 blb14 wl11 vdd vss bitcell
Xc_11_15 bl15 blb15 wl11 vdd vss bitcell
Xc_12_0 bl0 blb0 wl12 vdd vss bitcell
Xc_12_1 bl1 blb1 wl12 vdd vss bitcell
Xc_12_2 bl2 blb2 wl12 vdd vss bitcell
Xc_12_3 bl3 blb3 wl12 vdd vss bitcell
Xc_12_4 bl4 blb4 wl12 vdd vss bitcell
Xc_12_5 bl5 blb5 wl12 vdd vss bitcell
Xc_12_6 bl6 blb6 wl12 vdd vss bitcell
Xc_12_7 bl7 blb7 wl12 vdd vss bitcell
Xc_12_8 bl8 blb8 wl12 vdd vss bitcell
Xc_12_9 bl9 blb9 wl12 vdd vss bitcell
Xc_12_10 bl10 blb10 wl12 vdd vss bitcell
Xc_12_11 bl11 blb11 wl12 vdd vss bitcell
Xc_12_12 bl12 blb12 wl12 vdd vss bitcell
Xc_12_13 bl13 blb13 wl12 vdd vss bitcell
Xc_12_14 bl14 blb14 wl12 vdd vss bitcell
Xc_12_15 bl15 blb15 wl12 vdd vss bitcell
Xc_13_0 bl0 blb0 wl13 vdd vss bitcell
Xc_13_1 bl1 blb1 wl13 vdd vss bitcell
Xc_13_2 bl2 blb2 wl13 vdd vss bitcell
Xc_13_3 bl3 blb3 wl13 vdd vss bitcell
Xc_13_4 bl4 blb4 wl13 vdd vss bitcell
Xc_13_5 bl5 blb5 wl13 vdd vss bitcell
Xc_13_6 bl6 blb6 wl13 vdd vss bitcell
Xc_13_7 bl7 blb7 wl13 vdd vss bitcell
Xc_13_8 bl8 blb8 wl13 vdd vss bitcell
Xc_13_9 bl9 blb9 wl13 vdd vss bitcell
Xc_13_10 bl10 blb10 wl13 vdd vss bitcell
Xc_13_11 bl11 blb11 wl13 vdd vss bitcell
Xc_13_12 bl12 blb12 wl13 vdd vss bitcell
Xc_13_13 bl13 blb13 wl13 vdd vss bitcell
Xc_13_14 bl14 blb14 wl13 vdd vss bitcell
Xc_13_15 bl15 blb15 wl13 vdd vss bitcell
Xc_14_0 bl0 blb0 wl14 vdd vss bitcell
Xc_14_1 bl1 blb1 wl14 vdd vss bitcell
Xc_14_2 bl2 blb2 wl14 vdd vss bitcell
Xc_14_3 bl3 blb3 wl14 vdd vss bitcell
Xc_14_4 bl4 blb4 wl14 vdd vss bitcell
Xc_14_5 bl5 blb5 wl14 vdd vss bitcell
Xc_14_6 bl6 blb6 wl14 vdd vss bitcell
Xc_14_7 bl7 blb7 wl14 vdd vss bitcell
Xc_14_8 bl8 blb8 wl14 vdd vss bitcell
Xc_14_9 bl9 blb9 wl14 vdd vss bitcell
Xc_14_10 bl10 blb10 wl14 vdd vss bitcell
Xc_14_11 bl11 blb11 wl14 vdd vss bitcell
Xc_14_12 bl12 blb12 wl14 vdd vss bitcell
Xc_14_13 bl13 blb13 wl14 vdd vss bitcell
Xc_14_14 bl14 blb14 wl14 vdd vss bitcell
Xc_14_15 bl15 blb15 wl14 vdd vss bitcell
Xc_15_0 bl0 blb0 wl15 vdd vss bitcell
Xc_15_1 bl1 blb1 wl15 vdd vss bitcell
Xc_15_2 bl2 blb2 wl15 vdd vss bitcell
Xc_15_3 bl3 blb3 wl15 vdd vss bitcell
Xc_15_4 bl4 blb4 wl15 vdd vss bitcell
Xc_15_5 bl5 blb5 wl15 vdd vss bitcell
Xc_15_6 bl6 blb6 wl15 vdd vss bitcell
Xc_15_7 bl7 blb7 wl15 vdd vss bitcell
Xc_15_8 bl8 blb8 wl15 vdd vss bitcell
Xc_15_9 bl9 blb9 wl15 vdd vss bitcell
Xc_15_10 bl10 blb10 wl15 vdd vss bitcell
Xc_15_11 bl11 blb11 wl15 vdd vss bitcell
Xc_15_12 bl12 blb12 wl15 vdd vss bitcell
Xc_15_13 bl13 blb13 wl15 vdd vss bitcell
Xc_15_14 bl14 blb14 wl15 vdd vss bitcell
Xc_15_15 bl15 blb15 wl15 vdd vss bitcell
Xpre0 bl0 blb0 pcb_s0 vdd precharge
Xmux0 bl0 blb0 dl dlb csel0 vss colmux
Cbl0 bl0 vss 5f
Cblb0 blb0 vss 5f
Xpre1 bl1 blb1 pcb_s1 vdd precharge
Xmux1 bl1 blb1 dl dlb csel1 vss colmux
Cbl1 bl1 vss 5f
Cblb1 blb1 vss 5f
Xpre2 bl2 blb2 pcb_s2 vdd precharge
Xmux2 bl2 blb2 dl dlb csel2 vss colmux
Cbl2 bl2 vss 5f
Cblb2 blb2 vss 5f
Xpre3 bl3 blb3 pcb_s3 vdd precharge
Xmux3 bl3 blb3 dl dlb csel3 vss colmux
Cbl3 bl3 vss 5f
Cblb3 blb3 vss 5f
Xpre4 bl4 blb4 pcb_s4 vdd precharge
Xmux4 bl4 blb4 dl dlb csel4 vss colmux
Cbl4 bl4 vss 5f
Cblb4 blb4 vss 5f
Xpre5 bl5 blb5 pcb_s5 vdd precharge
Xmux5 bl5 blb5 dl dlb csel5 vss colmux
Cbl5 bl5 vss 5f
Cblb5 blb5 vss 5f
Xpre6 bl6 blb6 pcb_s6 vdd precharge
Xmux6 bl6 blb6 dl dlb csel6 vss colmux
Cbl6 bl6 vss 5f
Cblb6 blb6 vss 5f
Xpre7 bl7 blb7 pcb_s7 vdd precharge
Xmux7 bl7 blb7 dl dlb csel7 vss colmux
Cbl7 bl7 vss 5f
Cblb7 blb7 vss 5f
Xpre8 bl8 blb8 pcb_s8 vdd precharge
Xmux8 bl8 blb8 dl dlb csel8 vss colmux
Cbl8 bl8 vss 5f
Cblb8 blb8 vss 5f
Xpre9 bl9 blb9 pcb_s9 vdd precharge
Xmux9 bl9 blb9 dl dlb csel9 vss colmux
Cbl9 bl9 vss 5f
Cblb9 blb9 vss 5f
Xpre10 bl10 blb10 pcb_s10 vdd precharge
Xmux10 bl10 blb10 dl dlb csel10 vss colmux
Cbl10 bl10 vss 5f
Cblb10 blb10 vss 5f
Xpre11 bl11 blb11 pcb_s11 vdd precharge
Xmux11 bl11 blb11 dl dlb csel11 vss colmux
Cbl11 bl11 vss 5f
Cblb11 blb11 vss 5f
Xpre12 bl12 blb12 pcb_s12 vdd precharge
Xmux12 bl12 blb12 dl dlb csel12 vss colmux
Cbl12 bl12 vss 5f
Cblb12 blb12 vss 5f
Xpre13 bl13 blb13 pcb_s13 vdd precharge
Xmux13 bl13 blb13 dl dlb csel13 vss colmux
Cbl13 bl13 vss 5f
Cblb13 blb13 vss 5f
Xpre14 bl14 blb14 pcb_s14 vdd precharge
Xmux14 bl14 blb14 dl dlb csel14 vss colmux
Cbl14 bl14 vss 5f
Cblb14 blb14 vss 5f
Xpre15 bl15 blb15 pcb_s15 vdd precharge
Xmux15 bl15 blb15 dl dlb csel15 vss colmux
Cbl15 bl15 vss 5f
Cblb15 blb15 vss 5f
Xwe1 rwq clkb_s_we web vdd vss nand2
Xwe2 web we vdd vss inv wn=1.26 wp=2.52
Xrw dl dlb we dinq dinqb pcb_s_rw rd vdd vss rwckt
Cdl dl vss 10f
Cdlb dlb vss 10f
Xff_out rd clk_ff_s0 rdq rdqb vdd vss dff
Xob rdqb dout_pad vddio vss outbuf
* --- clock RC trees (gen/clocktree.py)
Rclk_ff1 clk_ff_t0 clk_ff_w1 1.625
Cclk_ff1a clk_ff_t0 0 0.1156f
Cclk_ff1b clk_ff_w1 0 0.1156f
Rclk_ff2 clk_ff_w1 clk_ff_w2 1.625
Cclk_ff2a clk_ff_w1 0 0.1156f
Cclk_ff2b clk_ff_w2 0 0.1156f
Rclk_ff3 clk_ff_w2 clk_ff_w3 1.625
Cclk_ff3a clk_ff_w2 0 0.1156f
Cclk_ff3b clk_ff_w3 0 0.1156f
Rclk_ff4 clk_ff_w3 clk_ff_w4 1.625
Cclk_ff4a clk_ff_w3 0 0.1156f
Cclk_ff4b clk_ff_w4 0 0.1156f
Rclk_ff5 clk_ff_w4 clk_ff_w5 1.625
Cclk_ff5a clk_ff_w4 0 0.1156f
Cclk_ff5b clk_ff_w5 0 0.1156f
Rclk_ff6 clk_ff_w5 clk_ff_w6 1.625
Cclk_ff6a clk_ff_w5 0 0.1156f
Cclk_ff6b clk_ff_w6 0 0.1156f
Rclk_ff7 clk_ff_w6 clk_ff_w7 1.625
Cclk_ff7a clk_ff_w6 0 0.1156f
Cclk_ff7b clk_ff_w7 0 0.1156f
Rclk_ff8 clk_ff_w7 clk_ff_w8 1.625
Cclk_ff8a clk_ff_w7 0 0.1156f
Cclk_ff8b clk_ff_w8 0 0.1156f
Rclk_ff9 clk_ff_w8 clk_ff_s0 9.535
Cclk_ff9a clk_ff_w8 0 0.1156f
Cclk_ff9b clk_ff_s0 0 0.1156f
Rclk_ff10 clk_ff_t1 clk_ff_w10 1.625
Cclk_ff10a clk_ff_t1 0 0.1156f
Cclk_ff10b clk_ff_w10 0 0.1156f
Rclk_ff11 clk_ff_w10 clk_ff_w11 1.625
Cclk_ff11a clk_ff_w10 0 0.1156f
Cclk_ff11b clk_ff_w11 0 0.1156f
Rclk_ff12 clk_ff_w11 clk_ff_w12 1.625
Cclk_ff12a clk_ff_w11 0 0.1156f
Cclk_ff12b clk_ff_w12 0 0.1156f
Rclk_ff13 clk_ff_w12 clk_ff_w13 1.625
Cclk_ff13a clk_ff_w12 0 0.1156f
Cclk_ff13b clk_ff_w13 0 0.1156f
Rclk_ff14 clk_ff_w13 clk_ff_w14 1.625
Cclk_ff14a clk_ff_w13 0 0.1156f
Cclk_ff14b clk_ff_w14 0 0.1156f
Rclk_ff15 clk_ff_w14 clk_ff_w15 1.625
Cclk_ff15a clk_ff_w14 0 0.1156f
Cclk_ff15b clk_ff_w15 0 0.1156f
Rclk_ff16 clk_ff_w15 clk_ff_w16 1.625
Cclk_ff16a clk_ff_w15 0 0.1156f
Cclk_ff16b clk_ff_w16 0 0.1156f
Rclk_ff17 clk_ff_w16 clk_ff_w17 1.625
Cclk_ff17a clk_ff_w16 0 0.1156f
Cclk_ff17b clk_ff_w17 0 0.1156f
Rclk_ff18 clk_ff_w17 clk_ff_s1 9.535
Cclk_ff18a clk_ff_w17 0 0.1156f
Cclk_ff18b clk_ff_s1 0 0.1156f
Rclk_ff19 clk_ff_t2 clk_ff_w19 1.625
Cclk_ff19a clk_ff_t2 0 0.1156f
Cclk_ff19b clk_ff_w19 0 0.1156f
Rclk_ff20 clk_ff_w19 clk_ff_w20 1.625
Cclk_ff20a clk_ff_w19 0 0.1156f
Cclk_ff20b clk_ff_w20 0 0.1156f
Rclk_ff21 clk_ff_w20 clk_ff_w21 1.625
Cclk_ff21a clk_ff_w20 0 0.1156f
Cclk_ff21b clk_ff_w21 0 0.1156f
Rclk_ff22 clk_ff_w21 clk_ff_w22 1.625
Cclk_ff22a clk_ff_w21 0 0.1156f
Cclk_ff22b clk_ff_w22 0 0.1156f
Rclk_ff23 clk_ff_w22 clk_ff_w23 1.625
Cclk_ff23a clk_ff_w22 0 0.1156f
Cclk_ff23b clk_ff_w23 0 0.1156f
Rclk_ff24 clk_ff_w23 clk_ff_w24 1.625
Cclk_ff24a clk_ff_w23 0 0.1156f
Cclk_ff24b clk_ff_w24 0 0.1156f
Rclk_ff25 clk_ff_w24 clk_ff_w25 1.625
Cclk_ff25a clk_ff_w24 0 0.1156f
Cclk_ff25b clk_ff_w25 0 0.1156f
Rclk_ff26 clk_ff_w25 clk_ff_w26 1.625
Cclk_ff26a clk_ff_w25 0 0.1156f
Cclk_ff26b clk_ff_w26 0 0.1156f
Rclk_ff27 clk_ff_w26 clk_ff_s2 9.535
Cclk_ff27a clk_ff_w26 0 0.1156f
Cclk_ff27b clk_ff_s2 0 0.1156f
Rclk_ff28 clk_ff_t3 clk_ff_w28 1.625
Cclk_ff28a clk_ff_t3 0 0.1156f
Cclk_ff28b clk_ff_w28 0 0.1156f
Rclk_ff29 clk_ff_w28 clk_ff_w29 1.625
Cclk_ff29a clk_ff_w28 0 0.1156f
Cclk_ff29b clk_ff_w29 0 0.1156f
Rclk_ff30 clk_ff_w29 clk_ff_w30 1.625
Cclk_ff30a clk_ff_w29 0 0.1156f
Cclk_ff30b clk_ff_w30 0 0.1156f
Rclk_ff31 clk_ff_w30 clk_ff_w31 1.625
Cclk_ff31a clk_ff_w30 0 0.1156f
Cclk_ff31b clk_ff_w31 0 0.1156f
Rclk_ff32 clk_ff_w31 clk_ff_w32 1.625
Cclk_ff32a clk_ff_w31 0 0.1156f
Cclk_ff32b clk_ff_w32 0 0.1156f
Rclk_ff33 clk_ff_w32 clk_ff_w33 1.625
Cclk_ff33a clk_ff_w32 0 0.1156f
Cclk_ff33b clk_ff_w33 0 0.1156f
Rclk_ff34 clk_ff_w33 clk_ff_w34 1.625
Cclk_ff34a clk_ff_w33 0 0.1156f
Cclk_ff34b clk_ff_w34 0 0.1156f
Rclk_ff35 clk_ff_w34 clk_ff_w35 1.625
Cclk_ff35a clk_ff_w34 0 0.1156f
Cclk_ff35b clk_ff_w35 0 0.1156f
Rclk_ff36 clk_ff_w35 clk_ff_s3 9.535
Cclk_ff36a clk_ff_w35 0 0.1156f
Cclk_ff36b clk_ff_s3 0 0.1156f
Rclk_ff37 clk_ff_t4 clk_ff_w37 1.625
Cclk_ff37a clk_ff_t4 0 0.1156f
Cclk_ff37b clk_ff_w37 0 0.1156f
Rclk_ff38 clk_ff_w37 clk_ff_w38 1.625
Cclk_ff38a clk_ff_w37 0 0.1156f
Cclk_ff38b clk_ff_w38 0 0.1156f
Rclk_ff39 clk_ff_w38 clk_ff_w39 1.625
Cclk_ff39a clk_ff_w38 0 0.1156f
Cclk_ff39b clk_ff_w39 0 0.1156f
Rclk_ff40 clk_ff_w39 clk_ff_w40 1.625
Cclk_ff40a clk_ff_w39 0 0.1156f
Cclk_ff40b clk_ff_w40 0 0.1156f
Rclk_ff41 clk_ff_w40 clk_ff_w41 1.625
Cclk_ff41a clk_ff_w40 0 0.1156f
Cclk_ff41b clk_ff_w41 0 0.1156f
Rclk_ff42 clk_ff_w41 clk_ff_w42 1.625
Cclk_ff42a clk_ff_w41 0 0.1156f
Cclk_ff42b clk_ff_w42 0 0.1156f
Rclk_ff43 clk_ff_w42 clk_ff_w43 1.625
Cclk_ff43a clk_ff_w42 0 0.1156f
Cclk_ff43b clk_ff_w43 0 0.1156f
Rclk_ff44 clk_ff_w43 clk_ff_w44 1.625
Cclk_ff44a clk_ff_w43 0 0.1156f
Cclk_ff44b clk_ff_w44 0 0.1156f
Rclk_ff45 clk_ff_w44 clk_ff_s4 9.535
Cclk_ff45a clk_ff_w44 0 0.1156f
Cclk_ff45b clk_ff_s4 0 0.1156f
Rclk_ff46 clk_ff_t5 clk_ff_w46 1.625
Cclk_ff46a clk_ff_t5 0 0.1156f
Cclk_ff46b clk_ff_w46 0 0.1156f
Rclk_ff47 clk_ff_w46 clk_ff_w47 1.625
Cclk_ff47a clk_ff_w46 0 0.1156f
Cclk_ff47b clk_ff_w47 0 0.1156f
Rclk_ff48 clk_ff_w47 clk_ff_w48 1.625
Cclk_ff48a clk_ff_w47 0 0.1156f
Cclk_ff48b clk_ff_w48 0 0.1156f
Rclk_ff49 clk_ff_w48 clk_ff_w49 1.625
Cclk_ff49a clk_ff_w48 0 0.1156f
Cclk_ff49b clk_ff_w49 0 0.1156f
Rclk_ff50 clk_ff_w49 clk_ff_w50 1.625
Cclk_ff50a clk_ff_w49 0 0.1156f
Cclk_ff50b clk_ff_w50 0 0.1156f
Rclk_ff51 clk_ff_w50 clk_ff_w51 1.625
Cclk_ff51a clk_ff_w50 0 0.1156f
Cclk_ff51b clk_ff_w51 0 0.1156f
Rclk_ff52 clk_ff_w51 clk_ff_w52 1.625
Cclk_ff52a clk_ff_w51 0 0.1156f
Cclk_ff52b clk_ff_w52 0 0.1156f
Rclk_ff53 clk_ff_w52 clk_ff_w53 1.625
Cclk_ff53a clk_ff_w52 0 0.1156f
Cclk_ff53b clk_ff_w53 0 0.1156f
Rclk_ff54 clk_ff_w53 clk_ff_s5 9.535
Cclk_ff54a clk_ff_w53 0 0.1156f
Cclk_ff54b clk_ff_s5 0 0.1156f
Rclk_ff55 clk_ff_t6 clk_ff_w55 1.625
Cclk_ff55a clk_ff_t6 0 0.1156f
Cclk_ff55b clk_ff_w55 0 0.1156f
Rclk_ff56 clk_ff_w55 clk_ff_w56 1.625
Cclk_ff56a clk_ff_w55 0 0.1156f
Cclk_ff56b clk_ff_w56 0 0.1156f
Rclk_ff57 clk_ff_w56 clk_ff_w57 1.625
Cclk_ff57a clk_ff_w56 0 0.1156f
Cclk_ff57b clk_ff_w57 0 0.1156f
Rclk_ff58 clk_ff_w57 clk_ff_w58 1.625
Cclk_ff58a clk_ff_w57 0 0.1156f
Cclk_ff58b clk_ff_w58 0 0.1156f
Rclk_ff59 clk_ff_w58 clk_ff_w59 1.625
Cclk_ff59a clk_ff_w58 0 0.1156f
Cclk_ff59b clk_ff_w59 0 0.1156f
Rclk_ff60 clk_ff_w59 clk_ff_w60 1.625
Cclk_ff60a clk_ff_w59 0 0.1156f
Cclk_ff60b clk_ff_w60 0 0.1156f
Rclk_ff61 clk_ff_w60 clk_ff_w61 1.625
Cclk_ff61a clk_ff_w60 0 0.1156f
Cclk_ff61b clk_ff_w61 0 0.1156f
Rclk_ff62 clk_ff_w61 clk_ff_w62 1.625
Cclk_ff62a clk_ff_w61 0 0.1156f
Cclk_ff62b clk_ff_w62 0 0.1156f
Rclk_ff63 clk_ff_w62 clk_ff_s6 9.535
Cclk_ff63a clk_ff_w62 0 0.1156f
Cclk_ff63b clk_ff_s6 0 0.1156f
Rclk_ff64 clk_ff_t7 clk_ff_w64 1.625
Cclk_ff64a clk_ff_t7 0 0.1156f
Cclk_ff64b clk_ff_w64 0 0.1156f
Rclk_ff65 clk_ff_w64 clk_ff_w65 1.625
Cclk_ff65a clk_ff_w64 0 0.1156f
Cclk_ff65b clk_ff_w65 0 0.1156f
Rclk_ff66 clk_ff_w65 clk_ff_w66 1.625
Cclk_ff66a clk_ff_w65 0 0.1156f
Cclk_ff66b clk_ff_w66 0 0.1156f
Rclk_ff67 clk_ff_w66 clk_ff_w67 1.625
Cclk_ff67a clk_ff_w66 0 0.1156f
Cclk_ff67b clk_ff_w67 0 0.1156f
Rclk_ff68 clk_ff_w67 clk_ff_w68 1.625
Cclk_ff68a clk_ff_w67 0 0.1156f
Cclk_ff68b clk_ff_w68 0 0.1156f
Rclk_ff69 clk_ff_w68 clk_ff_w69 1.625
Cclk_ff69a clk_ff_w68 0 0.1156f
Cclk_ff69b clk_ff_w69 0 0.1156f
Rclk_ff70 clk_ff_w69 clk_ff_w70 1.625
Cclk_ff70a clk_ff_w69 0 0.1156f
Cclk_ff70b clk_ff_w70 0 0.1156f
Rclk_ff71 clk_ff_w70 clk_ff_w71 1.625
Cclk_ff71a clk_ff_w70 0 0.1156f
Cclk_ff71b clk_ff_w71 0 0.1156f
Rclk_ff72 clk_ff_w71 clk_ff_s7 9.535
Cclk_ff72a clk_ff_w71 0 0.1156f
Cclk_ff72b clk_ff_s7 0 0.1156f
Rclk_ff73 clk_ff_t8 clk_ff_w73 1.625
Cclk_ff73a clk_ff_t8 0 0.1156f
Cclk_ff73b clk_ff_w73 0 0.1156f
Rclk_ff74 clk_ff_w73 clk_ff_w74 1.625
Cclk_ff74a clk_ff_w73 0 0.1156f
Cclk_ff74b clk_ff_w74 0 0.1156f
Rclk_ff75 clk_ff_w74 clk_ff_w75 1.625
Cclk_ff75a clk_ff_w74 0 0.1156f
Cclk_ff75b clk_ff_w75 0 0.1156f
Rclk_ff76 clk_ff_w75 clk_ff_w76 1.625
Cclk_ff76a clk_ff_w75 0 0.1156f
Cclk_ff76b clk_ff_w76 0 0.1156f
Rclk_ff77 clk_ff_w76 clk_ff_w77 1.625
Cclk_ff77a clk_ff_w76 0 0.1156f
Cclk_ff77b clk_ff_w77 0 0.1156f
Rclk_ff78 clk_ff_w77 clk_ff_w78 1.625
Cclk_ff78a clk_ff_w77 0 0.1156f
Cclk_ff78b clk_ff_w78 0 0.1156f
Rclk_ff79 clk_ff_w78 clk_ff_w79 1.625
Cclk_ff79a clk_ff_w78 0 0.1156f
Cclk_ff79b clk_ff_w79 0 0.1156f
Rclk_ff80 clk_ff_w79 clk_ff_w80 1.625
Cclk_ff80a clk_ff_w79 0 0.1156f
Cclk_ff80b clk_ff_w80 0 0.1156f
Rclk_ff81 clk_ff_w80 clk_ff_s8 9.535
Cclk_ff81a clk_ff_w80 0 0.1156f
Cclk_ff81b clk_ff_s8 0 0.1156f
Rclk_ff82 clk_ff_t9 clk_ff_w82 1.625
Cclk_ff82a clk_ff_t9 0 0.1156f
Cclk_ff82b clk_ff_w82 0 0.1156f
Rclk_ff83 clk_ff_w82 clk_ff_w83 1.625
Cclk_ff83a clk_ff_w82 0 0.1156f
Cclk_ff83b clk_ff_w83 0 0.1156f
Rclk_ff84 clk_ff_w83 clk_ff_w84 1.625
Cclk_ff84a clk_ff_w83 0 0.1156f
Cclk_ff84b clk_ff_w84 0 0.1156f
Rclk_ff85 clk_ff_w84 clk_ff_w85 1.625
Cclk_ff85a clk_ff_w84 0 0.1156f
Cclk_ff85b clk_ff_w85 0 0.1156f
Rclk_ff86 clk_ff_w85 clk_ff_w86 1.625
Cclk_ff86a clk_ff_w85 0 0.1156f
Cclk_ff86b clk_ff_w86 0 0.1156f
Rclk_ff87 clk_ff_w86 clk_ff_w87 1.625
Cclk_ff87a clk_ff_w86 0 0.1156f
Cclk_ff87b clk_ff_w87 0 0.1156f
Rclk_ff88 clk_ff_w87 clk_ff_w88 1.625
Cclk_ff88a clk_ff_w87 0 0.1156f
Cclk_ff88b clk_ff_w88 0 0.1156f
Rclk_ff89 clk_ff_w88 clk_ff_w89 1.625
Cclk_ff89a clk_ff_w88 0 0.1156f
Cclk_ff89b clk_ff_w89 0 0.1156f
Rclk_ff90 clk_ff_w89 clk_ff_s9 9.535
Cclk_ff90a clk_ff_w89 0 0.1156f
Cclk_ff90b clk_ff_s9 0 0.1156f
Rclk_ff91 clk_ff_t10 clk_ff_w91 1.625
Cclk_ff91a clk_ff_t10 0 0.1156f
Cclk_ff91b clk_ff_w91 0 0.1156f
Rclk_ff92 clk_ff_w91 clk_ff_w92 1.625
Cclk_ff92a clk_ff_w91 0 0.1156f
Cclk_ff92b clk_ff_w92 0 0.1156f
Rclk_ff93 clk_ff_w92 clk_ff_w93 1.625
Cclk_ff93a clk_ff_w92 0 0.1156f
Cclk_ff93b clk_ff_w93 0 0.1156f
Rclk_ff94 clk_ff_w93 clk_ff_w94 1.625
Cclk_ff94a clk_ff_w93 0 0.1156f
Cclk_ff94b clk_ff_w94 0 0.1156f
Rclk_ff95 clk_ff_w94 clk_ff_w95 1.625
Cclk_ff95a clk_ff_w94 0 0.1156f
Cclk_ff95b clk_ff_w95 0 0.1156f
Rclk_ff96 clk_ff_w95 clk_ff_w96 1.625
Cclk_ff96a clk_ff_w95 0 0.1156f
Cclk_ff96b clk_ff_w96 0 0.1156f
Rclk_ff97 clk_ff_w96 clk_ff_w97 1.625
Cclk_ff97a clk_ff_w96 0 0.1156f
Cclk_ff97b clk_ff_w97 0 0.1156f
Rclk_ff98 clk_ff_w97 clk_ff_w98 1.625
Cclk_ff98a clk_ff_w97 0 0.1156f
Cclk_ff98b clk_ff_w98 0 0.1156f
Rclk_ff99 clk_ff_w98 clk_ff_s10 9.535
Cclk_ff99a clk_ff_w98 0 0.1156f
Cclk_ff99b clk_ff_s10 0 0.1156f
Rclk_ff100 clk_ff clk_ff_w100 0.267
Cclk_ff100a clk_ff 0 0.1074f
Cclk_ff100b clk_ff_w100 0 0.1074f
Rclk_ff101 clk_ff_w100 clk_ff_w101 0.267
Cclk_ff101a clk_ff_w100 0 0.1074f
Cclk_ff101b clk_ff_w101 0 0.1074f
Rclk_ff102 clk_ff_w101 clk_ff_w102 0.267
Cclk_ff102a clk_ff_w101 0 0.1074f
Cclk_ff102b clk_ff_w102 0 0.1074f
Rclk_ff103 clk_ff_w102 clk_ff_f 0.267
Cclk_ff103a clk_ff_w102 0 0.1074f
Cclk_ff103b clk_ff_f 0 0.1074f
Rclk_ff104 clk_ff_t0 clk_ff_w104 0.2612
Cclk_ff104a clk_ff_t0 0 0.1198f
Cclk_ff104b clk_ff_w104 0 0.1198f
Rclk_ff105 clk_ff_w104 clk_ff_w105 0.2612
Cclk_ff105a clk_ff_w104 0 0.1198f
Cclk_ff105b clk_ff_w105 0 0.1198f
Rclk_ff106 clk_ff_w105 clk_ff_w106 0.2612
Cclk_ff106a clk_ff_w105 0 0.1198f
Cclk_ff106b clk_ff_w106 0 0.1198f
Rclk_ff107 clk_ff_w106 clk_ff_w107 0.2612
Cclk_ff107a clk_ff_w106 0 0.1198f
Cclk_ff107b clk_ff_w107 0 0.1198f
Rclk_ff108 clk_ff_w107 clk_ff_w108 0.2612
Cclk_ff108a clk_ff_w107 0 0.1198f
Cclk_ff108b clk_ff_w108 0 0.1198f
Rclk_ff109 clk_ff_w108 clk_ff_w109 0.2612
Cclk_ff109a clk_ff_w108 0 0.1198f
Cclk_ff109b clk_ff_w109 0 0.1198f
Rclk_ff110 clk_ff_w109 clk_ff_w110 0.2612
Cclk_ff110a clk_ff_w109 0 0.1198f
Cclk_ff110b clk_ff_w110 0 0.1198f
Rclk_ff111 clk_ff_w110 clk_ff_w111 0.2612
Cclk_ff111a clk_ff_w110 0 0.1198f
Cclk_ff111b clk_ff_w111 0 0.1198f
Rclk_ff112 clk_ff_w111 clk_ff_w112 0.2612
Cclk_ff112a clk_ff_w111 0 0.1198f
Cclk_ff112b clk_ff_w112 0 0.1198f
Rclk_ff113 clk_ff_w112 clk_ff_w113 0.2612
Cclk_ff113a clk_ff_w112 0 0.1198f
Cclk_ff113b clk_ff_w113 0 0.1198f
Rclk_ff114 clk_ff_w113 clk_ff_t1 0.2612
Cclk_ff114a clk_ff_w113 0 0.1198f
Cclk_ff114b clk_ff_t1 0 0.1198f
Rclk_ff115 clk_ff_t1 clk_ff_w115 0.2612
Cclk_ff115a clk_ff_t1 0 0.1198f
Cclk_ff115b clk_ff_w115 0 0.1198f
Rclk_ff116 clk_ff_w115 clk_ff_w116 0.2612
Cclk_ff116a clk_ff_w115 0 0.1198f
Cclk_ff116b clk_ff_w116 0 0.1198f
Rclk_ff117 clk_ff_w116 clk_ff_w117 0.2612
Cclk_ff117a clk_ff_w116 0 0.1198f
Cclk_ff117b clk_ff_w117 0 0.1198f
Rclk_ff118 clk_ff_w117 clk_ff_w118 0.2612
Cclk_ff118a clk_ff_w117 0 0.1198f
Cclk_ff118b clk_ff_w118 0 0.1198f
Rclk_ff119 clk_ff_w118 clk_ff_w119 0.2612
Cclk_ff119a clk_ff_w118 0 0.1198f
Cclk_ff119b clk_ff_w119 0 0.1198f
Rclk_ff120 clk_ff_w119 clk_ff_w120 0.2612
Cclk_ff120a clk_ff_w119 0 0.1198f
Cclk_ff120b clk_ff_w120 0 0.1198f
Rclk_ff121 clk_ff_w120 clk_ff_w121 0.2612
Cclk_ff121a clk_ff_w120 0 0.1198f
Cclk_ff121b clk_ff_w121 0 0.1198f
Rclk_ff122 clk_ff_w121 clk_ff_w122 0.2612
Cclk_ff122a clk_ff_w121 0 0.1198f
Cclk_ff122b clk_ff_w122 0 0.1198f
Rclk_ff123 clk_ff_w122 clk_ff_w123 0.2612
Cclk_ff123a clk_ff_w122 0 0.1198f
Cclk_ff123b clk_ff_w123 0 0.1198f
Rclk_ff124 clk_ff_w123 clk_ff_w124 0.2612
Cclk_ff124a clk_ff_w123 0 0.1198f
Cclk_ff124b clk_ff_w124 0 0.1198f
Rclk_ff125 clk_ff_w124 clk_ff_t2 0.2612
Cclk_ff125a clk_ff_w124 0 0.1198f
Cclk_ff125b clk_ff_t2 0 0.1198f
Rclk_ff126 clk_ff_t2 clk_ff_w126 0.2612
Cclk_ff126a clk_ff_t2 0 0.1198f
Cclk_ff126b clk_ff_w126 0 0.1198f
Rclk_ff127 clk_ff_w126 clk_ff_w127 0.2612
Cclk_ff127a clk_ff_w126 0 0.1198f
Cclk_ff127b clk_ff_w127 0 0.1198f
Rclk_ff128 clk_ff_w127 clk_ff_w128 0.2612
Cclk_ff128a clk_ff_w127 0 0.1198f
Cclk_ff128b clk_ff_w128 0 0.1198f
Rclk_ff129 clk_ff_w128 clk_ff_w129 0.2612
Cclk_ff129a clk_ff_w128 0 0.1198f
Cclk_ff129b clk_ff_w129 0 0.1198f
Rclk_ff130 clk_ff_w129 clk_ff_w130 0.2612
Cclk_ff130a clk_ff_w129 0 0.1198f
Cclk_ff130b clk_ff_w130 0 0.1198f
Rclk_ff131 clk_ff_w130 clk_ff_w131 0.2612
Cclk_ff131a clk_ff_w130 0 0.1198f
Cclk_ff131b clk_ff_w131 0 0.1198f
Rclk_ff132 clk_ff_w131 clk_ff_w132 0.2612
Cclk_ff132a clk_ff_w131 0 0.1198f
Cclk_ff132b clk_ff_w132 0 0.1198f
Rclk_ff133 clk_ff_w132 clk_ff_w133 0.2612
Cclk_ff133a clk_ff_w132 0 0.1198f
Cclk_ff133b clk_ff_w133 0 0.1198f
Rclk_ff134 clk_ff_w133 clk_ff_w134 0.2612
Cclk_ff134a clk_ff_w133 0 0.1198f
Cclk_ff134b clk_ff_w134 0 0.1198f
Rclk_ff135 clk_ff_w134 clk_ff_w135 0.2612
Cclk_ff135a clk_ff_w134 0 0.1198f
Cclk_ff135b clk_ff_w135 0 0.1198f
Rclk_ff136 clk_ff_w135 clk_ff_t3 0.2612
Cclk_ff136a clk_ff_w135 0 0.1198f
Cclk_ff136b clk_ff_t3 0 0.1198f
Rclk_ff137 clk_ff_t3 clk_ff_w137 0.2612
Cclk_ff137a clk_ff_t3 0 0.1198f
Cclk_ff137b clk_ff_w137 0 0.1198f
Rclk_ff138 clk_ff_w137 clk_ff_w138 0.2612
Cclk_ff138a clk_ff_w137 0 0.1198f
Cclk_ff138b clk_ff_w138 0 0.1198f
Rclk_ff139 clk_ff_w138 clk_ff_w139 0.2612
Cclk_ff139a clk_ff_w138 0 0.1198f
Cclk_ff139b clk_ff_w139 0 0.1198f
Rclk_ff140 clk_ff_w139 clk_ff_w140 0.2612
Cclk_ff140a clk_ff_w139 0 0.1198f
Cclk_ff140b clk_ff_w140 0 0.1198f
Rclk_ff141 clk_ff_w140 clk_ff_w141 0.2612
Cclk_ff141a clk_ff_w140 0 0.1198f
Cclk_ff141b clk_ff_w141 0 0.1198f
Rclk_ff142 clk_ff_w141 clk_ff_w142 0.2612
Cclk_ff142a clk_ff_w141 0 0.1198f
Cclk_ff142b clk_ff_w142 0 0.1198f
Rclk_ff143 clk_ff_w142 clk_ff_w143 0.2612
Cclk_ff143a clk_ff_w142 0 0.1198f
Cclk_ff143b clk_ff_w143 0 0.1198f
Rclk_ff144 clk_ff_w143 clk_ff_w144 0.2612
Cclk_ff144a clk_ff_w143 0 0.1198f
Cclk_ff144b clk_ff_w144 0 0.1198f
Rclk_ff145 clk_ff_w144 clk_ff_w145 0.2612
Cclk_ff145a clk_ff_w144 0 0.1198f
Cclk_ff145b clk_ff_w145 0 0.1198f
Rclk_ff146 clk_ff_w145 clk_ff_w146 0.2612
Cclk_ff146a clk_ff_w145 0 0.1198f
Cclk_ff146b clk_ff_w146 0 0.1198f
Rclk_ff147 clk_ff_w146 clk_ff_t4 0.2612
Cclk_ff147a clk_ff_w146 0 0.1198f
Cclk_ff147b clk_ff_t4 0 0.1198f
Rclk_ff148 clk_ff_t4 clk_ff_w148 0.2732
Cclk_ff148a clk_ff_t4 0 0.1253f
Cclk_ff148b clk_ff_w148 0 0.1253f
Rclk_ff149 clk_ff_w148 clk_ff_w149 0.2732
Cclk_ff149a clk_ff_w148 0 0.1253f
Cclk_ff149b clk_ff_w149 0 0.1253f
Rclk_ff150 clk_ff_w149 clk_ff_w150 0.2732
Cclk_ff150a clk_ff_w149 0 0.1253f
Cclk_ff150b clk_ff_w150 0 0.1253f
Rclk_ff151 clk_ff_w150 clk_ff_w151 0.2732
Cclk_ff151a clk_ff_w150 0 0.1253f
Cclk_ff151b clk_ff_w151 0 0.1253f
Rclk_ff152 clk_ff_w151 clk_ff_w152 0.2732
Cclk_ff152a clk_ff_w151 0 0.1253f
Cclk_ff152b clk_ff_w152 0 0.1253f
Rclk_ff153 clk_ff_w152 clk_ff_w153 0.2732
Cclk_ff153a clk_ff_w152 0 0.1253f
Cclk_ff153b clk_ff_w153 0 0.1253f
Rclk_ff154 clk_ff_w153 clk_ff_w154 0.2732
Cclk_ff154a clk_ff_w153 0 0.1253f
Cclk_ff154b clk_ff_w154 0 0.1253f
Rclk_ff155 clk_ff_w154 clk_ff_w155 0.2732
Cclk_ff155a clk_ff_w154 0 0.1253f
Cclk_ff155b clk_ff_w155 0 0.1253f
Rclk_ff156 clk_ff_w155 clk_ff_w156 0.2732
Cclk_ff156a clk_ff_w155 0 0.1253f
Cclk_ff156b clk_ff_w156 0 0.1253f
Rclk_ff157 clk_ff_w156 clk_ff_f 0.2732
Cclk_ff157a clk_ff_w156 0 0.1253f
Cclk_ff157b clk_ff_f 0 0.1253f
Rclk_ff158 clk_ff_f clk_ff_t5 0.1403
Cclk_ff158a clk_ff_f 0 0.06433f
Cclk_ff158b clk_ff_t5 0 0.06433f
Rclk_ff159 clk_ff_t5 clk_ff_w159 0.2612
Cclk_ff159a clk_ff_t5 0 0.1198f
Cclk_ff159b clk_ff_w159 0 0.1198f
Rclk_ff160 clk_ff_w159 clk_ff_w160 0.2612
Cclk_ff160a clk_ff_w159 0 0.1198f
Cclk_ff160b clk_ff_w160 0 0.1198f
Rclk_ff161 clk_ff_w160 clk_ff_w161 0.2612
Cclk_ff161a clk_ff_w160 0 0.1198f
Cclk_ff161b clk_ff_w161 0 0.1198f
Rclk_ff162 clk_ff_w161 clk_ff_w162 0.2612
Cclk_ff162a clk_ff_w161 0 0.1198f
Cclk_ff162b clk_ff_w162 0 0.1198f
Rclk_ff163 clk_ff_w162 clk_ff_w163 0.2612
Cclk_ff163a clk_ff_w162 0 0.1198f
Cclk_ff163b clk_ff_w163 0 0.1198f
Rclk_ff164 clk_ff_w163 clk_ff_w164 0.2612
Cclk_ff164a clk_ff_w163 0 0.1198f
Cclk_ff164b clk_ff_w164 0 0.1198f
Rclk_ff165 clk_ff_w164 clk_ff_w165 0.2612
Cclk_ff165a clk_ff_w164 0 0.1198f
Cclk_ff165b clk_ff_w165 0 0.1198f
Rclk_ff166 clk_ff_w165 clk_ff_w166 0.2612
Cclk_ff166a clk_ff_w165 0 0.1198f
Cclk_ff166b clk_ff_w166 0 0.1198f
Rclk_ff167 clk_ff_w166 clk_ff_w167 0.2612
Cclk_ff167a clk_ff_w166 0 0.1198f
Cclk_ff167b clk_ff_w167 0 0.1198f
Rclk_ff168 clk_ff_w167 clk_ff_w168 0.2612
Cclk_ff168a clk_ff_w167 0 0.1198f
Cclk_ff168b clk_ff_w168 0 0.1198f
Rclk_ff169 clk_ff_w168 clk_ff_t6 0.2612
Cclk_ff169a clk_ff_w168 0 0.1198f
Cclk_ff169b clk_ff_t6 0 0.1198f
Rclk_ff170 clk_ff_t6 clk_ff_w170 0.2612
Cclk_ff170a clk_ff_t6 0 0.1198f
Cclk_ff170b clk_ff_w170 0 0.1198f
Rclk_ff171 clk_ff_w170 clk_ff_w171 0.2612
Cclk_ff171a clk_ff_w170 0 0.1198f
Cclk_ff171b clk_ff_w171 0 0.1198f
Rclk_ff172 clk_ff_w171 clk_ff_w172 0.2612
Cclk_ff172a clk_ff_w171 0 0.1198f
Cclk_ff172b clk_ff_w172 0 0.1198f
Rclk_ff173 clk_ff_w172 clk_ff_w173 0.2612
Cclk_ff173a clk_ff_w172 0 0.1198f
Cclk_ff173b clk_ff_w173 0 0.1198f
Rclk_ff174 clk_ff_w173 clk_ff_w174 0.2612
Cclk_ff174a clk_ff_w173 0 0.1198f
Cclk_ff174b clk_ff_w174 0 0.1198f
Rclk_ff175 clk_ff_w174 clk_ff_w175 0.2612
Cclk_ff175a clk_ff_w174 0 0.1198f
Cclk_ff175b clk_ff_w175 0 0.1198f
Rclk_ff176 clk_ff_w175 clk_ff_w176 0.2612
Cclk_ff176a clk_ff_w175 0 0.1198f
Cclk_ff176b clk_ff_w176 0 0.1198f
Rclk_ff177 clk_ff_w176 clk_ff_w177 0.2612
Cclk_ff177a clk_ff_w176 0 0.1198f
Cclk_ff177b clk_ff_w177 0 0.1198f
Rclk_ff178 clk_ff_w177 clk_ff_w178 0.2612
Cclk_ff178a clk_ff_w177 0 0.1198f
Cclk_ff178b clk_ff_w178 0 0.1198f
Rclk_ff179 clk_ff_w178 clk_ff_w179 0.2612
Cclk_ff179a clk_ff_w178 0 0.1198f
Cclk_ff179b clk_ff_w179 0 0.1198f
Rclk_ff180 clk_ff_w179 clk_ff_t7 0.2612
Cclk_ff180a clk_ff_w179 0 0.1198f
Cclk_ff180b clk_ff_t7 0 0.1198f
Rclk_ff181 clk_ff_t7 clk_ff_w181 0.2612
Cclk_ff181a clk_ff_t7 0 0.1198f
Cclk_ff181b clk_ff_w181 0 0.1198f
Rclk_ff182 clk_ff_w181 clk_ff_w182 0.2612
Cclk_ff182a clk_ff_w181 0 0.1198f
Cclk_ff182b clk_ff_w182 0 0.1198f
Rclk_ff183 clk_ff_w182 clk_ff_w183 0.2612
Cclk_ff183a clk_ff_w182 0 0.1198f
Cclk_ff183b clk_ff_w183 0 0.1198f
Rclk_ff184 clk_ff_w183 clk_ff_w184 0.2612
Cclk_ff184a clk_ff_w183 0 0.1198f
Cclk_ff184b clk_ff_w184 0 0.1198f
Rclk_ff185 clk_ff_w184 clk_ff_w185 0.2612
Cclk_ff185a clk_ff_w184 0 0.1198f
Cclk_ff185b clk_ff_w185 0 0.1198f
Rclk_ff186 clk_ff_w185 clk_ff_w186 0.2612
Cclk_ff186a clk_ff_w185 0 0.1198f
Cclk_ff186b clk_ff_w186 0 0.1198f
Rclk_ff187 clk_ff_w186 clk_ff_w187 0.2612
Cclk_ff187a clk_ff_w186 0 0.1198f
Cclk_ff187b clk_ff_w187 0 0.1198f
Rclk_ff188 clk_ff_w187 clk_ff_w188 0.2612
Cclk_ff188a clk_ff_w187 0 0.1198f
Cclk_ff188b clk_ff_w188 0 0.1198f
Rclk_ff189 clk_ff_w188 clk_ff_w189 0.2612
Cclk_ff189a clk_ff_w188 0 0.1198f
Cclk_ff189b clk_ff_w189 0 0.1198f
Rclk_ff190 clk_ff_w189 clk_ff_w190 0.2612
Cclk_ff190a clk_ff_w189 0 0.1198f
Cclk_ff190b clk_ff_w190 0 0.1198f
Rclk_ff191 clk_ff_w190 clk_ff_t8 0.2612
Cclk_ff191a clk_ff_w190 0 0.1198f
Cclk_ff191b clk_ff_t8 0 0.1198f
Rclk_ff192 clk_ff_t8 clk_ff_w192 0.2612
Cclk_ff192a clk_ff_t8 0 0.1198f
Cclk_ff192b clk_ff_w192 0 0.1198f
Rclk_ff193 clk_ff_w192 clk_ff_w193 0.2612
Cclk_ff193a clk_ff_w192 0 0.1198f
Cclk_ff193b clk_ff_w193 0 0.1198f
Rclk_ff194 clk_ff_w193 clk_ff_w194 0.2612
Cclk_ff194a clk_ff_w193 0 0.1198f
Cclk_ff194b clk_ff_w194 0 0.1198f
Rclk_ff195 clk_ff_w194 clk_ff_w195 0.2612
Cclk_ff195a clk_ff_w194 0 0.1198f
Cclk_ff195b clk_ff_w195 0 0.1198f
Rclk_ff196 clk_ff_w195 clk_ff_w196 0.2612
Cclk_ff196a clk_ff_w195 0 0.1198f
Cclk_ff196b clk_ff_w196 0 0.1198f
Rclk_ff197 clk_ff_w196 clk_ff_w197 0.2612
Cclk_ff197a clk_ff_w196 0 0.1198f
Cclk_ff197b clk_ff_w197 0 0.1198f
Rclk_ff198 clk_ff_w197 clk_ff_w198 0.2612
Cclk_ff198a clk_ff_w197 0 0.1198f
Cclk_ff198b clk_ff_w198 0 0.1198f
Rclk_ff199 clk_ff_w198 clk_ff_w199 0.2612
Cclk_ff199a clk_ff_w198 0 0.1198f
Cclk_ff199b clk_ff_w199 0 0.1198f
Rclk_ff200 clk_ff_w199 clk_ff_w200 0.2612
Cclk_ff200a clk_ff_w199 0 0.1198f
Cclk_ff200b clk_ff_w200 0 0.1198f
Rclk_ff201 clk_ff_w200 clk_ff_w201 0.2612
Cclk_ff201a clk_ff_w200 0 0.1198f
Cclk_ff201b clk_ff_w201 0 0.1198f
Rclk_ff202 clk_ff_w201 clk_ff_t9 0.2612
Cclk_ff202a clk_ff_w201 0 0.1198f
Cclk_ff202b clk_ff_t9 0 0.1198f
Rclk_ff203 clk_ff_t9 clk_ff_w203 0.2612
Cclk_ff203a clk_ff_t9 0 0.1198f
Cclk_ff203b clk_ff_w203 0 0.1198f
Rclk_ff204 clk_ff_w203 clk_ff_w204 0.2612
Cclk_ff204a clk_ff_w203 0 0.1198f
Cclk_ff204b clk_ff_w204 0 0.1198f
Rclk_ff205 clk_ff_w204 clk_ff_w205 0.2612
Cclk_ff205a clk_ff_w204 0 0.1198f
Cclk_ff205b clk_ff_w205 0 0.1198f
Rclk_ff206 clk_ff_w205 clk_ff_w206 0.2612
Cclk_ff206a clk_ff_w205 0 0.1198f
Cclk_ff206b clk_ff_w206 0 0.1198f
Rclk_ff207 clk_ff_w206 clk_ff_w207 0.2612
Cclk_ff207a clk_ff_w206 0 0.1198f
Cclk_ff207b clk_ff_w207 0 0.1198f
Rclk_ff208 clk_ff_w207 clk_ff_w208 0.2612
Cclk_ff208a clk_ff_w207 0 0.1198f
Cclk_ff208b clk_ff_w208 0 0.1198f
Rclk_ff209 clk_ff_w208 clk_ff_w209 0.2612
Cclk_ff209a clk_ff_w208 0 0.1198f
Cclk_ff209b clk_ff_w209 0 0.1198f
Rclk_ff210 clk_ff_w209 clk_ff_w210 0.2612
Cclk_ff210a clk_ff_w209 0 0.1198f
Cclk_ff210b clk_ff_w210 0 0.1198f
Rclk_ff211 clk_ff_w210 clk_ff_w211 0.2612
Cclk_ff211a clk_ff_w210 0 0.1198f
Cclk_ff211b clk_ff_w211 0 0.1198f
Rclk_ff212 clk_ff_w211 clk_ff_w212 0.2612
Cclk_ff212a clk_ff_w211 0 0.1198f
Cclk_ff212b clk_ff_w212 0 0.1198f
Rclk_ff213 clk_ff_w212 clk_ff_t10 0.2612
Cclk_ff213a clk_ff_w212 0 0.1198f
Cclk_ff213b clk_ff_t10 0 0.1198f
Rclkb1 clkb clkb_w1 0.2465
Cclkb1a clkb 0 0.1176f
Cclkb1b clkb_w1 0 0.1176f
Rclkb2 clkb_w1 clkb_w2 0.2465
Cclkb2a clkb_w1 0 0.1176f
Cclkb2b clkb_w2 0 0.1176f
Rclkb3 clkb_w2 clkb_w3 0.2465
Cclkb3a clkb_w2 0 0.1176f
Cclkb3b clkb_w3 0 0.1176f
Rclkb4 clkb_w3 clkb_w4 0.2465
Cclkb4a clkb_w3 0 0.1176f
Cclkb4b clkb_w4 0 0.1176f
Rclkb5 clkb_w4 clkb_w5 0.2465
Cclkb5a clkb_w4 0 0.1176f
Cclkb5b clkb_w5 0 0.1176f
Rclkb6 clkb_w5 clkb_f 0.2465
Cclkb6a clkb_w5 0 0.1176f
Cclkb6b clkb_f 0 0.1176f
Rclkb7 clkb_sp clkb_w7 0.2828
Cclkb7a clkb_sp 0 0.1491f
Cclkb7b clkb_w7 0 0.1491f
Rclkb8 clkb_w7 clkb_w8 0.2828
Cclkb8a clkb_w7 0 0.1491f
Cclkb8b clkb_w8 0 0.1491f
Rclkb9 clkb_w8 clkb_w9 0.2828
Cclkb9a clkb_w8 0 0.1491f
Cclkb9b clkb_w9 0 0.1491f
Rclkb10 clkb_w9 clkb_w10 0.2828
Cclkb10a clkb_w9 0 0.1491f
Cclkb10b clkb_w10 0 0.1491f
Rclkb11 clkb_w10 clkb_w11 0.2828
Cclkb11a clkb_w10 0 0.1491f
Cclkb11b clkb_w11 0 0.1491f
Rclkb12 clkb_w11 clkb_w12 0.2828
Cclkb12a clkb_w11 0 0.1491f
Cclkb12b clkb_w12 0 0.1491f
Rclkb13 clkb_w12 clkb_w13 0.2828
Cclkb13a clkb_w12 0 0.1491f
Cclkb13b clkb_w13 0 0.1491f
Rclkb14 clkb_w13 clkb_w14 0.2828
Cclkb14a clkb_w13 0 0.1491f
Cclkb14b clkb_w14 0 0.1491f
Rclkb15 clkb_w14 clkb_w15 0.2828
Cclkb15a clkb_w14 0 0.1491f
Cclkb15b clkb_w15 0 0.1491f
Rclkb16 clkb_w15 clkb_w16 0.2828
Cclkb16a clkb_w15 0 0.1491f
Cclkb16b clkb_w16 0 0.1491f
Rclkb17 clkb_w16 clkb_w17 0.2828
Cclkb17a clkb_w16 0 0.1491f
Cclkb17b clkb_w17 0 0.1491f
Rclkb18 clkb_w17 clkb_w18 0.2828
Cclkb18a clkb_w17 0 0.1491f
Cclkb18b clkb_w18 0 0.1491f
Rclkb19 clkb_w18 clkb_w19 0.2828
Cclkb19a clkb_w18 0 0.1491f
Cclkb19b clkb_w19 0 0.1491f
Rclkb20 clkb_w19 clkb_w20 0.2828
Cclkb20a clkb_w19 0 0.1491f
Cclkb20b clkb_w20 0 0.1491f
Rclkb21 clkb_w20 clkb_f 0.2828
Cclkb21a clkb_w20 0 0.1491f
Cclkb21b clkb_f 0 0.1491f
Rclkb22 clkb_f clkb_w22 0.2848
Cclkb22a clkb_f 0 0.1501f
Cclkb22b clkb_w22 0 0.1501f
Rclkb23 clkb_w22 clkb_w23 0.2848
Cclkb23a clkb_w22 0 0.1501f
Cclkb23b clkb_w23 0 0.1501f
Rclkb24 clkb_w23 clkb_w24 0.2848
Cclkb24a clkb_w23 0 0.1501f
Cclkb24b clkb_w24 0 0.1501f
Rclkb25 clkb_w24 clkb_w25 0.2848
Cclkb25a clkb_w24 0 0.1501f
Cclkb25b clkb_w25 0 0.1501f
Rclkb26 clkb_w25 clkb_w26 0.2848
Cclkb26a clkb_w25 0 0.1501f
Cclkb26b clkb_w26 0 0.1501f
Rclkb27 clkb_w26 clkb_w27 0.2848
Cclkb27a clkb_w26 0 0.1501f
Cclkb27b clkb_w27 0 0.1501f
Rclkb28 clkb_w27 clkb_w28 0.2848
Cclkb28a clkb_w27 0 0.1501f
Cclkb28b clkb_w28 0 0.1501f
Rclkb29 clkb_w28 clkb_w29 0.2848
Cclkb29a clkb_w28 0 0.1501f
Cclkb29b clkb_w29 0 0.1501f
Rclkb30 clkb_w29 clkb_w30 0.2848
Cclkb30a clkb_w29 0 0.1501f
Cclkb30b clkb_w30 0 0.1501f
Rclkb31 clkb_w30 clkb_w31 0.2848
Cclkb31a clkb_w30 0 0.1501f
Cclkb31b clkb_w31 0 0.1501f
Rclkb32 clkb_w31 clkb_w32 0.2848
Cclkb32a clkb_w31 0 0.1501f
Cclkb32b clkb_w32 0 0.1501f
Rclkb33 clkb_w32 clkb_w33 0.2848
Cclkb33a clkb_w32 0 0.1501f
Cclkb33b clkb_w33 0 0.1501f
Rclkb34 clkb_w33 clkb_w34 0.2848
Cclkb34a clkb_w33 0 0.1501f
Cclkb34b clkb_w34 0 0.1501f
Rclkb35 clkb_w34 clkb_w35 0.2848
Cclkb35a clkb_w34 0 0.1501f
Cclkb35b clkb_w35 0 0.1501f
Rclkb36 clkb_w35 clkb_w36 0.2848
Cclkb36a clkb_w35 0 0.1501f
Cclkb36b clkb_w36 0 0.1501f
Rclkb37 clkb_w36 clkb_w37 0.2848
Cclkb37a clkb_w36 0 0.1501f
Cclkb37b clkb_w37 0 0.1501f
Rclkb38 clkb_w37 clkb_w38 0.2848
Cclkb38a clkb_w37 0 0.1501f
Cclkb38b clkb_w38 0 0.1501f
Rclkb39 clkb_w38 clkb_w39 0.2848
Cclkb39a clkb_w38 0 0.1501f
Cclkb39b clkb_w39 0 0.1501f
Rclkb40 clkb_w39 clkb_w40 0.2848
Cclkb40a clkb_w39 0 0.1501f
Cclkb40b clkb_w40 0 0.1501f
Rclkb41 clkb_w40 clkb_w41 0.2848
Cclkb41a clkb_w40 0 0.1501f
Cclkb41b clkb_w41 0 0.1501f
Rclkb42 clkb_w41 clkb_w42 0.2848
Cclkb42a clkb_w41 0 0.1501f
Cclkb42b clkb_w42 0 0.1501f
Rclkb43 clkb_w42 clkb_w43 0.2848
Cclkb43a clkb_w42 0 0.1501f
Cclkb43b clkb_w43 0 0.1501f
Rclkb44 clkb_w43 clkb_w44 0.2848
Cclkb44a clkb_w43 0 0.1501f
Cclkb44b clkb_w44 0 0.1501f
Rclkb45 clkb_w44 clkb_w45 0.2848
Cclkb45a clkb_w44 0 0.1501f
Cclkb45b clkb_w45 0 0.1501f
Rclkb46 clkb_w45 clkb_w46 0.2848
Cclkb46a clkb_w45 0 0.1501f
Cclkb46b clkb_w46 0 0.1501f
Rclkb47 clkb_w46 clkb_w47 0.2848
Cclkb47a clkb_w46 0 0.1501f
Cclkb47b clkb_w47 0 0.1501f
Rclkb48 clkb_w47 clkb_w48 0.2848
Cclkb48a clkb_w47 0 0.1501f
Cclkb48b clkb_w48 0 0.1501f
Rclkb49 clkb_w48 clkb_w49 0.2848
Cclkb49a clkb_w48 0 0.1501f
Cclkb49b clkb_w49 0 0.1501f
Rclkb50 clkb_w49 clkb_w50 0.2848
Cclkb50a clkb_w49 0 0.1501f
Cclkb50b clkb_w50 0 0.1501f
Rclkb51 clkb_w50 clkb_w51 0.2848
Cclkb51a clkb_w50 0 0.1501f
Cclkb51b clkb_w51 0 0.1501f
Rclkb52 clkb_w51 clkb_w52 0.2848
Cclkb52a clkb_w51 0 0.1501f
Cclkb52b clkb_w52 0 0.1501f
Rclkb53 clkb_w52 clkb_w53 0.2848
Cclkb53a clkb_w52 0 0.1501f
Cclkb53b clkb_w53 0 0.1501f
Rclkb54 clkb_w53 clkb_w54 0.2848
Cclkb54a clkb_w53 0 0.1501f
Cclkb54b clkb_w54 0 0.1501f
Rclkb55 clkb_w54 clkb_w55 0.2848
Cclkb55a clkb_w54 0 0.1501f
Cclkb55b clkb_w55 0 0.1501f
Rclkb56 clkb_w55 clkb_w56 0.2848
Cclkb56a clkb_w55 0 0.1501f
Cclkb56b clkb_w56 0 0.1501f
Rclkb57 clkb_w56 clkb_w57 0.2848
Cclkb57a clkb_w56 0 0.1501f
Cclkb57b clkb_w57 0 0.1501f
Rclkb58 clkb_w57 clkb_w58 0.2848
Cclkb58a clkb_w57 0 0.1501f
Cclkb58b clkb_w58 0 0.1501f
Rclkb59 clkb_w58 clkb_w59 0.2848
Cclkb59a clkb_w58 0 0.1501f
Cclkb59b clkb_w59 0 0.1501f
Rclkb60 clkb_w59 clkb_w60 0.2848
Cclkb60a clkb_w59 0 0.1501f
Cclkb60b clkb_w60 0 0.1501f
Rclkb61 clkb_w60 clkb_w61 0.2848
Cclkb61a clkb_w60 0 0.1501f
Cclkb61b clkb_w61 0 0.1501f
Rclkb62 clkb_w61 clkb_w62 0.2848
Cclkb62a clkb_w61 0 0.1501f
Cclkb62b clkb_w62 0 0.1501f
Rclkb63 clkb_w62 clkb_w63 0.2848
Cclkb63a clkb_w62 0 0.1501f
Cclkb63b clkb_w63 0 0.1501f
Rclkb64 clkb_w63 clkb_w64 0.2848
Cclkb64a clkb_w63 0 0.1501f
Cclkb64b clkb_w64 0 0.1501f
Rclkb65 clkb_w64 clkb_w65 0.2848
Cclkb65a clkb_w64 0 0.1501f
Cclkb65b clkb_w65 0 0.1501f
Rclkb66 clkb_w65 clkb_w66 0.2848
Cclkb66a clkb_w65 0 0.1501f
Cclkb66b clkb_w66 0 0.1501f
Rclkb67 clkb_w66 clkb_w67 0.2848
Cclkb67a clkb_w66 0 0.1501f
Cclkb67b clkb_w67 0 0.1501f
Rclkb68 clkb_w67 clkb_w68 0.2848
Cclkb68a clkb_w67 0 0.1501f
Cclkb68b clkb_w68 0 0.1501f
Rclkb69 clkb_w68 clkb_w69 0.2848
Cclkb69a clkb_w68 0 0.1501f
Cclkb69b clkb_w69 0 0.1501f
Rclkb70 clkb_w69 clkb_w70 0.2848
Cclkb70a clkb_w69 0 0.1501f
Cclkb70b clkb_w70 0 0.1501f
Rclkb71 clkb_w70 clkb_w71 0.2848
Cclkb71a clkb_w70 0 0.1501f
Cclkb71b clkb_w71 0 0.1501f
Rclkb72 clkb_w71 clkb_w72 0.2848
Cclkb72a clkb_w71 0 0.1501f
Cclkb72b clkb_w72 0 0.1501f
Rclkb73 clkb_w72 clkb_w73 0.2848
Cclkb73a clkb_w72 0 0.1501f
Cclkb73b clkb_w73 0 0.1501f
Rclkb74 clkb_w73 clkb_w74 0.2848
Cclkb74a clkb_w73 0 0.1501f
Cclkb74b clkb_w74 0 0.1501f
Rclkb75 clkb_w74 clkb_w75 0.2848
Cclkb75a clkb_w74 0 0.1501f
Cclkb75b clkb_w75 0 0.1501f
Rclkb76 clkb_w75 clkb_w76 0.2848
Cclkb76a clkb_w75 0 0.1501f
Cclkb76b clkb_w76 0 0.1501f
Rclkb77 clkb_w76 clkb_w77 0.2848
Cclkb77a clkb_w76 0 0.1501f
Cclkb77b clkb_w77 0 0.1501f
Rclkb78 clkb_w77 clkb_w78 0.2848
Cclkb78a clkb_w77 0 0.1501f
Cclkb78b clkb_w78 0 0.1501f
Rclkb79 clkb_w78 clkb_w79 0.2848
Cclkb79a clkb_w78 0 0.1501f
Cclkb79b clkb_w79 0 0.1501f
Rclkb80 clkb_w79 clkb_w80 0.2848
Cclkb80a clkb_w79 0 0.1501f
Cclkb80b clkb_w80 0 0.1501f
Rclkb81 clkb_w80 clkb_we_t 0.2848
Cclkb81a clkb_w80 0 0.1501f
Cclkb81b clkb_we_t 0 0.1501f
Rclkb82 clkb_we_t clkb_w82 0.2696
Cclkb82a clkb_we_t 0 0.1285f
Cclkb82b clkb_w82 0 0.1285f
Rclkb83 clkb_w82 clkb_w83 0.2696
Cclkb83a clkb_w82 0 0.1285f
Cclkb83b clkb_w83 0 0.1285f
Rclkb84 clkb_w83 clkb_w84 0.2696
Cclkb84a clkb_w83 0 0.1285f
Cclkb84b clkb_w84 0 0.1285f
Rclkb85 clkb_w84 clkb_w85 0.2696
Cclkb85a clkb_w84 0 0.1285f
Cclkb85b clkb_w85 0 0.1285f
Rclkb86 clkb_w85 clkb_w86 0.2696
Cclkb86a clkb_w85 0 0.1285f
Cclkb86b clkb_w86 0 0.1285f
Rclkb87 clkb_w86 clkb_s_we 0.2696
Cclkb87a clkb_w86 0 0.1285f
Cclkb87b clkb_s_we 0 0.1285f
Rclkb88 clkb_sp clkb_w88 1.746
Cclkb88a clkb_sp 0 0.1331f
Cclkb88b clkb_w88 0 0.1331f
Rclkb89 clkb_w88 clkb_w89 1.746
Cclkb89a clkb_w88 0 0.1331f
Cclkb89b clkb_w89 0 0.1331f
Rclkb90 clkb_w89 clkb_w90 1.746
Cclkb90a clkb_w89 0 0.1331f
Cclkb90b clkb_w90 0 0.1331f
Rclkb91 clkb_w90 clkb_w91 1.746
Cclkb91a clkb_w90 0 0.1331f
Cclkb91b clkb_w91 0 0.1331f
Rclkb92 clkb_w91 clkb_w92 1.746
Cclkb92a clkb_w91 0 0.1331f
Cclkb92b clkb_w92 0 0.1331f
Rclkb93 clkb_w92 clkb_w93 1.746
Cclkb93a clkb_w92 0 0.1331f
Cclkb93b clkb_w93 0 0.1331f
Rclkb94 clkb_w93 clkb_w94 1.746
Cclkb94a clkb_w93 0 0.1331f
Cclkb94b clkb_w94 0 0.1331f
Rclkb95 clkb_w94 clkb_w95 1.746
Cclkb95a clkb_w94 0 0.1331f
Cclkb95b clkb_w95 0 0.1331f
Rclkb96 clkb_w95 clkb_y0 1.746
Cclkb96a clkb_w95 0 0.1331f
Cclkb96b clkb_y0 0 0.1331f
Rclkb97 clkb_r0 clkb_w97 0.2485
Cclkb97a clkb_r0 0 0.131f
Cclkb97b clkb_w97 0 0.131f
Rclkb98 clkb_w97 clkb_s0 8.159
Cclkb98a clkb_w97 0 0.131f
Cclkb98b clkb_s0 0 0.131f
Rclkb99 clkb_r1 clkb_w99 0.2485
Cclkb99a clkb_r1 0 0.131f
Cclkb99b clkb_w99 0 0.131f
Rclkb100 clkb_w99 clkb_s1 8.159
Cclkb100a clkb_w99 0 0.131f
Cclkb100b clkb_s1 0 0.131f
Rclkb101 clkb_r2 clkb_w101 0.2485
Cclkb101a clkb_r2 0 0.131f
Cclkb101b clkb_w101 0 0.131f
Rclkb102 clkb_w101 clkb_s2 8.159
Cclkb102a clkb_w101 0 0.131f
Cclkb102b clkb_s2 0 0.131f
Rclkb103 clkb_r3 clkb_w103 0.2485
Cclkb103a clkb_r3 0 0.131f
Cclkb103b clkb_w103 0 0.131f
Rclkb104 clkb_w103 clkb_s3 8.159
Cclkb104a clkb_w103 0 0.131f
Cclkb104b clkb_s3 0 0.131f
Rclkb105 clkb_r4 clkb_w105 0.2485
Cclkb105a clkb_r4 0 0.131f
Cclkb105b clkb_w105 0 0.131f
Rclkb106 clkb_w105 clkb_s4 8.159
Cclkb106a clkb_w105 0 0.131f
Cclkb106b clkb_s4 0 0.131f
Rclkb107 clkb_r5 clkb_w107 0.2485
Cclkb107a clkb_r5 0 0.131f
Cclkb107b clkb_w107 0 0.131f
Rclkb108 clkb_w107 clkb_s5 8.159
Cclkb108a clkb_w107 0 0.131f
Cclkb108b clkb_s5 0 0.131f
Rclkb109 clkb_r6 clkb_w109 0.2485
Cclkb109a clkb_r6 0 0.131f
Cclkb109b clkb_w109 0 0.131f
Rclkb110 clkb_w109 clkb_s6 8.159
Cclkb110a clkb_w109 0 0.131f
Cclkb110b clkb_s6 0 0.131f
Rclkb111 clkb_r7 clkb_w111 0.2485
Cclkb111a clkb_r7 0 0.131f
Cclkb111b clkb_w111 0 0.131f
Rclkb112 clkb_w111 clkb_s7 8.159
Cclkb112a clkb_w111 0 0.131f
Cclkb112b clkb_s7 0 0.131f
Rclkb113 clkb_r8 clkb_w113 0.2485
Cclkb113a clkb_r8 0 0.131f
Cclkb113b clkb_w113 0 0.131f
Rclkb114 clkb_w113 clkb_s8 8.159
Cclkb114a clkb_w113 0 0.131f
Cclkb114b clkb_s8 0 0.131f
Rclkb115 clkb_r9 clkb_w115 0.2485
Cclkb115a clkb_r9 0 0.131f
Cclkb115b clkb_w115 0 0.131f
Rclkb116 clkb_w115 clkb_s9 8.159
Cclkb116a clkb_w115 0 0.131f
Cclkb116b clkb_s9 0 0.131f
Rclkb117 clkb_r10 clkb_w117 0.2485
Cclkb117a clkb_r10 0 0.131f
Cclkb117b clkb_w117 0 0.131f
Rclkb118 clkb_w117 clkb_s10 8.159
Cclkb118a clkb_w117 0 0.131f
Cclkb118b clkb_s10 0 0.131f
Rclkb119 clkb_r11 clkb_w119 0.2485
Cclkb119a clkb_r11 0 0.131f
Cclkb119b clkb_w119 0 0.131f
Rclkb120 clkb_w119 clkb_s11 8.159
Cclkb120a clkb_w119 0 0.131f
Cclkb120b clkb_s11 0 0.131f
Rclkb121 clkb_r12 clkb_w121 0.2485
Cclkb121a clkb_r12 0 0.131f
Cclkb121b clkb_w121 0 0.131f
Rclkb122 clkb_w121 clkb_s12 8.159
Cclkb122a clkb_w121 0 0.131f
Cclkb122b clkb_s12 0 0.131f
Rclkb123 clkb_r13 clkb_w123 0.2485
Cclkb123a clkb_r13 0 0.131f
Cclkb123b clkb_w123 0 0.131f
Rclkb124 clkb_w123 clkb_s13 8.159
Cclkb124a clkb_w123 0 0.131f
Cclkb124b clkb_s13 0 0.131f
Rclkb125 clkb_r14 clkb_w125 0.2485
Cclkb125a clkb_r14 0 0.131f
Cclkb125b clkb_w125 0 0.131f
Rclkb126 clkb_w125 clkb_s14 8.159
Cclkb126a clkb_w125 0 0.131f
Cclkb126b clkb_s14 0 0.131f
Rclkb127 clkb_r15 clkb_w127 0.2485
Cclkb127a clkb_r15 0 0.131f
Cclkb127b clkb_w127 0 0.131f
Rclkb128 clkb_w127 clkb_s15 8.159
Cclkb128a clkb_w127 0 0.131f
Cclkb128b clkb_s15 0 0.131f
Rclkb129 clkb_y0 clkb_w129 0.7741
Cclkb129a clkb_y0 0 0.1309f
Cclkb129b clkb_w129 0 0.1309f
Rclkb130 clkb_w129 clkb_w130 0.7741
Cclkb130a clkb_w129 0 0.1309f
Cclkb130b clkb_w130 0 0.1309f
Rclkb131 clkb_w130 clkb_w131 0.7741
Cclkb131a clkb_w130 0 0.1309f
Cclkb131b clkb_w131 0 0.1309f
Rclkb132 clkb_w131 clkb_w132 0.7741
Cclkb132a clkb_w131 0 0.1309f
Cclkb132b clkb_w132 0 0.1309f
Rclkb133 clkb_w132 clkb_w133 0.7741
Cclkb133a clkb_w132 0 0.1309f
Cclkb133b clkb_w133 0 0.1309f
Rclkb134 clkb_w133 clkb_w134 0.7741
Cclkb134a clkb_w133 0 0.1309f
Cclkb134b clkb_w134 0 0.1309f
Rclkb135 clkb_w134 clkb_w135 0.7741
Cclkb135a clkb_w134 0 0.1309f
Cclkb135b clkb_w135 0 0.1309f
Rclkb136 clkb_w135 clkb_w136 0.7741
Cclkb136a clkb_w135 0 0.1309f
Cclkb136b clkb_w136 0 0.1309f
Rclkb137 clkb_w136 clkb_r0 0.7741
Cclkb137a clkb_w136 0 0.1309f
Cclkb137b clkb_r0 0 0.1309f
Rclkb138 clkb_r0 clkb_w138 0.625
Cclkb138a clkb_r0 0 0.1057f
Cclkb138b clkb_w138 0 0.1057f
Rclkb139 clkb_w138 clkb_r1 0.625
Cclkb139a clkb_w138 0 0.1057f
Cclkb139b clkb_r1 0 0.1057f
Rclkb140 clkb_r1 clkb_w140 0.725
Cclkb140a clkb_r1 0 0.1226f
Cclkb140b clkb_w140 0 0.1226f
Rclkb141 clkb_w140 clkb_r2 0.725
Cclkb141a clkb_w140 0 0.1226f
Cclkb141b clkb_r2 0 0.1226f
Rclkb142 clkb_r2 clkb_w142 0.625
Cclkb142a clkb_r2 0 0.1057f
Cclkb142b clkb_w142 0 0.1057f
Rclkb143 clkb_w142 clkb_r3 0.625
Cclkb143a clkb_w142 0 0.1057f
Cclkb143b clkb_r3 0 0.1057f
Rclkb144 clkb_r3 clkb_w144 0.725
Cclkb144a clkb_r3 0 0.1226f
Cclkb144b clkb_w144 0 0.1226f
Rclkb145 clkb_w144 clkb_r4 0.725
Cclkb145a clkb_w144 0 0.1226f
Cclkb145b clkb_r4 0 0.1226f
Rclkb146 clkb_r4 clkb_w146 0.625
Cclkb146a clkb_r4 0 0.1057f
Cclkb146b clkb_w146 0 0.1057f
Rclkb147 clkb_w146 clkb_r5 0.625
Cclkb147a clkb_w146 0 0.1057f
Cclkb147b clkb_r5 0 0.1057f
Rclkb148 clkb_r5 clkb_w148 0.725
Cclkb148a clkb_r5 0 0.1226f
Cclkb148b clkb_w148 0 0.1226f
Rclkb149 clkb_w148 clkb_r6 0.725
Cclkb149a clkb_w148 0 0.1226f
Cclkb149b clkb_r6 0 0.1226f
Rclkb150 clkb_r6 clkb_w150 0.625
Cclkb150a clkb_r6 0 0.1057f
Cclkb150b clkb_w150 0 0.1057f
Rclkb151 clkb_w150 clkb_r7 0.625
Cclkb151a clkb_w150 0 0.1057f
Cclkb151b clkb_r7 0 0.1057f
Rclkb152 clkb_r7 clkb_w152 0.725
Cclkb152a clkb_r7 0 0.1226f
Cclkb152b clkb_w152 0 0.1226f
Rclkb153 clkb_w152 clkb_r8 0.725
Cclkb153a clkb_w152 0 0.1226f
Cclkb153b clkb_r8 0 0.1226f
Rclkb154 clkb_r8 clkb_w154 0.625
Cclkb154a clkb_r8 0 0.1057f
Cclkb154b clkb_w154 0 0.1057f
Rclkb155 clkb_w154 clkb_r9 0.625
Cclkb155a clkb_w154 0 0.1057f
Cclkb155b clkb_r9 0 0.1057f
Rclkb156 clkb_r9 clkb_w156 0.725
Cclkb156a clkb_r9 0 0.1226f
Cclkb156b clkb_w156 0 0.1226f
Rclkb157 clkb_w156 clkb_r10 0.725
Cclkb157a clkb_w156 0 0.1226f
Cclkb157b clkb_r10 0 0.1226f
Rclkb158 clkb_r10 clkb_w158 0.625
Cclkb158a clkb_r10 0 0.1057f
Cclkb158b clkb_w158 0 0.1057f
Rclkb159 clkb_w158 clkb_r11 0.625
Cclkb159a clkb_w158 0 0.1057f
Cclkb159b clkb_r11 0 0.1057f
Rclkb160 clkb_r11 clkb_w160 0.725
Cclkb160a clkb_r11 0 0.1226f
Cclkb160b clkb_w160 0 0.1226f
Rclkb161 clkb_w160 clkb_r12 0.725
Cclkb161a clkb_w160 0 0.1226f
Cclkb161b clkb_r12 0 0.1226f
Rclkb162 clkb_r12 clkb_w162 0.625
Cclkb162a clkb_r12 0 0.1057f
Cclkb162b clkb_w162 0 0.1057f
Rclkb163 clkb_w162 clkb_r13 0.625
Cclkb163a clkb_w162 0 0.1057f
Cclkb163b clkb_r13 0 0.1057f
Rclkb164 clkb_r13 clkb_w164 0.725
Cclkb164a clkb_r13 0 0.1226f
Cclkb164b clkb_w164 0 0.1226f
Rclkb165 clkb_w164 clkb_r14 0.725
Cclkb165a clkb_w164 0 0.1226f
Cclkb165b clkb_r14 0 0.1226f
Rclkb166 clkb_r14 clkb_w166 0.625
Cclkb166a clkb_r14 0 0.1057f
Cclkb166b clkb_w166 0 0.1057f
Rclkb167 clkb_w166 clkb_r15 0.625
Cclkb167a clkb_w166 0 0.1057f
Cclkb167b clkb_r15 0 0.1057f
Rpcb1 pcb pcb_w1 0.2462
Cpcb1a pcb 0 0.1285f
Cpcb1b pcb_w1 0 0.1285f
Rpcb2 pcb_w1 pcb_w2 0.2462
Cpcb2a pcb_w1 0 0.1285f
Cpcb2b pcb_w2 0 0.1285f
Rpcb3 pcb_w2 pcb_w3 0.2462
Cpcb3a pcb_w2 0 0.1285f
Cpcb3b pcb_w3 0 0.1285f
Rpcb4 pcb_w3 pcb_w4 0.2462
Cpcb4a pcb_w3 0 0.1285f
Cpcb4b pcb_w4 0 0.1285f
Rpcb5 pcb_w4 pcb_w5 0.2462
Cpcb5a pcb_w4 0 0.1285f
Cpcb5b pcb_w5 0 0.1285f
Rpcb6 pcb_w5 pcb_w6 0.2462
Cpcb6a pcb_w5 0 0.1285f
Cpcb6b pcb_w6 0 0.1285f
Rpcb7 pcb_w6 pcb_w7 0.2462
Cpcb7a pcb_w6 0 0.1285f
Cpcb7b pcb_w7 0 0.1285f
Rpcb8 pcb_w7 pcb_w8 0.2462
Cpcb8a pcb_w7 0 0.1285f
Cpcb8b pcb_w8 0 0.1285f
Rpcb9 pcb_w8 pcb_f 0.2462
Cpcb9a pcb_w8 0 0.1285f
Cpcb9b pcb_f 0 0.1285f
Rpcb10 pcb_rs pcb_w10 0.2662
Cpcb10a pcb_rs 0 0.1491f
Cpcb10b pcb_w10 0 0.1491f
Rpcb11 pcb_w10 pcb_w11 0.2662
Cpcb11a pcb_w10 0 0.1491f
Cpcb11b pcb_w11 0 0.1491f
Rpcb12 pcb_w11 pcb_w12 0.2662
Cpcb12a pcb_w11 0 0.1491f
Cpcb12b pcb_w12 0 0.1491f
Rpcb13 pcb_w12 pcb_w13 0.2662
Cpcb13a pcb_w12 0 0.1491f
Cpcb13b pcb_w13 0 0.1491f
Rpcb14 pcb_w13 pcb_w14 0.2662
Cpcb14a pcb_w13 0 0.1491f
Cpcb14b pcb_w14 0 0.1491f
Rpcb15 pcb_w14 pcb_w15 0.2662
Cpcb15a pcb_w14 0 0.1491f
Cpcb15b pcb_w15 0 0.1491f
Rpcb16 pcb_w15 pcb_w16 0.2662
Cpcb16a pcb_w15 0 0.1491f
Cpcb16b pcb_w16 0 0.1491f
Rpcb17 pcb_w16 pcb_rw_t 0.2662
Cpcb17a pcb_w16 0 0.1491f
Cpcb17b pcb_rw_t 0 0.1491f
Rpcb18 pcb_rw_t pcb_w18 0.2846
Cpcb18a pcb_rw_t 0 0.1594f
Cpcb18b pcb_w18 0 0.1594f
Rpcb19 pcb_w18 pcb_w19 0.2846
Cpcb19a pcb_w18 0 0.1594f
Cpcb19b pcb_w19 0 0.1594f
Rpcb20 pcb_w19 pcb_w20 0.2846
Cpcb20a pcb_w19 0 0.1594f
Cpcb20b pcb_w20 0 0.1594f
Rpcb21 pcb_w20 pcb_w21 0.2846
Cpcb21a pcb_w20 0 0.1594f
Cpcb21b pcb_w21 0 0.1594f
Rpcb22 pcb_w21 pcb_w22 0.2846
Cpcb22a pcb_w21 0 0.1594f
Cpcb22b pcb_w22 0 0.1594f
Rpcb23 pcb_w22 pcb_w23 0.2846
Cpcb23a pcb_w22 0 0.1594f
Cpcb23b pcb_w23 0 0.1594f
Rpcb24 pcb_w23 pcb_w24 0.2846
Cpcb24a pcb_w23 0 0.1594f
Cpcb24b pcb_w24 0 0.1594f
Rpcb25 pcb_w24 pcb_w25 0.2846
Cpcb25a pcb_w24 0 0.1594f
Cpcb25b pcb_w25 0 0.1594f
Rpcb26 pcb_w25 pcb_w26 0.2846
Cpcb26a pcb_w25 0 0.1594f
Cpcb26b pcb_w26 0 0.1594f
Rpcb27 pcb_w26 pcb_w27 0.2846
Cpcb27a pcb_w26 0 0.1594f
Cpcb27b pcb_w27 0 0.1594f
Rpcb28 pcb_w27 pcb_w28 0.2846
Cpcb28a pcb_w27 0 0.1594f
Cpcb28b pcb_w28 0 0.1594f
Rpcb29 pcb_w28 pcb_w29 0.2846
Cpcb29a pcb_w28 0 0.1594f
Cpcb29b pcb_w29 0 0.1594f
Rpcb30 pcb_w29 pcb_w30 0.2846
Cpcb30a pcb_w29 0 0.1594f
Cpcb30b pcb_w30 0 0.1594f
Rpcb31 pcb_w30 pcb_w31 0.2846
Cpcb31a pcb_w30 0 0.1594f
Cpcb31b pcb_w31 0 0.1594f
Rpcb32 pcb_w31 pcb_w32 0.2846
Cpcb32a pcb_w31 0 0.1594f
Cpcb32b pcb_w32 0 0.1594f
Rpcb33 pcb_w32 pcb_w33 0.2846
Cpcb33a pcb_w32 0 0.1594f
Cpcb33b pcb_w33 0 0.1594f
Rpcb34 pcb_w33 pcb_w34 0.2846
Cpcb34a pcb_w33 0 0.1594f
Cpcb34b pcb_w34 0 0.1594f
Rpcb35 pcb_w34 pcb_w35 0.2846
Cpcb35a pcb_w34 0 0.1594f
Cpcb35b pcb_w35 0 0.1594f
Rpcb36 pcb_w35 pcb_w36 0.2846
Cpcb36a pcb_w35 0 0.1594f
Cpcb36b pcb_w36 0 0.1594f
Rpcb37 pcb_w36 pcb_w37 0.2846
Cpcb37a pcb_w36 0 0.1594f
Cpcb37b pcb_w37 0 0.1594f
Rpcb38 pcb_w37 pcb_w38 0.2846
Cpcb38a pcb_w37 0 0.1594f
Cpcb38b pcb_w38 0 0.1594f
Rpcb39 pcb_w38 pcb_w39 0.2846
Cpcb39a pcb_w38 0 0.1594f
Cpcb39b pcb_w39 0 0.1594f
Rpcb40 pcb_w39 pcb_w40 0.2846
Cpcb40a pcb_w39 0 0.1594f
Cpcb40b pcb_w40 0 0.1594f
Rpcb41 pcb_w40 pcb_f 0.2846
Cpcb41a pcb_w40 0 0.1594f
Cpcb41b pcb_f 0 0.1594f
Rpcb42 pcb_rw_t pcb_w42 1.654
Cpcb42a pcb_rw_t 0 0.124f
Cpcb42b pcb_w42 0 0.124f
Rpcb43 pcb_w42 pcb_w43 1.654
Cpcb43a pcb_w42 0 0.124f
Cpcb43b pcb_w43 0 0.124f
Rpcb44 pcb_w43 pcb_w44 1.654
Cpcb44a pcb_w43 0 0.124f
Cpcb44b pcb_w44 0 0.124f
Rpcb45 pcb_w44 pcb_w45 1.654
Cpcb45a pcb_w44 0 0.124f
Cpcb45b pcb_w45 0 0.124f
Rpcb46 pcb_w45 pcb_s_rw 9.564
Cpcb46a pcb_w45 0 0.124f
Cpcb46b pcb_s_rw 0 0.124f
Rpcb47 pcb_rs pcb_w47 0.8262
Cpcb47a pcb_rs 0 0.1485f
Cpcb47b pcb_w47 0 0.1485f
Rpcb48 pcb_w47 pcb_w48 0.8262
Cpcb48a pcb_w47 0 0.1485f
Cpcb48b pcb_w48 0 0.1485f
Rpcb49 pcb_w48 pcb_w49 0.8262
Cpcb49a pcb_w48 0 0.1485f
Cpcb49b pcb_w49 0 0.1485f
Rpcb50 pcb_w49 pcb_w50 0.8262
Cpcb50a pcb_w49 0 0.1485f
Cpcb50b pcb_w50 0 0.1485f
Rpcb51 pcb_w50 pcb_w51 0.8262
Cpcb51a pcb_w50 0 0.1485f
Cpcb51b pcb_w51 0 0.1485f
Rpcb52 pcb_w51 pcb_w52 0.8262
Cpcb52a pcb_w51 0 0.1485f
Cpcb52b pcb_w52 0 0.1485f
Rpcb53 pcb_w52 pcb_w53 0.8262
Cpcb53a pcb_w52 0 0.1485f
Cpcb53b pcb_w53 0 0.1485f
Rpcb54 pcb_w53 pcb_w54 0.8262
Cpcb54a pcb_w53 0 0.1485f
Cpcb54b pcb_w54 0 0.1485f
Rpcb55 pcb_w54 pcb_w55 0.8262
Cpcb55a pcb_w54 0 0.1485f
Cpcb55b pcb_w55 0 0.1485f
Rpcb56 pcb_w55 pcb_w56 0.8262
Cpcb56a pcb_w55 0 0.1485f
Cpcb56b pcb_w56 0 0.1485f
Rpcb57 pcb_w56 pcb_w57 0.8262
Cpcb57a pcb_w56 0 0.1485f
Cpcb57b pcb_w57 0 0.1485f
Rpcb58 pcb_w57 pcb_w58 0.8262
Cpcb58a pcb_w57 0 0.1485f
Cpcb58b pcb_w58 0 0.1485f
Rpcb59 pcb_w58 pcb_w59 0.8262
Cpcb59a pcb_w58 0 0.1485f
Cpcb59b pcb_w59 0 0.1485f
Rpcb60 pcb_w59 pcb_w60 0.8262
Cpcb60a pcb_w59 0 0.1485f
Cpcb60b pcb_w60 0 0.1485f
Rpcb61 pcb_w60 pcb_w61 0.8262
Cpcb61a pcb_w60 0 0.1485f
Cpcb61b pcb_w61 0 0.1485f
Rpcb62 pcb_w61 pcb_w62 0.8262
Cpcb62a pcb_w61 0 0.1485f
Cpcb62b pcb_w62 0 0.1485f
Rpcb63 pcb_w62 pcb_w63 0.8262
Cpcb63a pcb_w62 0 0.1485f
Cpcb63b pcb_w63 0 0.1485f
Rpcb64 pcb_w63 pcb_w64 0.8262
Cpcb64a pcb_w63 0 0.1485f
Cpcb64b pcb_w64 0 0.1485f
Rpcb65 pcb_w64 pcb_w65 0.8262
Cpcb65a pcb_w64 0 0.1485f
Cpcb65b pcb_w65 0 0.1485f
Rpcb66 pcb_w65 pcb_w66 0.8262
Cpcb66a pcb_w65 0 0.1485f
Cpcb66b pcb_w66 0 0.1485f
Rpcb67 pcb_w66 pcb_w67 0.8262
Cpcb67a pcb_w66 0 0.1485f
Cpcb67b pcb_w67 0 0.1485f
Rpcb68 pcb_w67 pcb_w68 0.8262
Cpcb68a pcb_w67 0 0.1485f
Cpcb68b pcb_w68 0 0.1485f
Rpcb69 pcb_w68 pcb_w69 0.8262
Cpcb69a pcb_w68 0 0.1485f
Cpcb69b pcb_w69 0 0.1485f
Rpcb70 pcb_w69 pcb_w70 0.8262
Cpcb70a pcb_w69 0 0.1485f
Cpcb70b pcb_w70 0 0.1485f
Rpcb71 pcb_w70 pcb_w71 0.8262
Cpcb71a pcb_w70 0 0.1485f
Cpcb71b pcb_w71 0 0.1485f
Rpcb72 pcb_w71 pcb_w72 0.8262
Cpcb72a pcb_w71 0 0.1485f
Cpcb72b pcb_w72 0 0.1485f
Rpcb73 pcb_w72 pcb_w73 0.8262
Cpcb73a pcb_w72 0 0.1485f
Cpcb73b pcb_w73 0 0.1485f
Rpcb74 pcb_w73 pcb_w74 0.8262
Cpcb74a pcb_w73 0 0.1485f
Cpcb74b pcb_w74 0 0.1485f
Rpcb75 pcb_w74 pcb_w75 0.8262
Cpcb75a pcb_w74 0 0.1485f
Cpcb75b pcb_w75 0 0.1485f
Rpcb76 pcb_w75 pcb_w76 0.8262
Cpcb76a pcb_w75 0 0.1485f
Cpcb76b pcb_w76 0 0.1485f
Rpcb77 pcb_w76 pcb_w77 0.8262
Cpcb77a pcb_w76 0 0.1485f
Cpcb77b pcb_w77 0 0.1485f
Rpcb78 pcb_w77 pcb_w78 0.8262
Cpcb78a pcb_w77 0 0.1485f
Cpcb78b pcb_w78 0 0.1485f
Rpcb79 pcb_w78 pcb_w79 0.8262
Cpcb79a pcb_w78 0 0.1485f
Cpcb79b pcb_w79 0 0.1485f
Rpcb80 pcb_w79 pcb_w80 0.8262
Cpcb80a pcb_w79 0 0.1485f
Cpcb80b pcb_w80 0 0.1485f
Rpcb81 pcb_w80 pcb_w81 0.8262
Cpcb81a pcb_w80 0 0.1485f
Cpcb81b pcb_w81 0 0.1485f
Rpcb82 pcb_w81 pcb_w82 0.8262
Cpcb82a pcb_w81 0 0.1485f
Cpcb82b pcb_w82 0 0.1485f
Rpcb83 pcb_w82 pcb_w83 0.8262
Cpcb83a pcb_w82 0 0.1485f
Cpcb83b pcb_w83 0 0.1485f
Rpcb84 pcb_w83 pcb_w84 0.8262
Cpcb84a pcb_w83 0 0.1485f
Cpcb84b pcb_w84 0 0.1485f
Rpcb85 pcb_w84 pcb_w85 0.8262
Cpcb85a pcb_w84 0 0.1485f
Cpcb85b pcb_w85 0 0.1485f
Rpcb86 pcb_w85 pcb_w86 0.8262
Cpcb86a pcb_w85 0 0.1485f
Cpcb86b pcb_w86 0 0.1485f
Rpcb87 pcb_w86 pcb_b0 0.8262
Cpcb87a pcb_w86 0 0.1485f
Cpcb87b pcb_b0 0 0.1485f
Rpcb88 pcb_c0 pcb_s0 8.118
Cpcb88a pcb_c0 0 0.03743f
Cpcb88b pcb_s0 0 0.03743f
Rpcb89 pcb_c1 pcb_s1 8.118
Cpcb89a pcb_c1 0 0.03743f
Cpcb89b pcb_s1 0 0.03743f
Rpcb90 pcb_c2 pcb_s2 8.118
Cpcb90a pcb_c2 0 0.03743f
Cpcb90b pcb_s2 0 0.03743f
Rpcb91 pcb_c3 pcb_s3 8.118
Cpcb91a pcb_c3 0 0.03743f
Cpcb91b pcb_s3 0 0.03743f
Rpcb92 pcb_c4 pcb_s4 8.118
Cpcb92a pcb_c4 0 0.03743f
Cpcb92b pcb_s4 0 0.03743f
Rpcb93 pcb_c5 pcb_s5 8.118
Cpcb93a pcb_c5 0 0.03743f
Cpcb93b pcb_s5 0 0.03743f
Rpcb94 pcb_c6 pcb_s6 8.118
Cpcb94a pcb_c6 0 0.03743f
Cpcb94b pcb_s6 0 0.03743f
Rpcb95 pcb_c7 pcb_s7 8.118
Cpcb95a pcb_c7 0 0.03743f
Cpcb95b pcb_s7 0 0.03743f
Rpcb96 pcb_c8 pcb_s8 8.118
Cpcb96a pcb_c8 0 0.03743f
Cpcb96b pcb_s8 0 0.03743f
Rpcb97 pcb_c9 pcb_s9 8.118
Cpcb97a pcb_c9 0 0.03743f
Cpcb97b pcb_s9 0 0.03743f
Rpcb98 pcb_c10 pcb_s10 8.118
Cpcb98a pcb_c10 0 0.03743f
Cpcb98b pcb_s10 0 0.03743f
Rpcb99 pcb_c11 pcb_s11 8.118
Cpcb99a pcb_c11 0 0.03743f
Cpcb99b pcb_s11 0 0.03743f
Rpcb100 pcb_c12 pcb_s12 8.118
Cpcb100a pcb_c12 0 0.03743f
Cpcb100b pcb_s12 0 0.03743f
Rpcb101 pcb_c13 pcb_s13 8.118
Cpcb101a pcb_c13 0 0.03743f
Cpcb101b pcb_s13 0 0.03743f
Rpcb102 pcb_c14 pcb_s14 8.118
Cpcb102a pcb_c14 0 0.03743f
Cpcb102b pcb_s14 0 0.03743f
Rpcb103 pcb_c15 pcb_s15 8.118
Cpcb103a pcb_c15 0 0.03743f
Cpcb103b pcb_s15 0 0.03743f
Rpcb104 pcb_b0 pcb_w104 0.2571
Cpcb104a pcb_b0 0 0.144f
Cpcb104b pcb_w104 0 0.144f
Rpcb105 pcb_w104 pcb_w105 0.2571
Cpcb105a pcb_w104 0 0.144f
Cpcb105b pcb_w105 0 0.144f
Rpcb106 pcb_w105 pcb_w106 0.2571
Cpcb106a pcb_w105 0 0.144f
Cpcb106b pcb_w106 0 0.144f
Rpcb107 pcb_w106 pcb_w107 0.2571
Cpcb107a pcb_w106 0 0.144f
Cpcb107b pcb_w107 0 0.144f
Rpcb108 pcb_w107 pcb_w108 0.2571
Cpcb108a pcb_w107 0 0.144f
Cpcb108b pcb_w108 0 0.144f
Rpcb109 pcb_w108 pcb_w109 0.2571
Cpcb109a pcb_w108 0 0.144f
Cpcb109b pcb_w109 0 0.144f
Rpcb110 pcb_w109 pcb_w110 0.2571
Cpcb110a pcb_w109 0 0.144f
Cpcb110b pcb_w110 0 0.144f
Rpcb111 pcb_w110 pcb_c0 0.2571
Cpcb111a pcb_w110 0 0.144f
Cpcb111b pcb_c0 0 0.144f
Rpcb112 pcb_c0 pcb_w112 0.2421
Cpcb112a pcb_c0 0 0.1356f
Cpcb112b pcb_w112 0 0.1356f
Rpcb113 pcb_w112 pcb_c1 0.2421
Cpcb113a pcb_w112 0 0.1356f
Cpcb113b pcb_c1 0 0.1356f
Rpcb114 pcb_c1 pcb_w114 0.2421
Cpcb114a pcb_c1 0 0.1356f
Cpcb114b pcb_w114 0 0.1356f
Rpcb115 pcb_w114 pcb_c2 0.2421
Cpcb115a pcb_w114 0 0.1356f
Cpcb115b pcb_c2 0 0.1356f
Rpcb116 pcb_c2 pcb_w116 0.2421
Cpcb116a pcb_c2 0 0.1356f
Cpcb116b pcb_w116 0 0.1356f
Rpcb117 pcb_w116 pcb_c3 0.2421
Cpcb117a pcb_w116 0 0.1356f
Cpcb117b pcb_c3 0 0.1356f
Rpcb118 pcb_c3 pcb_w118 0.2421
Cpcb118a pcb_c3 0 0.1356f
Cpcb118b pcb_w118 0 0.1356f
Rpcb119 pcb_w118 pcb_c4 0.2421
Cpcb119a pcb_w118 0 0.1356f
Cpcb119b pcb_c4 0 0.1356f
Rpcb120 pcb_c4 pcb_w120 0.2421
Cpcb120a pcb_c4 0 0.1356f
Cpcb120b pcb_w120 0 0.1356f
Rpcb121 pcb_w120 pcb_c5 0.2421
Cpcb121a pcb_w120 0 0.1356f
Cpcb121b pcb_c5 0 0.1356f
Rpcb122 pcb_c5 pcb_w122 0.2421
Cpcb122a pcb_c5 0 0.1356f
Cpcb122b pcb_w122 0 0.1356f
Rpcb123 pcb_w122 pcb_c6 0.2421
Cpcb123a pcb_w122 0 0.1356f
Cpcb123b pcb_c6 0 0.1356f
Rpcb124 pcb_c6 pcb_w124 0.2421
Cpcb124a pcb_c6 0 0.1356f
Cpcb124b pcb_w124 0 0.1356f
Rpcb125 pcb_w124 pcb_c7 0.2421
Cpcb125a pcb_w124 0 0.1356f
Cpcb125b pcb_c7 0 0.1356f
Rpcb126 pcb_c7 pcb_w126 0.2421
Cpcb126a pcb_c7 0 0.1356f
Cpcb126b pcb_w126 0 0.1356f
Rpcb127 pcb_w126 pcb_c8 0.2421
Cpcb127a pcb_w126 0 0.1356f
Cpcb127b pcb_c8 0 0.1356f
Rpcb128 pcb_c8 pcb_w128 0.2421
Cpcb128a pcb_c8 0 0.1356f
Cpcb128b pcb_w128 0 0.1356f
Rpcb129 pcb_w128 pcb_c9 0.2421
Cpcb129a pcb_w128 0 0.1356f
Cpcb129b pcb_c9 0 0.1356f
Rpcb130 pcb_c9 pcb_w130 0.2421
Cpcb130a pcb_c9 0 0.1356f
Cpcb130b pcb_w130 0 0.1356f
Rpcb131 pcb_w130 pcb_c10 0.2421
Cpcb131a pcb_w130 0 0.1356f
Cpcb131b pcb_c10 0 0.1356f
Rpcb132 pcb_c10 pcb_w132 0.2421
Cpcb132a pcb_c10 0 0.1356f
Cpcb132b pcb_w132 0 0.1356f
Rpcb133 pcb_w132 pcb_c11 0.2421
Cpcb133a pcb_w132 0 0.1356f
Cpcb133b pcb_c11 0 0.1356f
Rpcb134 pcb_c11 pcb_w134 0.2421
Cpcb134a pcb_c11 0 0.1356f
Cpcb134b pcb_w134 0 0.1356f
Rpcb135 pcb_w134 pcb_c12 0.2421
Cpcb135a pcb_w134 0 0.1356f
Cpcb135b pcb_c12 0 0.1356f
Rpcb136 pcb_c12 pcb_w136 0.2421
Cpcb136a pcb_c12 0 0.1356f
Cpcb136b pcb_w136 0 0.1356f
Rpcb137 pcb_w136 pcb_c13 0.2421
Cpcb137a pcb_w136 0 0.1356f
Cpcb137b pcb_c13 0 0.1356f
Rpcb138 pcb_c13 pcb_w138 0.2421
Cpcb138a pcb_c13 0 0.1356f
Cpcb138b pcb_w138 0 0.1356f
Rpcb139 pcb_w138 pcb_c14 0.2421
Cpcb139a pcb_w138 0 0.1356f
Cpcb139b pcb_c14 0 0.1356f
Rpcb140 pcb_c14 pcb_w140 0.2421
Cpcb140a pcb_c14 0 0.1356f
Cpcb140b pcb_w140 0 0.1356f
Rpcb141 pcb_w140 pcb_c15 0.2421
Cpcb141a pcb_w140 0 0.1356f
Cpcb141b pcb_c15 0 0.1356f
.control
set wr_singlescale
set wr_vecnames
run
wrdata ct_rand64_1.4ns.dat v(CLK) v(ADDR) v(RW) v(DIN) v(DOUT) v(xdut.rdqb) v(xdut.rd) v(xdut.dl) v(xdut.dlb) v(xdut.pcb) v(xdut.clkb) v(xdut.we) v(xdut.wl0) v(xdut.wl15) v(xdut.bl0) v(xdut.blb0) v(xdut.bl15) v(xdut.blb15) v(xdut.xc_0_0.q) v(xdut.xc_15_15.q) i(Vdd) i(Vddio) v(xdut.clk_ff)
.endc
.ends sram256
Vdd vdd 0 1.8
Vddio vddio 0 1.8
Vclk clk_src 0 PULSE(0 1.8 7.0000e-10 5.00e-11 5.00e-11 6.5000e-10 1.4000e-09)
Rclk clk_src CLK 50
Vaddr ADDR_src 0 PWL(0.0000e+00 0.00 1.4000e-09 0.00 1.4500e-09 1.80 2.8000e-09 1.80 2.8500e-09 0.00 7.0000e-09 0.00 7.0500e-09 1.80 1.2600e-08 1.80 1.2650e-08 0.00 1.4000e-08 0.00 1.4050e-08 1.80 1.6800e-08 1.80 1.6850e-08 0.00 1.8200e-08 0.00 1.8250e-08 1.80 1.9600e-08 1.80 1.9650e-08 0.00 2.5200e-08 0.00 2.5250e-08 1.80 2.9400e-08 1.80 2.9450e-08 0.00 3.0800e-08 0.00 3.0850e-08 1.80 3.2200e-08 1.80 3.2250e-08 0.00 3.3600e-08 0.00 3.3650e-08 1.80 3.5000e-08 1.80 3.5050e-08 0.00 3.6400e-08 0.00 3.6450e-08 1.80 3.7800e-08 1.80 3.7850e-08 0.00 3.9200e-08 0.00 3.9250e-08 1.80 4.0600e-08 1.80 4.0650e-08 0.00 4.4800e-08 0.00 4.4850e-08 1.80 4.7600e-08 1.80 4.7650e-08 0.00 4.9000e-08 0.00 4.9050e-08 1.80 5.1800e-08 1.80 5.1850e-08 0.00 5.7400e-08 0.00 5.7450e-08 1.80 6.0200e-08 1.80 6.0250e-08 0.00 6.4400e-08 0.00 6.4450e-08 1.80 6.5800e-08 1.80 6.5850e-08 0.00 6.8600e-08 0.00 6.8650e-08 1.80 7.0000e-08 1.80 7.0050e-08 0.00 7.1400e-08 0.00 7.1450e-08 1.80 7.2800e-08 1.80 7.2850e-08 0.00 7.4200e-08 0.00 7.4250e-08 1.80 7.5600e-08 1.80 7.5650e-08 0.00 7.7000e-08 0.00 7.7050e-08 1.80 7.8400e-08 1.80 7.8450e-08 0.00 7.9800e-08 0.00 7.9850e-08 1.80 8.1200e-08 1.80 8.1250e-08 0.00 8.5400e-08 0.00 8.5450e-08 1.80 8.9600e-08 1.80 8.9650e-08 0.00)
Raddr ADDR_src ADDR 50
Vrw RW_src 0 PWL(0.0000e+00 0.00 2.9400e-08 0.00 2.9450e-08 1.80 3.0800e-08 1.80 3.0850e-08 0.00 3.2200e-08 0.00 3.2250e-08 1.80 3.3600e-08 1.80 3.3650e-08 0.00 3.5000e-08 0.00 3.5050e-08 1.80 3.7800e-08 1.80 3.7850e-08 0.00 4.4800e-08 0.00 4.4850e-08 1.80 4.6200e-08 1.80 4.6250e-08 0.00 4.7600e-08 0.00 4.7650e-08 1.80 4.9000e-08 1.80 4.9050e-08 0.00 5.6000e-08 0.00 5.6050e-08 1.80 6.0200e-08 1.80 6.0250e-08 0.00 6.1600e-08 0.00 6.1650e-08 1.80 6.5800e-08 1.80 6.5850e-08 0.00 6.7200e-08 0.00 6.7250e-08 1.80 6.8600e-08 1.80 6.8650e-08 0.00 7.2800e-08 0.00 7.2850e-08 1.80 7.5600e-08 1.80 7.5650e-08 0.00 8.1200e-08 0.00 8.1250e-08 1.80 8.2600e-08 1.80 8.2650e-08 0.00)
Rrw RW_src RW 50
Vdin DIN_src 0 PWL(0.0000e+00 1.80 1.4000e-09 1.80 1.4500e-09 0.00 8.4000e-09 0.00 8.4500e-09 1.80 1.2600e-08 1.80 1.2650e-08 0.00 1.4000e-08 0.00 1.4050e-08 1.80 1.6800e-08 1.80 1.6850e-08 0.00 1.8200e-08 0.00 1.8250e-08 1.80 2.2400e-08 1.80 2.2450e-08 0.00 2.6600e-08 0.00 2.6650e-08 1.80 2.9400e-08 1.80 2.9450e-08 0.00 3.0800e-08 0.00 3.0850e-08 1.80 3.3600e-08 1.80 3.3650e-08 0.00 3.6400e-08 0.00 3.6450e-08 1.80 4.0600e-08 1.80 4.0650e-08 0.00 4.4800e-08 0.00 4.4850e-08 1.80 4.9000e-08 1.80 4.9050e-08 0.00 5.1800e-08 0.00 5.1850e-08 1.80 5.4600e-08 1.80 5.4650e-08 0.00 5.8800e-08 0.00 5.8850e-08 1.80 6.1600e-08 1.80 6.1650e-08 0.00 6.3000e-08 0.00 6.3050e-08 1.80 6.4400e-08 1.80 6.4450e-08 0.00 6.5800e-08 0.00 6.5850e-08 1.80 6.7200e-08 1.80 6.7250e-08 0.00 6.8600e-08 0.00 6.8650e-08 1.80 7.2800e-08 1.80 7.2850e-08 0.00 7.8400e-08 0.00 7.8450e-08 1.80 7.9800e-08 1.80 7.9850e-08 0.00 8.1200e-08 0.00 8.1250e-08 1.80 8.4000e-08 1.80 8.4050e-08 0.00 8.5400e-08 0.00 8.5450e-08 1.80 8.8200e-08 1.80 8.8250e-08 0.00)
Rdin DIN_src DIN 50
Cload DOUT 0 5.000e-12
Xdut CLK ADDR RW DIN DOUT vdd vddio 0 sram256
.ic v(xdut.xc_0_0.q)=1.8 v(xdut.xc_0_0.qb)=0.0 v(xdut.xc_0_1.q)=1.8 v(xdut.xc_0_1.qb)=0.0 v(xdut.xc_0_2.q)=0.0 v(xdut.xc_0_2.qb)=1.8 v(xdut.xc_0_3.q)=0.0 v(xdut.xc_0_3.qb)=1.8 v(xdut.xc_0_4.q)=0.0 v(xdut.xc_0_4.qb)=1.8 v(xdut.xc_0_5.q)=0.0 v(xdut.xc_0_5.qb)=1.8 v(xdut.xc_0_6.q)=0.0 v(xdut.xc_0_6.qb)=1.8 v(xdut.xc_0_7.q)=0.0 v(xdut.xc_0_7.qb)=1.8
.ic v(xdut.xc_0_8.q)=1.8 v(xdut.xc_0_8.qb)=0.0 v(xdut.xc_0_9.q)=1.8 v(xdut.xc_0_9.qb)=0.0 v(xdut.xc_0_10.q)=0.0 v(xdut.xc_0_10.qb)=1.8 v(xdut.xc_0_11.q)=1.8 v(xdut.xc_0_11.qb)=0.0 v(xdut.xc_0_12.q)=0.0 v(xdut.xc_0_12.qb)=1.8 v(xdut.xc_0_13.q)=1.8 v(xdut.xc_0_13.qb)=0.0 v(xdut.xc_0_14.q)=0.0 v(xdut.xc_0_14.qb)=1.8 v(xdut.xc_0_15.q)=1.8 v(xdut.xc_0_15.qb)=0.0
.ic v(xdut.xc_1_0.q)=1.8 v(xdut.xc_1_0.qb)=0.0 v(xdut.xc_1_1.q)=0.0 v(xdut.xc_1_1.qb)=1.8 v(xdut.xc_1_2.q)=0.0 v(xdut.xc_1_2.qb)=1.8 v(xdut.xc_1_3.q)=1.8 v(xdut.xc_1_3.qb)=0.0 v(xdut.xc_1_4.q)=0.0 v(xdut.xc_1_4.qb)=1.8 v(xdut.xc_1_5.q)=1.8 v(xdut.xc_1_5.qb)=0.0 v(xdut.xc_1_6.q)=0.0 v(xdut.xc_1_6.qb)=1.8 v(xdut.xc_1_7.q)=0.0 v(xdut.xc_1_7.qb)=1.8
.ic v(xdut.xc_1_8.q)=1.8 v(xdut.xc_1_8.qb)=0.0 v(xdut.xc_1_9.q)=1.8 v(xdut.xc_1_9.qb)=0.0 v(xdut.xc_1_10.q)=1.8 v(xdut.xc_1_10.qb)=0.0 v(xdut.xc_1_11.q)=0.0 v(xdut.xc_1_11.qb)=1.8 v(xdut.xc_1_12.q)=1.8 v(xdut.xc_1_12.qb)=0.0 v(xdut.xc_1_13.q)=0.0 v(xdut.xc_1_13.qb)=1.8 v(xdut.xc_1_14.q)=1.8 v(xdut.xc_1_14.qb)=0.0 v(xdut.xc_1_15.q)=0.0 v(xdut.xc_1_15.qb)=1.8
.ic v(xdut.xc_2_0.q)=1.8 v(xdut.xc_2_0.qb)=0.0 v(xdut.xc_2_1.q)=0.0 v(xdut.xc_2_1.qb)=1.8 v(xdut.xc_2_2.q)=1.8 v(xdut.xc_2_2.qb)=0.0 v(xdut.xc_2_3.q)=0.0 v(xdut.xc_2_3.qb)=1.8 v(xdut.xc_2_4.q)=1.8 v(xdut.xc_2_4.qb)=0.0 v(xdut.xc_2_5.q)=0.0 v(xdut.xc_2_5.qb)=1.8 v(xdut.xc_2_6.q)=1.8 v(xdut.xc_2_6.qb)=0.0 v(xdut.xc_2_7.q)=0.0 v(xdut.xc_2_7.qb)=1.8
.ic v(xdut.xc_2_8.q)=0.0 v(xdut.xc_2_8.qb)=1.8 v(xdut.xc_2_9.q)=0.0 v(xdut.xc_2_9.qb)=1.8 v(xdut.xc_2_10.q)=1.8 v(xdut.xc_2_10.qb)=0.0 v(xdut.xc_2_11.q)=0.0 v(xdut.xc_2_11.qb)=1.8 v(xdut.xc_2_12.q)=0.0 v(xdut.xc_2_12.qb)=1.8 v(xdut.xc_2_13.q)=0.0 v(xdut.xc_2_13.qb)=1.8 v(xdut.xc_2_14.q)=0.0 v(xdut.xc_2_14.qb)=1.8 v(xdut.xc_2_15.q)=0.0 v(xdut.xc_2_15.qb)=1.8
.ic v(xdut.xc_3_0.q)=0.0 v(xdut.xc_3_0.qb)=1.8 v(xdut.xc_3_1.q)=1.8 v(xdut.xc_3_1.qb)=0.0 v(xdut.xc_3_2.q)=1.8 v(xdut.xc_3_2.qb)=0.0 v(xdut.xc_3_3.q)=0.0 v(xdut.xc_3_3.qb)=1.8 v(xdut.xc_3_4.q)=1.8 v(xdut.xc_3_4.qb)=0.0 v(xdut.xc_3_5.q)=0.0 v(xdut.xc_3_5.qb)=1.8 v(xdut.xc_3_6.q)=0.0 v(xdut.xc_3_6.qb)=1.8 v(xdut.xc_3_7.q)=1.8 v(xdut.xc_3_7.qb)=0.0
.ic v(xdut.xc_3_8.q)=0.0 v(xdut.xc_3_8.qb)=1.8 v(xdut.xc_3_9.q)=1.8 v(xdut.xc_3_9.qb)=0.0 v(xdut.xc_3_10.q)=1.8 v(xdut.xc_3_10.qb)=0.0 v(xdut.xc_3_11.q)=0.0 v(xdut.xc_3_11.qb)=1.8 v(xdut.xc_3_12.q)=1.8 v(xdut.xc_3_12.qb)=0.0 v(xdut.xc_3_13.q)=0.0 v(xdut.xc_3_13.qb)=1.8 v(xdut.xc_3_14.q)=0.0 v(xdut.xc_3_14.qb)=1.8 v(xdut.xc_3_15.q)=0.0 v(xdut.xc_3_15.qb)=1.8
.ic v(xdut.xc_4_0.q)=1.8 v(xdut.xc_4_0.qb)=0.0 v(xdut.xc_4_1.q)=1.8 v(xdut.xc_4_1.qb)=0.0 v(xdut.xc_4_2.q)=1.8 v(xdut.xc_4_2.qb)=0.0 v(xdut.xc_4_3.q)=0.0 v(xdut.xc_4_3.qb)=1.8 v(xdut.xc_4_4.q)=1.8 v(xdut.xc_4_4.qb)=0.0 v(xdut.xc_4_5.q)=1.8 v(xdut.xc_4_5.qb)=0.0 v(xdut.xc_4_6.q)=0.0 v(xdut.xc_4_6.qb)=1.8 v(xdut.xc_4_7.q)=0.0 v(xdut.xc_4_7.qb)=1.8
.ic v(xdut.xc_4_8.q)=0.0 v(xdut.xc_4_8.qb)=1.8 v(xdut.xc_4_9.q)=1.8 v(xdut.xc_4_9.qb)=0.0 v(xdut.xc_4_10.q)=0.0 v(xdut.xc_4_10.qb)=1.8 v(xdut.xc_4_11.q)=0.0 v(xdut.xc_4_11.qb)=1.8 v(xdut.xc_4_12.q)=0.0 v(xdut.xc_4_12.qb)=1.8 v(xdut.xc_4_13.q)=0.0 v(xdut.xc_4_13.qb)=1.8 v(xdut.xc_4_14.q)=1.8 v(xdut.xc_4_14.qb)=0.0 v(xdut.xc_4_15.q)=0.0 v(xdut.xc_4_15.qb)=1.8
.ic v(xdut.xc_5_0.q)=0.0 v(xdut.xc_5_0.qb)=1.8 v(xdut.xc_5_1.q)=1.8 v(xdut.xc_5_1.qb)=0.0 v(xdut.xc_5_2.q)=0.0 v(xdut.xc_5_2.qb)=1.8 v(xdut.xc_5_3.q)=0.0 v(xdut.xc_5_3.qb)=1.8 v(xdut.xc_5_4.q)=1.8 v(xdut.xc_5_4.qb)=0.0 v(xdut.xc_5_5.q)=1.8 v(xdut.xc_5_5.qb)=0.0 v(xdut.xc_5_6.q)=0.0 v(xdut.xc_5_6.qb)=1.8 v(xdut.xc_5_7.q)=1.8 v(xdut.xc_5_7.qb)=0.0
.ic v(xdut.xc_5_8.q)=0.0 v(xdut.xc_5_8.qb)=1.8 v(xdut.xc_5_9.q)=1.8 v(xdut.xc_5_9.qb)=0.0 v(xdut.xc_5_10.q)=0.0 v(xdut.xc_5_10.qb)=1.8 v(xdut.xc_5_11.q)=0.0 v(xdut.xc_5_11.qb)=1.8 v(xdut.xc_5_12.q)=1.8 v(xdut.xc_5_12.qb)=0.0 v(xdut.xc_5_13.q)=0.0 v(xdut.xc_5_13.qb)=1.8 v(xdut.xc_5_14.q)=0.0 v(xdut.xc_5_14.qb)=1.8 v(xdut.xc_5_15.q)=1.8 v(xdut.xc_5_15.qb)=0.0
.ic v(xdut.xc_6_0.q)=0.0 v(xdut.xc_6_0.qb)=1.8 v(xdut.xc_6_1.q)=1.8 v(xdut.xc_6_1.qb)=0.0 v(xdut.xc_6_2.q)=1.8 v(xdut.xc_6_2.qb)=0.0 v(xdut.xc_6_3.q)=1.8 v(xdut.xc_6_3.qb)=0.0 v(xdut.xc_6_4.q)=1.8 v(xdut.xc_6_4.qb)=0.0 v(xdut.xc_6_5.q)=1.8 v(xdut.xc_6_5.qb)=0.0 v(xdut.xc_6_6.q)=1.8 v(xdut.xc_6_6.qb)=0.0 v(xdut.xc_6_7.q)=1.8 v(xdut.xc_6_7.qb)=0.0
.ic v(xdut.xc_6_8.q)=0.0 v(xdut.xc_6_8.qb)=1.8 v(xdut.xc_6_9.q)=0.0 v(xdut.xc_6_9.qb)=1.8 v(xdut.xc_6_10.q)=0.0 v(xdut.xc_6_10.qb)=1.8 v(xdut.xc_6_11.q)=1.8 v(xdut.xc_6_11.qb)=0.0 v(xdut.xc_6_12.q)=1.8 v(xdut.xc_6_12.qb)=0.0 v(xdut.xc_6_13.q)=1.8 v(xdut.xc_6_13.qb)=0.0 v(xdut.xc_6_14.q)=0.0 v(xdut.xc_6_14.qb)=1.8 v(xdut.xc_6_15.q)=1.8 v(xdut.xc_6_15.qb)=0.0
.ic v(xdut.xc_7_0.q)=0.0 v(xdut.xc_7_0.qb)=1.8 v(xdut.xc_7_1.q)=1.8 v(xdut.xc_7_1.qb)=0.0 v(xdut.xc_7_2.q)=0.0 v(xdut.xc_7_2.qb)=1.8 v(xdut.xc_7_3.q)=1.8 v(xdut.xc_7_3.qb)=0.0 v(xdut.xc_7_4.q)=0.0 v(xdut.xc_7_4.qb)=1.8 v(xdut.xc_7_5.q)=0.0 v(xdut.xc_7_5.qb)=1.8 v(xdut.xc_7_6.q)=1.8 v(xdut.xc_7_6.qb)=0.0 v(xdut.xc_7_7.q)=1.8 v(xdut.xc_7_7.qb)=0.0
.ic v(xdut.xc_7_8.q)=1.8 v(xdut.xc_7_8.qb)=0.0 v(xdut.xc_7_9.q)=0.0 v(xdut.xc_7_9.qb)=1.8 v(xdut.xc_7_10.q)=1.8 v(xdut.xc_7_10.qb)=0.0 v(xdut.xc_7_11.q)=1.8 v(xdut.xc_7_11.qb)=0.0 v(xdut.xc_7_12.q)=1.8 v(xdut.xc_7_12.qb)=0.0 v(xdut.xc_7_13.q)=0.0 v(xdut.xc_7_13.qb)=1.8 v(xdut.xc_7_14.q)=1.8 v(xdut.xc_7_14.qb)=0.0 v(xdut.xc_7_15.q)=1.8 v(xdut.xc_7_15.qb)=0.0
.ic v(xdut.xc_8_0.q)=1.8 v(xdut.xc_8_0.qb)=0.0 v(xdut.xc_8_1.q)=0.0 v(xdut.xc_8_1.qb)=1.8 v(xdut.xc_8_2.q)=1.8 v(xdut.xc_8_2.qb)=0.0 v(xdut.xc_8_3.q)=1.8 v(xdut.xc_8_3.qb)=0.0 v(xdut.xc_8_4.q)=1.8 v(xdut.xc_8_4.qb)=0.0 v(xdut.xc_8_5.q)=1.8 v(xdut.xc_8_5.qb)=0.0 v(xdut.xc_8_6.q)=0.0 v(xdut.xc_8_6.qb)=1.8 v(xdut.xc_8_7.q)=1.8 v(xdut.xc_8_7.qb)=0.0
.ic v(xdut.xc_8_8.q)=1.8 v(xdut.xc_8_8.qb)=0.0 v(xdut.xc_8_9.q)=1.8 v(xdut.xc_8_9.qb)=0.0 v(xdut.xc_8_10.q)=0.0 v(xdut.xc_8_10.qb)=1.8 v(xdut.xc_8_11.q)=1.8 v(xdut.xc_8_11.qb)=0.0 v(xdut.xc_8_12.q)=1.8 v(xdut.xc_8_12.qb)=0.0 v(xdut.xc_8_13.q)=0.0 v(xdut.xc_8_13.qb)=1.8 v(xdut.xc_8_14.q)=1.8 v(xdut.xc_8_14.qb)=0.0 v(xdut.xc_8_15.q)=0.0 v(xdut.xc_8_15.qb)=1.8
.ic v(xdut.xc_9_0.q)=1.8 v(xdut.xc_9_0.qb)=0.0 v(xdut.xc_9_1.q)=1.8 v(xdut.xc_9_1.qb)=0.0 v(xdut.xc_9_2.q)=0.0 v(xdut.xc_9_2.qb)=1.8 v(xdut.xc_9_3.q)=0.0 v(xdut.xc_9_3.qb)=1.8 v(xdut.xc_9_4.q)=1.8 v(xdut.xc_9_4.qb)=0.0 v(xdut.xc_9_5.q)=1.8 v(xdut.xc_9_5.qb)=0.0 v(xdut.xc_9_6.q)=0.0 v(xdut.xc_9_6.qb)=1.8 v(xdut.xc_9_7.q)=1.8 v(xdut.xc_9_7.qb)=0.0
.ic v(xdut.xc_9_8.q)=1.8 v(xdut.xc_9_8.qb)=0.0 v(xdut.xc_9_9.q)=1.8 v(xdut.xc_9_9.qb)=0.0 v(xdut.xc_9_10.q)=0.0 v(xdut.xc_9_10.qb)=1.8 v(xdut.xc_9_11.q)=0.0 v(xdut.xc_9_11.qb)=1.8 v(xdut.xc_9_12.q)=0.0 v(xdut.xc_9_12.qb)=1.8 v(xdut.xc_9_13.q)=0.0 v(xdut.xc_9_13.qb)=1.8 v(xdut.xc_9_14.q)=1.8 v(xdut.xc_9_14.qb)=0.0 v(xdut.xc_9_15.q)=0.0 v(xdut.xc_9_15.qb)=1.8
.ic v(xdut.xc_10_0.q)=1.8 v(xdut.xc_10_0.qb)=0.0 v(xdut.xc_10_1.q)=0.0 v(xdut.xc_10_1.qb)=1.8 v(xdut.xc_10_2.q)=1.8 v(xdut.xc_10_2.qb)=0.0 v(xdut.xc_10_3.q)=1.8 v(xdut.xc_10_3.qb)=0.0 v(xdut.xc_10_4.q)=1.8 v(xdut.xc_10_4.qb)=0.0 v(xdut.xc_10_5.q)=1.8 v(xdut.xc_10_5.qb)=0.0 v(xdut.xc_10_6.q)=0.0 v(xdut.xc_10_6.qb)=1.8 v(xdut.xc_10_7.q)=0.0 v(xdut.xc_10_7.qb)=1.8
.ic v(xdut.xc_10_8.q)=0.0 v(xdut.xc_10_8.qb)=1.8 v(xdut.xc_10_9.q)=1.8 v(xdut.xc_10_9.qb)=0.0 v(xdut.xc_10_10.q)=0.0 v(xdut.xc_10_10.qb)=1.8 v(xdut.xc_10_11.q)=0.0 v(xdut.xc_10_11.qb)=1.8 v(xdut.xc_10_12.q)=0.0 v(xdut.xc_10_12.qb)=1.8 v(xdut.xc_10_13.q)=1.8 v(xdut.xc_10_13.qb)=0.0 v(xdut.xc_10_14.q)=1.8 v(xdut.xc_10_14.qb)=0.0 v(xdut.xc_10_15.q)=1.8 v(xdut.xc_10_15.qb)=0.0
.ic v(xdut.xc_11_0.q)=1.8 v(xdut.xc_11_0.qb)=0.0 v(xdut.xc_11_1.q)=0.0 v(xdut.xc_11_1.qb)=1.8 v(xdut.xc_11_2.q)=0.0 v(xdut.xc_11_2.qb)=1.8 v(xdut.xc_11_3.q)=1.8 v(xdut.xc_11_3.qb)=0.0 v(xdut.xc_11_4.q)=1.8 v(xdut.xc_11_4.qb)=0.0 v(xdut.xc_11_5.q)=0.0 v(xdut.xc_11_5.qb)=1.8 v(xdut.xc_11_6.q)=1.8 v(xdut.xc_11_6.qb)=0.0 v(xdut.xc_11_7.q)=1.8 v(xdut.xc_11_7.qb)=0.0
.ic v(xdut.xc_11_8.q)=1.8 v(xdut.xc_11_8.qb)=0.0 v(xdut.xc_11_9.q)=0.0 v(xdut.xc_11_9.qb)=1.8 v(xdut.xc_11_10.q)=0.0 v(xdut.xc_11_10.qb)=1.8 v(xdut.xc_11_11.q)=1.8 v(xdut.xc_11_11.qb)=0.0 v(xdut.xc_11_12.q)=1.8 v(xdut.xc_11_12.qb)=0.0 v(xdut.xc_11_13.q)=1.8 v(xdut.xc_11_13.qb)=0.0 v(xdut.xc_11_14.q)=0.0 v(xdut.xc_11_14.qb)=1.8 v(xdut.xc_11_15.q)=1.8 v(xdut.xc_11_15.qb)=0.0
.ic v(xdut.xc_12_0.q)=1.8 v(xdut.xc_12_0.qb)=0.0 v(xdut.xc_12_1.q)=0.0 v(xdut.xc_12_1.qb)=1.8 v(xdut.xc_12_2.q)=1.8 v(xdut.xc_12_2.qb)=0.0 v(xdut.xc_12_3.q)=1.8 v(xdut.xc_12_3.qb)=0.0 v(xdut.xc_12_4.q)=1.8 v(xdut.xc_12_4.qb)=0.0 v(xdut.xc_12_5.q)=0.0 v(xdut.xc_12_5.qb)=1.8 v(xdut.xc_12_6.q)=1.8 v(xdut.xc_12_6.qb)=0.0 v(xdut.xc_12_7.q)=1.8 v(xdut.xc_12_7.qb)=0.0
.ic v(xdut.xc_12_8.q)=0.0 v(xdut.xc_12_8.qb)=1.8 v(xdut.xc_12_9.q)=0.0 v(xdut.xc_12_9.qb)=1.8 v(xdut.xc_12_10.q)=0.0 v(xdut.xc_12_10.qb)=1.8 v(xdut.xc_12_11.q)=1.8 v(xdut.xc_12_11.qb)=0.0 v(xdut.xc_12_12.q)=0.0 v(xdut.xc_12_12.qb)=1.8 v(xdut.xc_12_13.q)=0.0 v(xdut.xc_12_13.qb)=1.8 v(xdut.xc_12_14.q)=1.8 v(xdut.xc_12_14.qb)=0.0 v(xdut.xc_12_15.q)=1.8 v(xdut.xc_12_15.qb)=0.0
.ic v(xdut.xc_13_0.q)=0.0 v(xdut.xc_13_0.qb)=1.8 v(xdut.xc_13_1.q)=1.8 v(xdut.xc_13_1.qb)=0.0 v(xdut.xc_13_2.q)=0.0 v(xdut.xc_13_2.qb)=1.8 v(xdut.xc_13_3.q)=1.8 v(xdut.xc_13_3.qb)=0.0 v(xdut.xc_13_4.q)=0.0 v(xdut.xc_13_4.qb)=1.8 v(xdut.xc_13_5.q)=1.8 v(xdut.xc_13_5.qb)=0.0 v(xdut.xc_13_6.q)=1.8 v(xdut.xc_13_6.qb)=0.0 v(xdut.xc_13_7.q)=1.8 v(xdut.xc_13_7.qb)=0.0
.ic v(xdut.xc_13_8.q)=0.0 v(xdut.xc_13_8.qb)=1.8 v(xdut.xc_13_9.q)=0.0 v(xdut.xc_13_9.qb)=1.8 v(xdut.xc_13_10.q)=0.0 v(xdut.xc_13_10.qb)=1.8 v(xdut.xc_13_11.q)=1.8 v(xdut.xc_13_11.qb)=0.0 v(xdut.xc_13_12.q)=0.0 v(xdut.xc_13_12.qb)=1.8 v(xdut.xc_13_13.q)=0.0 v(xdut.xc_13_13.qb)=1.8 v(xdut.xc_13_14.q)=1.8 v(xdut.xc_13_14.qb)=0.0 v(xdut.xc_13_15.q)=0.0 v(xdut.xc_13_15.qb)=1.8
.ic v(xdut.xc_14_0.q)=1.8 v(xdut.xc_14_0.qb)=0.0 v(xdut.xc_14_1.q)=0.0 v(xdut.xc_14_1.qb)=1.8 v(xdut.xc_14_2.q)=1.8 v(xdut.xc_14_2.qb)=0.0 v(xdut.xc_14_3.q)=0.0 v(xdut.xc_14_3.qb)=1.8 v(xdut.xc_14_4.q)=1.8 v(xdut.xc_14_4.qb)=0.0 v(xdut.xc_14_5.q)=0.0 v(xdut.xc_14_5.qb)=1.8 v(xdut.xc_14_6.q)=0.0 v(xdut.xc_14_6.qb)=1.8 v(xdut.xc_14_7.q)=0.0 v(xdut.xc_14_7.qb)=1.8
.ic v(xdut.xc_14_8.q)=1.8 v(xdut.xc_14_8.qb)=0.0 v(xdut.xc_14_9.q)=0.0 v(xdut.xc_14_9.qb)=1.8 v(xdut.xc_14_10.q)=1.8 v(xdut.xc_14_10.qb)=0.0 v(xdut.xc_14_11.q)=1.8 v(xdut.xc_14_11.qb)=0.0 v(xdut.xc_14_12.q)=1.8 v(xdut.xc_14_12.qb)=0.0 v(xdut.xc_14_13.q)=0.0 v(xdut.xc_14_13.qb)=1.8 v(xdut.xc_14_14.q)=0.0 v(xdut.xc_14_14.qb)=1.8 v(xdut.xc_14_15.q)=0.0 v(xdut.xc_14_15.qb)=1.8
.ic v(xdut.xc_15_0.q)=1.8 v(xdut.xc_15_0.qb)=0.0 v(xdut.xc_15_1.q)=0.0 v(xdut.xc_15_1.qb)=1.8 v(xdut.xc_15_2.q)=0.0 v(xdut.xc_15_2.qb)=1.8 v(xdut.xc_15_3.q)=0.0 v(xdut.xc_15_3.qb)=1.8 v(xdut.xc_15_4.q)=0.0 v(xdut.xc_15_4.qb)=1.8 v(xdut.xc_15_5.q)=0.0 v(xdut.xc_15_5.qb)=1.8 v(xdut.xc_15_6.q)=0.0 v(xdut.xc_15_6.qb)=1.8 v(xdut.xc_15_7.q)=0.0 v(xdut.xc_15_7.qb)=1.8
.ic v(xdut.xc_15_8.q)=1.8 v(xdut.xc_15_8.qb)=0.0 v(xdut.xc_15_9.q)=0.0 v(xdut.xc_15_9.qb)=1.8 v(xdut.xc_15_10.q)=1.8 v(xdut.xc_15_10.qb)=0.0 v(xdut.xc_15_11.q)=0.0 v(xdut.xc_15_11.qb)=1.8 v(xdut.xc_15_12.q)=0.0 v(xdut.xc_15_12.qb)=1.8 v(xdut.xc_15_13.q)=1.8 v(xdut.xc_15_13.qb)=0.0 v(xdut.xc_15_14.q)=0.0 v(xdut.xc_15_14.qb)=1.8 v(xdut.xc_15_15.q)=1.8 v(xdut.xc_15_15.qb)=0.0
.option reltol=1e-3
.tran 2.800e-11 9.3100e-08
.save v(CLK) v(ADDR) v(RW) v(DIN) v(DOUT) v(xdut.rdqb) v(xdut.rd) v(xdut.dl) v(xdut.dlb) v(xdut.pcb) v(xdut.clkb) v(xdut.clk_ff) v(xdut.we) v(xdut.wl0) v(xdut.wl15) v(xdut.bl0) v(xdut.blb0) v(xdut.bl15) v(xdut.blb15) v(xdut.xc_0_0.q) v(xdut.xc_15_15.q) i(Vdd) i(Vddio)
.control
set wr_singlescale
set wr_vecnames
run
wrdata ct_rand64_1.4ns.dat v(CLK) v(ADDR) v(RW) v(DIN) v(DOUT) v(xdut.rdqb) v(xdut.rd) v(xdut.dl) v(xdut.dlb) v(xdut.pcb) v(xdut.clkb) v(xdut.we) v(xdut.wl0) v(xdut.wl15) v(xdut.bl0) v(xdut.blb0) v(xdut.bl15) v(xdut.blb15) v(xdut.xc_0_0.q) v(xdut.xc_15_15.q) i(Vdd) i(Vddio) v(xdut.clk_ff)
.endc
.end
