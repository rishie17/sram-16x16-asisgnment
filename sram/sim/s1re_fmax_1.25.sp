* SRAM256 testbench: rand64, T=1.250 ns
.lib /foss/pdks/sky130A/libs.tech/ngspice/sky130.lib.spice tt
.include /foss/designs/sram/cells/cells.sp
* ===== 256x1 SRAM core + I/O (generated by gen_sram.py) =====
.subckt sram256 CLK ADDR RW DIN DOUT vdd vddio vss
Xpad_CLK CLK clk_pad vddio vss bondpad
Xib_CLK clk_pad clk_in vdd vss inbuf
Xpad_ADDR ADDR addr_pad vddio vss bondpad
Xib_ADDR addr_pad addr_in vdd vss inbuf
Xpad_RW RW rw_pad vddio vss bondpad
Xib_RW rw_pad rw_in vdd vss inbuf
Xpad_DIN DIN din_pad vddio vss bondpad
Xib_DIN din_pad din_in vdd vss inbuf
Xpad_DOUT DOUT dout_pad vddio vss bondpad
* --- clock distribution: root buffer + 3 balanced branches
Xck_r1 clk_in ckr_b vdd vss inv wn=1.68 wp=3.36
Xck_r2 ckr_b ckr vdd vss inv wn=3.36 wp=6.72
Xck_a1 ckr cka_b vdd vss inv wn=0.84 wp=1.68
Xck_a2 cka_b clk_ff vdd vss inv wn=1.68 wp=3.36
Xck_b1 ckr ckb1 vdd vss inv wn=0.84 wp=1.68
Xck_b2 ckb1 ckb2 vdd vss inv wn=1.26 wp=2.52
Xck_b3 ckb2 clkb vdd vss inv wn=2.52 wp=5.04
Xck_d1 ckr d1 vdd vss inv
Xck_d2 d1 d2 vdd vss inv
Xck_d3 d2 d3 vdd vss inv
Xck_d4 d3 d4 vdd vss inv
Xck_d5 d4 d5 vdd vss inv
Xck_d6 d5 d6 vdd vss inv
Xck_d7 d6 d7 vdd vss inv
Xck_d8 d7 ckd vdd vss inv
Xck_c1 ckr ckd pc0 vdd vss nand2 wn=1.68 wp=1.68
Xck_c2 pc0 pc1 vdd vss inv wn=0.84 wp=1.68
Xck_c3 pc1 pcb vdd vss inv wn=2.52 wp=5.04
* --- serial address shift register (a0 = newest bit, a7 = oldest = MSB)
Xff_a0 addr_in clk_ff a0 ab0 vdd vss dff
Xff_a1 a0 clk_ff a1 ab1 vdd vss dff
Xff_a2 a1 clk_ff a2 ab2 vdd vss dff
Xff_a3 a2 clk_ff a3 ab3 vdd vss dff
Xff_a4 a3 clk_ff a4 ab4 vdd vss dff
Xff_a5 a4 clk_ff a5 ab5 vdd vss dff
Xff_a6 a5 clk_ff a6 ab6 vdd vss dff
Xff_a7 a6 clk_ff a7 ab7 vdd vss dff
Xff_rw rw_in clk_ff rwq rwqb vdd vss dff
Xff_din din_in clk_ff dinq dinqb vdd vss dff
Xpd_rh0 ab7 ab6 rhb0 vdd vss nand2
Xpi_rh0 rhb0 rh0 vdd vss inv wn=0.84 wp=1.68
Xpd_rh1 ab7 a6 rhb1 vdd vss nand2
Xpi_rh1 rhb1 rh1 vdd vss inv wn=0.84 wp=1.68
Xpd_rh2 a7 ab6 rhb2 vdd vss nand2
Xpi_rh2 rhb2 rh2 vdd vss inv wn=0.84 wp=1.68
Xpd_rh3 a7 a6 rhb3 vdd vss nand2
Xpi_rh3 rhb3 rh3 vdd vss inv wn=0.84 wp=1.68
Xpd_rl0 ab5 ab4 rlb0 vdd vss nand2
Xpi_rl0 rlb0 rl0 vdd vss inv wn=0.84 wp=1.68
Xpd_rl1 ab5 a4 rlb1 vdd vss nand2
Xpi_rl1 rlb1 rl1 vdd vss inv wn=0.84 wp=1.68
Xpd_rl2 a5 ab4 rlb2 vdd vss nand2
Xpi_rl2 rlb2 rl2 vdd vss inv wn=0.84 wp=1.68
Xpd_rl3 a5 a4 rlb3 vdd vss nand2
Xpi_rl3 rlb3 rl3 vdd vss inv wn=0.84 wp=1.68
Xpd_ch0 ab3 ab2 chb0 vdd vss nand2
Xpi_ch0 chb0 ch0 vdd vss inv wn=0.84 wp=1.68
Xpd_ch1 ab3 a2 chb1 vdd vss nand2
Xpi_ch1 chb1 ch1 vdd vss inv wn=0.84 wp=1.68
Xpd_ch2 a3 ab2 chb2 vdd vss nand2
Xpi_ch2 chb2 ch2 vdd vss inv wn=0.84 wp=1.68
Xpd_ch3 a3 a2 chb3 vdd vss nand2
Xpi_ch3 chb3 ch3 vdd vss inv wn=0.84 wp=1.68
Xpd_cl0 ab1 ab0 clb0 vdd vss nand2
Xpi_cl0 clb0 cl0 vdd vss inv wn=0.84 wp=1.68
Xpd_cl1 ab1 a0 clb1 vdd vss nand2
Xpi_cl1 clb1 cl1 vdd vss inv wn=0.84 wp=1.68
Xpd_cl2 a1 ab0 clb2 vdd vss nand2
Xpi_cl2 clb2 cl2 vdd vss inv wn=0.84 wp=1.68
Xpd_cl3 a1 a0 clb3 vdd vss nand2
Xpi_cl3 clb3 cl3 vdd vss inv wn=0.84 wp=1.68
* --- row decoder: WL_r = rh & rl & clkb
Xrd0 rh0 rl0 clkb wlb0 vdd vss nand3
Xwd0 wlb0 wl0 vdd vss inv wn=0.84 wp=1.68
Cwl0 wl0 vss 4f
Xrd1 rh0 rl1 clkb wlb1 vdd vss nand3
Xwd1 wlb1 wl1 vdd vss inv wn=0.84 wp=1.68
Cwl1 wl1 vss 4f
Xrd2 rh0 rl2 clkb wlb2 vdd vss nand3
Xwd2 wlb2 wl2 vdd vss inv wn=0.84 wp=1.68
Cwl2 wl2 vss 4f
Xrd3 rh0 rl3 clkb wlb3 vdd vss nand3
Xwd3 wlb3 wl3 vdd vss inv wn=0.84 wp=1.68
Cwl3 wl3 vss 4f
Xrd4 rh1 rl0 clkb wlb4 vdd vss nand3
Xwd4 wlb4 wl4 vdd vss inv wn=0.84 wp=1.68
Cwl4 wl4 vss 4f
Xrd5 rh1 rl1 clkb wlb5 vdd vss nand3
Xwd5 wlb5 wl5 vdd vss inv wn=0.84 wp=1.68
Cwl5 wl5 vss 4f
Xrd6 rh1 rl2 clkb wlb6 vdd vss nand3
Xwd6 wlb6 wl6 vdd vss inv wn=0.84 wp=1.68
Cwl6 wl6 vss 4f
Xrd7 rh1 rl3 clkb wlb7 vdd vss nand3
Xwd7 wlb7 wl7 vdd vss inv wn=0.84 wp=1.68
Cwl7 wl7 vss 4f
Xrd8 rh2 rl0 clkb wlb8 vdd vss nand3
Xwd8 wlb8 wl8 vdd vss inv wn=0.84 wp=1.68
Cwl8 wl8 vss 4f
Xrd9 rh2 rl1 clkb wlb9 vdd vss nand3
Xwd9 wlb9 wl9 vdd vss inv wn=0.84 wp=1.68
Cwl9 wl9 vss 4f
Xrd10 rh2 rl2 clkb wlb10 vdd vss nand3
Xwd10 wlb10 wl10 vdd vss inv wn=0.84 wp=1.68
Cwl10 wl10 vss 4f
Xrd11 rh2 rl3 clkb wlb11 vdd vss nand3
Xwd11 wlb11 wl11 vdd vss inv wn=0.84 wp=1.68
Cwl11 wl11 vss 4f
Xrd12 rh3 rl0 clkb wlb12 vdd vss nand3
Xwd12 wlb12 wl12 vdd vss inv wn=0.84 wp=1.68
Cwl12 wl12 vss 4f
Xrd13 rh3 rl1 clkb wlb13 vdd vss nand3
Xwd13 wlb13 wl13 vdd vss inv wn=0.84 wp=1.68
Cwl13 wl13 vss 4f
Xrd14 rh3 rl2 clkb wlb14 vdd vss nand3
Xwd14 wlb14 wl14 vdd vss inv wn=0.84 wp=1.68
Cwl14 wl14 vss 4f
Xrd15 rh3 rl3 clkb wlb15 vdd vss nand3
Xwd15 wlb15 wl15 vdd vss inv wn=0.84 wp=1.68
Cwl15 wl15 vss 4f
* --- column decoder
Xcd0 ch0 cl0 cselb0 vdd vss nand2
Xcs0 cselb0 csel0 vdd vss inv wn=0.84 wp=1.68
Xcd1 ch0 cl1 cselb1 vdd vss nand2
Xcs1 cselb1 csel1 vdd vss inv wn=0.84 wp=1.68
Xcd2 ch0 cl2 cselb2 vdd vss nand2
Xcs2 cselb2 csel2 vdd vss inv wn=0.84 wp=1.68
Xcd3 ch0 cl3 cselb3 vdd vss nand2
Xcs3 cselb3 csel3 vdd vss inv wn=0.84 wp=1.68
Xcd4 ch1 cl0 cselb4 vdd vss nand2
Xcs4 cselb4 csel4 vdd vss inv wn=0.84 wp=1.68
Xcd5 ch1 cl1 cselb5 vdd vss nand2
Xcs5 cselb5 csel5 vdd vss inv wn=0.84 wp=1.68
Xcd6 ch1 cl2 cselb6 vdd vss nand2
Xcs6 cselb6 csel6 vdd vss inv wn=0.84 wp=1.68
Xcd7 ch1 cl3 cselb7 vdd vss nand2
Xcs7 cselb7 csel7 vdd vss inv wn=0.84 wp=1.68
Xcd8 ch2 cl0 cselb8 vdd vss nand2
Xcs8 cselb8 csel8 vdd vss inv wn=0.84 wp=1.68
Xcd9 ch2 cl1 cselb9 vdd vss nand2
Xcs9 cselb9 csel9 vdd vss inv wn=0.84 wp=1.68
Xcd10 ch2 cl2 cselb10 vdd vss nand2
Xcs10 cselb10 csel10 vdd vss inv wn=0.84 wp=1.68
Xcd11 ch2 cl3 cselb11 vdd vss nand2
Xcs11 cselb11 csel11 vdd vss inv wn=0.84 wp=1.68
Xcd12 ch3 cl0 cselb12 vdd vss nand2
Xcs12 cselb12 csel12 vdd vss inv wn=0.84 wp=1.68
Xcd13 ch3 cl1 cselb13 vdd vss nand2
Xcs13 cselb13 csel13 vdd vss inv wn=0.84 wp=1.68
Xcd14 ch3 cl2 cselb14 vdd vss nand2
Xcs14 cselb14 csel14 vdd vss inv wn=0.84 wp=1.68
Xcd15 ch3 cl3 cselb15 vdd vss nand2
Xcs15 cselb15 csel15 vdd vss inv wn=0.84 wp=1.68
* --- 16x16 bit-cell array
Xc_0_0 bl0 blb0 wl0 vdd vss bitcell
Xc_0_1 bl1 blb1 wl0 vdd vss bitcell
Xc_0_2 bl2 blb2 wl0 vdd vss bitcell
Xc_0_3 bl3 blb3 wl0 vdd vss bitcell
Xc_0_4 bl4 blb4 wl0 vdd vss bitcell
Xc_0_5 bl5 blb5 wl0 vdd vss bitcell
Xc_0_6 bl6 blb6 wl0 vdd vss bitcell
Xc_0_7 bl7 blb7 wl0 vdd vss bitcell
Xc_0_8 bl8 blb8 wl0 vdd vss bitcell
Xc_0_9 bl9 blb9 wl0 vdd vss bitcell
Xc_0_10 bl10 blb10 wl0 vdd vss bitcell
Xc_0_11 bl11 blb11 wl0 vdd vss bitcell
Xc_0_12 bl12 blb12 wl0 vdd vss bitcell
Xc_0_13 bl13 blb13 wl0 vdd vss bitcell
Xc_0_14 bl14 blb14 wl0 vdd vss bitcell
Xc_0_15 bl15 blb15 wl0 vdd vss bitcell
Xc_1_0 bl0 blb0 wl1 vdd vss bitcell
Xc_1_1 bl1 blb1 wl1 vdd vss bitcell
Xc_1_2 bl2 blb2 wl1 vdd vss bitcell
Xc_1_3 bl3 blb3 wl1 vdd vss bitcell
Xc_1_4 bl4 blb4 wl1 vdd vss bitcell
Xc_1_5 bl5 blb5 wl1 vdd vss bitcell
Xc_1_6 bl6 blb6 wl1 vdd vss bitcell
Xc_1_7 bl7 blb7 wl1 vdd vss bitcell
Xc_1_8 bl8 blb8 wl1 vdd vss bitcell
Xc_1_9 bl9 blb9 wl1 vdd vss bitcell
Xc_1_10 bl10 blb10 wl1 vdd vss bitcell
Xc_1_11 bl11 blb11 wl1 vdd vss bitcell
Xc_1_12 bl12 blb12 wl1 vdd vss bitcell
Xc_1_13 bl13 blb13 wl1 vdd vss bitcell
Xc_1_14 bl14 blb14 wl1 vdd vss bitcell
Xc_1_15 bl15 blb15 wl1 vdd vss bitcell
Xc_2_0 bl0 blb0 wl2 vdd vss bitcell
Xc_2_1 bl1 blb1 wl2 vdd vss bitcell
Xc_2_2 bl2 blb2 wl2 vdd vss bitcell
Xc_2_3 bl3 blb3 wl2 vdd vss bitcell
Xc_2_4 bl4 blb4 wl2 vdd vss bitcell
Xc_2_5 bl5 blb5 wl2 vdd vss bitcell
Xc_2_6 bl6 blb6 wl2 vdd vss bitcell
Xc_2_7 bl7 blb7 wl2 vdd vss bitcell
Xc_2_8 bl8 blb8 wl2 vdd vss bitcell
Xc_2_9 bl9 blb9 wl2 vdd vss bitcell
Xc_2_10 bl10 blb10 wl2 vdd vss bitcell
Xc_2_11 bl11 blb11 wl2 vdd vss bitcell
Xc_2_12 bl12 blb12 wl2 vdd vss bitcell
Xc_2_13 bl13 blb13 wl2 vdd vss bitcell
Xc_2_14 bl14 blb14 wl2 vdd vss bitcell
Xc_2_15 bl15 blb15 wl2 vdd vss bitcell
Xc_3_0 bl0 blb0 wl3 vdd vss bitcell
Xc_3_1 bl1 blb1 wl3 vdd vss bitcell
Xc_3_2 bl2 blb2 wl3 vdd vss bitcell
Xc_3_3 bl3 blb3 wl3 vdd vss bitcell
Xc_3_4 bl4 blb4 wl3 vdd vss bitcell
Xc_3_5 bl5 blb5 wl3 vdd vss bitcell
Xc_3_6 bl6 blb6 wl3 vdd vss bitcell
Xc_3_7 bl7 blb7 wl3 vdd vss bitcell
Xc_3_8 bl8 blb8 wl3 vdd vss bitcell
Xc_3_9 bl9 blb9 wl3 vdd vss bitcell
Xc_3_10 bl10 blb10 wl3 vdd vss bitcell
Xc_3_11 bl11 blb11 wl3 vdd vss bitcell
Xc_3_12 bl12 blb12 wl3 vdd vss bitcell
Xc_3_13 bl13 blb13 wl3 vdd vss bitcell
Xc_3_14 bl14 blb14 wl3 vdd vss bitcell
Xc_3_15 bl15 blb15 wl3 vdd vss bitcell
Xc_4_0 bl0 blb0 wl4 vdd vss bitcell
Xc_4_1 bl1 blb1 wl4 vdd vss bitcell
Xc_4_2 bl2 blb2 wl4 vdd vss bitcell
Xc_4_3 bl3 blb3 wl4 vdd vss bitcell
Xc_4_4 bl4 blb4 wl4 vdd vss bitcell
Xc_4_5 bl5 blb5 wl4 vdd vss bitcell
Xc_4_6 bl6 blb6 wl4 vdd vss bitcell
Xc_4_7 bl7 blb7 wl4 vdd vss bitcell
Xc_4_8 bl8 blb8 wl4 vdd vss bitcell
Xc_4_9 bl9 blb9 wl4 vdd vss bitcell
Xc_4_10 bl10 blb10 wl4 vdd vss bitcell
Xc_4_11 bl11 blb11 wl4 vdd vss bitcell
Xc_4_12 bl12 blb12 wl4 vdd vss bitcell
Xc_4_13 bl13 blb13 wl4 vdd vss bitcell
Xc_4_14 bl14 blb14 wl4 vdd vss bitcell
Xc_4_15 bl15 blb15 wl4 vdd vss bitcell
Xc_5_0 bl0 blb0 wl5 vdd vss bitcell
Xc_5_1 bl1 blb1 wl5 vdd vss bitcell
Xc_5_2 bl2 blb2 wl5 vdd vss bitcell
Xc_5_3 bl3 blb3 wl5 vdd vss bitcell
Xc_5_4 bl4 blb4 wl5 vdd vss bitcell
Xc_5_5 bl5 blb5 wl5 vdd vss bitcell
Xc_5_6 bl6 blb6 wl5 vdd vss bitcell
Xc_5_7 bl7 blb7 wl5 vdd vss bitcell
Xc_5_8 bl8 blb8 wl5 vdd vss bitcell
Xc_5_9 bl9 blb9 wl5 vdd vss bitcell
Xc_5_10 bl10 blb10 wl5 vdd vss bitcell
Xc_5_11 bl11 blb11 wl5 vdd vss bitcell
Xc_5_12 bl12 blb12 wl5 vdd vss bitcell
Xc_5_13 bl13 blb13 wl5 vdd vss bitcell
Xc_5_14 bl14 blb14 wl5 vdd vss bitcell
Xc_5_15 bl15 blb15 wl5 vdd vss bitcell
Xc_6_0 bl0 blb0 wl6 vdd vss bitcell
Xc_6_1 bl1 blb1 wl6 vdd vss bitcell
Xc_6_2 bl2 blb2 wl6 vdd vss bitcell
Xc_6_3 bl3 blb3 wl6 vdd vss bitcell
Xc_6_4 bl4 blb4 wl6 vdd vss bitcell
Xc_6_5 bl5 blb5 wl6 vdd vss bitcell
Xc_6_6 bl6 blb6 wl6 vdd vss bitcell
Xc_6_7 bl7 blb7 wl6 vdd vss bitcell
Xc_6_8 bl8 blb8 wl6 vdd vss bitcell
Xc_6_9 bl9 blb9 wl6 vdd vss bitcell
Xc_6_10 bl10 blb10 wl6 vdd vss bitcell
Xc_6_11 bl11 blb11 wl6 vdd vss bitcell
Xc_6_12 bl12 blb12 wl6 vdd vss bitcell
Xc_6_13 bl13 blb13 wl6 vdd vss bitcell
Xc_6_14 bl14 blb14 wl6 vdd vss bitcell
Xc_6_15 bl15 blb15 wl6 vdd vss bitcell
Xc_7_0 bl0 blb0 wl7 vdd vss bitcell
Xc_7_1 bl1 blb1 wl7 vdd vss bitcell
Xc_7_2 bl2 blb2 wl7 vdd vss bitcell
Xc_7_3 bl3 blb3 wl7 vdd vss bitcell
Xc_7_4 bl4 blb4 wl7 vdd vss bitcell
Xc_7_5 bl5 blb5 wl7 vdd vss bitcell
Xc_7_6 bl6 blb6 wl7 vdd vss bitcell
Xc_7_7 bl7 blb7 wl7 vdd vss bitcell
Xc_7_8 bl8 blb8 wl7 vdd vss bitcell
Xc_7_9 bl9 blb9 wl7 vdd vss bitcell
Xc_7_10 bl10 blb10 wl7 vdd vss bitcell
Xc_7_11 bl11 blb11 wl7 vdd vss bitcell
Xc_7_12 bl12 blb12 wl7 vdd vss bitcell
Xc_7_13 bl13 blb13 wl7 vdd vss bitcell
Xc_7_14 bl14 blb14 wl7 vdd vss bitcell
Xc_7_15 bl15 blb15 wl7 vdd vss bitcell
Xc_8_0 bl0 blb0 wl8 vdd vss bitcell
Xc_8_1 bl1 blb1 wl8 vdd vss bitcell
Xc_8_2 bl2 blb2 wl8 vdd vss bitcell
Xc_8_3 bl3 blb3 wl8 vdd vss bitcell
Xc_8_4 bl4 blb4 wl8 vdd vss bitcell
Xc_8_5 bl5 blb5 wl8 vdd vss bitcell
Xc_8_6 bl6 blb6 wl8 vdd vss bitcell
Xc_8_7 bl7 blb7 wl8 vdd vss bitcell
Xc_8_8 bl8 blb8 wl8 vdd vss bitcell
Xc_8_9 bl9 blb9 wl8 vdd vss bitcell
Xc_8_10 bl10 blb10 wl8 vdd vss bitcell
Xc_8_11 bl11 blb11 wl8 vdd vss bitcell
Xc_8_12 bl12 blb12 wl8 vdd vss bitcell
Xc_8_13 bl13 blb13 wl8 vdd vss bitcell
Xc_8_14 bl14 blb14 wl8 vdd vss bitcell
Xc_8_15 bl15 blb15 wl8 vdd vss bitcell
Xc_9_0 bl0 blb0 wl9 vdd vss bitcell
Xc_9_1 bl1 blb1 wl9 vdd vss bitcell
Xc_9_2 bl2 blb2 wl9 vdd vss bitcell
Xc_9_3 bl3 blb3 wl9 vdd vss bitcell
Xc_9_4 bl4 blb4 wl9 vdd vss bitcell
Xc_9_5 bl5 blb5 wl9 vdd vss bitcell
Xc_9_6 bl6 blb6 wl9 vdd vss bitcell
Xc_9_7 bl7 blb7 wl9 vdd vss bitcell
Xc_9_8 bl8 blb8 wl9 vdd vss bitcell
Xc_9_9 bl9 blb9 wl9 vdd vss bitcell
Xc_9_10 bl10 blb10 wl9 vdd vss bitcell
Xc_9_11 bl11 blb11 wl9 vdd vss bitcell
Xc_9_12 bl12 blb12 wl9 vdd vss bitcell
Xc_9_13 bl13 blb13 wl9 vdd vss bitcell
Xc_9_14 bl14 blb14 wl9 vdd vss bitcell
Xc_9_15 bl15 blb15 wl9 vdd vss bitcell
Xc_10_0 bl0 blb0 wl10 vdd vss bitcell
Xc_10_1 bl1 blb1 wl10 vdd vss bitcell
Xc_10_2 bl2 blb2 wl10 vdd vss bitcell
Xc_10_3 bl3 blb3 wl10 vdd vss bitcell
Xc_10_4 bl4 blb4 wl10 vdd vss bitcell
Xc_10_5 bl5 blb5 wl10 vdd vss bitcell
Xc_10_6 bl6 blb6 wl10 vdd vss bitcell
Xc_10_7 bl7 blb7 wl10 vdd vss bitcell
Xc_10_8 bl8 blb8 wl10 vdd vss bitcell
Xc_10_9 bl9 blb9 wl10 vdd vss bitcell
Xc_10_10 bl10 blb10 wl10 vdd vss bitcell
Xc_10_11 bl11 blb11 wl10 vdd vss bitcell
Xc_10_12 bl12 blb12 wl10 vdd vss bitcell
Xc_10_13 bl13 blb13 wl10 vdd vss bitcell
Xc_10_14 bl14 blb14 wl10 vdd vss bitcell
Xc_10_15 bl15 blb15 wl10 vdd vss bitcell
Xc_11_0 bl0 blb0 wl11 vdd vss bitcell
Xc_11_1 bl1 blb1 wl11 vdd vss bitcell
Xc_11_2 bl2 blb2 wl11 vdd vss bitcell
Xc_11_3 bl3 blb3 wl11 vdd vss bitcell
Xc_11_4 bl4 blb4 wl11 vdd vss bitcell
Xc_11_5 bl5 blb5 wl11 vdd vss bitcell
Xc_11_6 bl6 blb6 wl11 vdd vss bitcell
Xc_11_7 bl7 blb7 wl11 vdd vss bitcell
Xc_11_8 bl8 blb8 wl11 vdd vss bitcell
Xc_11_9 bl9 blb9 wl11 vdd vss bitcell
Xc_11_10 bl10 blb10 wl11 vdd vss bitcell
Xc_11_11 bl11 blb11 wl11 vdd vss bitcell
Xc_11_12 bl12 blb12 wl11 vdd vss bitcell
Xc_11_13 bl13 blb13 wl11 vdd vss bitcell
Xc_11_14 bl14 blb14 wl11 vdd vss bitcell
Xc_11_15 bl15 blb15 wl11 vdd vss bitcell
Xc_12_0 bl0 blb0 wl12 vdd vss bitcell
Xc_12_1 bl1 blb1 wl12 vdd vss bitcell
Xc_12_2 bl2 blb2 wl12 vdd vss bitcell
Xc_12_3 bl3 blb3 wl12 vdd vss bitcell
Xc_12_4 bl4 blb4 wl12 vdd vss bitcell
Xc_12_5 bl5 blb5 wl12 vdd vss bitcell
Xc_12_6 bl6 blb6 wl12 vdd vss bitcell
Xc_12_7 bl7 blb7 wl12 vdd vss bitcell
Xc_12_8 bl8 blb8 wl12 vdd vss bitcell
Xc_12_9 bl9 blb9 wl12 vdd vss bitcell
Xc_12_10 bl10 blb10 wl12 vdd vss bitcell
Xc_12_11 bl11 blb11 wl12 vdd vss bitcell
Xc_12_12 bl12 blb12 wl12 vdd vss bitcell
Xc_12_13 bl13 blb13 wl12 vdd vss bitcell
Xc_12_14 bl14 blb14 wl12 vdd vss bitcell
Xc_12_15 bl15 blb15 wl12 vdd vss bitcell
Xc_13_0 bl0 blb0 wl13 vdd vss bitcell
Xc_13_1 bl1 blb1 wl13 vdd vss bitcell
Xc_13_2 bl2 blb2 wl13 vdd vss bitcell
Xc_13_3 bl3 blb3 wl13 vdd vss bitcell
Xc_13_4 bl4 blb4 wl13 vdd vss bitcell
Xc_13_5 bl5 blb5 wl13 vdd vss bitcell
Xc_13_6 bl6 blb6 wl13 vdd vss bitcell
Xc_13_7 bl7 blb7 wl13 vdd vss bitcell
Xc_13_8 bl8 blb8 wl13 vdd vss bitcell
Xc_13_9 bl9 blb9 wl13 vdd vss bitcell
Xc_13_10 bl10 blb10 wl13 vdd vss bitcell
Xc_13_11 bl11 blb11 wl13 vdd vss bitcell
Xc_13_12 bl12 blb12 wl13 vdd vss bitcell
Xc_13_13 bl13 blb13 wl13 vdd vss bitcell
Xc_13_14 bl14 blb14 wl13 vdd vss bitcell
Xc_13_15 bl15 blb15 wl13 vdd vss bitcell
Xc_14_0 bl0 blb0 wl14 vdd vss bitcell
Xc_14_1 bl1 blb1 wl14 vdd vss bitcell
Xc_14_2 bl2 blb2 wl14 vdd vss bitcell
Xc_14_3 bl3 blb3 wl14 vdd vss bitcell
Xc_14_4 bl4 blb4 wl14 vdd vss bitcell
Xc_14_5 bl5 blb5 wl14 vdd vss bitcell
Xc_14_6 bl6 blb6 wl14 vdd vss bitcell
Xc_14_7 bl7 blb7 wl14 vdd vss bitcell
Xc_14_8 bl8 blb8 wl14 vdd vss bitcell
Xc_14_9 bl9 blb9 wl14 vdd vss bitcell
Xc_14_10 bl10 blb10 wl14 vdd vss bitcell
Xc_14_11 bl11 blb11 wl14 vdd vss bitcell
Xc_14_12 bl12 blb12 wl14 vdd vss bitcell
Xc_14_13 bl13 blb13 wl14 vdd vss bitcell
Xc_14_14 bl14 blb14 wl14 vdd vss bitcell
Xc_14_15 bl15 blb15 wl14 vdd vss bitcell
Xc_15_0 bl0 blb0 wl15 vdd vss bitcell
Xc_15_1 bl1 blb1 wl15 vdd vss bitcell
Xc_15_2 bl2 blb2 wl15 vdd vss bitcell
Xc_15_3 bl3 blb3 wl15 vdd vss bitcell
Xc_15_4 bl4 blb4 wl15 vdd vss bitcell
Xc_15_5 bl5 blb5 wl15 vdd vss bitcell
Xc_15_6 bl6 blb6 wl15 vdd vss bitcell
Xc_15_7 bl7 blb7 wl15 vdd vss bitcell
Xc_15_8 bl8 blb8 wl15 vdd vss bitcell
Xc_15_9 bl9 blb9 wl15 vdd vss bitcell
Xc_15_10 bl10 blb10 wl15 vdd vss bitcell
Xc_15_11 bl11 blb11 wl15 vdd vss bitcell
Xc_15_12 bl12 blb12 wl15 vdd vss bitcell
Xc_15_13 bl13 blb13 wl15 vdd vss bitcell
Xc_15_14 bl14 blb14 wl15 vdd vss bitcell
Xc_15_15 bl15 blb15 wl15 vdd vss bitcell
Xpre0 bl0 blb0 pcb vdd precharge
Xmux0 bl0 blb0 dl dlb csel0 vss colmux
Cbl0 bl0 vss 5f
Cblb0 blb0 vss 5f
Xpre1 bl1 blb1 pcb vdd precharge
Xmux1 bl1 blb1 dl dlb csel1 vss colmux
Cbl1 bl1 vss 5f
Cblb1 blb1 vss 5f
Xpre2 bl2 blb2 pcb vdd precharge
Xmux2 bl2 blb2 dl dlb csel2 vss colmux
Cbl2 bl2 vss 5f
Cblb2 blb2 vss 5f
Xpre3 bl3 blb3 pcb vdd precharge
Xmux3 bl3 blb3 dl dlb csel3 vss colmux
Cbl3 bl3 vss 5f
Cblb3 blb3 vss 5f
Xpre4 bl4 blb4 pcb vdd precharge
Xmux4 bl4 blb4 dl dlb csel4 vss colmux
Cbl4 bl4 vss 5f
Cblb4 blb4 vss 5f
Xpre5 bl5 blb5 pcb vdd precharge
Xmux5 bl5 blb5 dl dlb csel5 vss colmux
Cbl5 bl5 vss 5f
Cblb5 blb5 vss 5f
Xpre6 bl6 blb6 pcb vdd precharge
Xmux6 bl6 blb6 dl dlb csel6 vss colmux
Cbl6 bl6 vss 5f
Cblb6 blb6 vss 5f
Xpre7 bl7 blb7 pcb vdd precharge
Xmux7 bl7 blb7 dl dlb csel7 vss colmux
Cbl7 bl7 vss 5f
Cblb7 blb7 vss 5f
Xpre8 bl8 blb8 pcb vdd precharge
Xmux8 bl8 blb8 dl dlb csel8 vss colmux
Cbl8 bl8 vss 5f
Cblb8 blb8 vss 5f
Xpre9 bl9 blb9 pcb vdd precharge
Xmux9 bl9 blb9 dl dlb csel9 vss colmux
Cbl9 bl9 vss 5f
Cblb9 blb9 vss 5f
Xpre10 bl10 blb10 pcb vdd precharge
Xmux10 bl10 blb10 dl dlb csel10 vss colmux
Cbl10 bl10 vss 5f
Cblb10 blb10 vss 5f
Xpre11 bl11 blb11 pcb vdd precharge
Xmux11 bl11 blb11 dl dlb csel11 vss colmux
Cbl11 bl11 vss 5f
Cblb11 blb11 vss 5f
Xpre12 bl12 blb12 pcb vdd precharge
Xmux12 bl12 blb12 dl dlb csel12 vss colmux
Cbl12 bl12 vss 5f
Cblb12 blb12 vss 5f
Xpre13 bl13 blb13 pcb vdd precharge
Xmux13 bl13 blb13 dl dlb csel13 vss colmux
Cbl13 bl13 vss 5f
Cblb13 blb13 vss 5f
Xpre14 bl14 blb14 pcb vdd precharge
Xmux14 bl14 blb14 dl dlb csel14 vss colmux
Cbl14 bl14 vss 5f
Cblb14 blb14 vss 5f
Xpre15 bl15 blb15 pcb vdd precharge
Xmux15 bl15 blb15 dl dlb csel15 vss colmux
Cbl15 bl15 vss 5f
Cblb15 blb15 vss 5f
Xwe1 rwq clkb web vdd vss nand2
Xwe2 web we vdd vss inv wn=1.26 wp=2.52
Xrw dl dlb we dinq dinqb pcb rd vdd vss rwckt
Cdl dl vss 10f
Cdlb dlb vss 10f
Xff_out rd clk_ff rdq rdqb vdd vss dff
Xob rdqb dout_pad vddio vss outbuf
.control
set wr_singlescale
set wr_vecnames
run
wrdata s1re_fmax_1.25.dat v(CLK) v(ADDR) v(RW) v(DIN) v(DOUT) v(xdut.rdqb) v(xdut.rd) v(xdut.dl) v(xdut.dlb) v(xdut.pcb) v(xdut.clkb) v(xdut.we) v(xdut.wl0) v(xdut.wl15) v(xdut.bl0) v(xdut.blb0) v(xdut.bl15) v(xdut.blb15) v(xdut.xc_0_0.q) v(xdut.xc_15_15.q) i(Vdd) i(Vddio) v(xdut.clk_ff)
.endc
.ends sram256
Vdd vdd 0 1.8
Vddio vddio 0 1.8
Vclk clk_src 0 PULSE(0 1.8 6.2500e-10 5.00e-11 5.00e-11 5.7500e-10 1.2500e-09)
Rclk clk_src CLK 50
Vaddr ADDR_src 0 PWL(0.0000e+00 0.00 1.2500e-09 0.00 1.3000e-09 1.80 2.5000e-09 1.80 2.5500e-09 0.00 6.2500e-09 0.00 6.3000e-09 1.80 1.1250e-08 1.80 1.1300e-08 0.00 1.2500e-08 0.00 1.2550e-08 1.80 1.5000e-08 1.80 1.5050e-08 0.00 1.6250e-08 0.00 1.6300e-08 1.80 1.7500e-08 1.80 1.7550e-08 0.00 2.2500e-08 0.00 2.2550e-08 1.80 2.6250e-08 1.80 2.6300e-08 0.00 2.7500e-08 0.00 2.7550e-08 1.80 2.8750e-08 1.80 2.8800e-08 0.00 3.0000e-08 0.00 3.0050e-08 1.80 3.1250e-08 1.80 3.1300e-08 0.00 3.2500e-08 0.00 3.2550e-08 1.80 3.3750e-08 1.80 3.3800e-08 0.00 3.5000e-08 0.00 3.5050e-08 1.80 3.6250e-08 1.80 3.6300e-08 0.00 4.0000e-08 0.00 4.0050e-08 1.80 4.2500e-08 1.80 4.2550e-08 0.00 4.3750e-08 0.00 4.3800e-08 1.80 4.6250e-08 1.80 4.6300e-08 0.00 5.1250e-08 0.00 5.1300e-08 1.80 5.3750e-08 1.80 5.3800e-08 0.00 5.7500e-08 0.00 5.7550e-08 1.80 5.8750e-08 1.80 5.8800e-08 0.00 6.1250e-08 0.00 6.1300e-08 1.80 6.2500e-08 1.80 6.2550e-08 0.00 6.3750e-08 0.00 6.3800e-08 1.80 6.5000e-08 1.80 6.5050e-08 0.00 6.6250e-08 0.00 6.6300e-08 1.80 6.7500e-08 1.80 6.7550e-08 0.00 6.8750e-08 0.00 6.8800e-08 1.80 7.0000e-08 1.80 7.0050e-08 0.00 7.1250e-08 0.00 7.1300e-08 1.80 7.2500e-08 1.80 7.2550e-08 0.00 7.6250e-08 0.00 7.6300e-08 1.80 8.0000e-08 1.80 8.0050e-08 0.00)
Raddr ADDR_src ADDR 50
Vrw RW_src 0 PWL(0.0000e+00 0.00 2.6250e-08 0.00 2.6300e-08 1.80 2.7500e-08 1.80 2.7550e-08 0.00 2.8750e-08 0.00 2.8800e-08 1.80 3.0000e-08 1.80 3.0050e-08 0.00 3.1250e-08 0.00 3.1300e-08 1.80 3.3750e-08 1.80 3.3800e-08 0.00 4.0000e-08 0.00 4.0050e-08 1.80 4.1250e-08 1.80 4.1300e-08 0.00 4.2500e-08 0.00 4.2550e-08 1.80 4.3750e-08 1.80 4.3800e-08 0.00 5.0000e-08 0.00 5.0050e-08 1.80 5.3750e-08 1.80 5.3800e-08 0.00 5.5000e-08 0.00 5.5050e-08 1.80 5.8750e-08 1.80 5.8800e-08 0.00 6.0000e-08 0.00 6.0050e-08 1.80 6.1250e-08 1.80 6.1300e-08 0.00 6.5000e-08 0.00 6.5050e-08 1.80 6.7500e-08 1.80 6.7550e-08 0.00 7.2500e-08 0.00 7.2550e-08 1.80 7.3750e-08 1.80 7.3800e-08 0.00)
Rrw RW_src RW 50
Vdin DIN_src 0 PWL(0.0000e+00 1.80 1.2500e-09 1.80 1.3000e-09 0.00 7.5000e-09 0.00 7.5500e-09 1.80 1.1250e-08 1.80 1.1300e-08 0.00 1.2500e-08 0.00 1.2550e-08 1.80 1.5000e-08 1.80 1.5050e-08 0.00 1.6250e-08 0.00 1.6300e-08 1.80 2.0000e-08 1.80 2.0050e-08 0.00 2.3750e-08 0.00 2.3800e-08 1.80 2.6250e-08 1.80 2.6300e-08 0.00 2.7500e-08 0.00 2.7550e-08 1.80 3.0000e-08 1.80 3.0050e-08 0.00 3.2500e-08 0.00 3.2550e-08 1.80 3.6250e-08 1.80 3.6300e-08 0.00 4.0000e-08 0.00 4.0050e-08 1.80 4.3750e-08 1.80 4.3800e-08 0.00 4.6250e-08 0.00 4.6300e-08 1.80 4.8750e-08 1.80 4.8800e-08 0.00 5.2500e-08 0.00 5.2550e-08 1.80 5.5000e-08 1.80 5.5050e-08 0.00 5.6250e-08 0.00 5.6300e-08 1.80 5.7500e-08 1.80 5.7550e-08 0.00 5.8750e-08 0.00 5.8800e-08 1.80 6.0000e-08 1.80 6.0050e-08 0.00 6.1250e-08 0.00 6.1300e-08 1.80 6.5000e-08 1.80 6.5050e-08 0.00 7.0000e-08 0.00 7.0050e-08 1.80 7.1250e-08 1.80 7.1300e-08 0.00 7.2500e-08 0.00 7.2550e-08 1.80 7.5000e-08 1.80 7.5050e-08 0.00 7.6250e-08 0.00 7.6300e-08 1.80 7.8750e-08 1.80 7.8800e-08 0.00)
Rdin DIN_src DIN 50
Cload DOUT 0 5.000e-12
Xdut CLK ADDR RW DIN DOUT vdd vddio 0 sram256
.ic v(xdut.xc_0_0.q)=1.8 v(xdut.xc_0_0.qb)=0.0 v(xdut.xc_0_1.q)=1.8 v(xdut.xc_0_1.qb)=0.0 v(xdut.xc_0_2.q)=0.0 v(xdut.xc_0_2.qb)=1.8 v(xdut.xc_0_3.q)=0.0 v(xdut.xc_0_3.qb)=1.8 v(xdut.xc_0_4.q)=0.0 v(xdut.xc_0_4.qb)=1.8 v(xdut.xc_0_5.q)=0.0 v(xdut.xc_0_5.qb)=1.8 v(xdut.xc_0_6.q)=0.0 v(xdut.xc_0_6.qb)=1.8 v(xdut.xc_0_7.q)=0.0 v(xdut.xc_0_7.qb)=1.8
.ic v(xdut.xc_0_8.q)=1.8 v(xdut.xc_0_8.qb)=0.0 v(xdut.xc_0_9.q)=1.8 v(xdut.xc_0_9.qb)=0.0 v(xdut.xc_0_10.q)=0.0 v(xdut.xc_0_10.qb)=1.8 v(xdut.xc_0_11.q)=1.8 v(xdut.xc_0_11.qb)=0.0 v(xdut.xc_0_12.q)=0.0 v(xdut.xc_0_12.qb)=1.8 v(xdut.xc_0_13.q)=1.8 v(xdut.xc_0_13.qb)=0.0 v(xdut.xc_0_14.q)=0.0 v(xdut.xc_0_14.qb)=1.8 v(xdut.xc_0_15.q)=1.8 v(xdut.xc_0_15.qb)=0.0
.ic v(xdut.xc_1_0.q)=1.8 v(xdut.xc_1_0.qb)=0.0 v(xdut.xc_1_1.q)=0.0 v(xdut.xc_1_1.qb)=1.8 v(xdut.xc_1_2.q)=0.0 v(xdut.xc_1_2.qb)=1.8 v(xdut.xc_1_3.q)=1.8 v(xdut.xc_1_3.qb)=0.0 v(xdut.xc_1_4.q)=0.0 v(xdut.xc_1_4.qb)=1.8 v(xdut.xc_1_5.q)=1.8 v(xdut.xc_1_5.qb)=0.0 v(xdut.xc_1_6.q)=0.0 v(xdut.xc_1_6.qb)=1.8 v(xdut.xc_1_7.q)=0.0 v(xdut.xc_1_7.qb)=1.8
.ic v(xdut.xc_1_8.q)=1.8 v(xdut.xc_1_8.qb)=0.0 v(xdut.xc_1_9.q)=1.8 v(xdut.xc_1_9.qb)=0.0 v(xdut.xc_1_10.q)=1.8 v(xdut.xc_1_10.qb)=0.0 v(xdut.xc_1_11.q)=0.0 v(xdut.xc_1_11.qb)=1.8 v(xdut.xc_1_12.q)=1.8 v(xdut.xc_1_12.qb)=0.0 v(xdut.xc_1_13.q)=0.0 v(xdut.xc_1_13.qb)=1.8 v(xdut.xc_1_14.q)=1.8 v(xdut.xc_1_14.qb)=0.0 v(xdut.xc_1_15.q)=0.0 v(xdut.xc_1_15.qb)=1.8
.ic v(xdut.xc_2_0.q)=1.8 v(xdut.xc_2_0.qb)=0.0 v(xdut.xc_2_1.q)=0.0 v(xdut.xc_2_1.qb)=1.8 v(xdut.xc_2_2.q)=1.8 v(xdut.xc_2_2.qb)=0.0 v(xdut.xc_2_3.q)=0.0 v(xdut.xc_2_3.qb)=1.8 v(xdut.xc_2_4.q)=1.8 v(xdut.xc_2_4.qb)=0.0 v(xdut.xc_2_5.q)=0.0 v(xdut.xc_2_5.qb)=1.8 v(xdut.xc_2_6.q)=1.8 v(xdut.xc_2_6.qb)=0.0 v(xdut.xc_2_7.q)=0.0 v(xdut.xc_2_7.qb)=1.8
.ic v(xdut.xc_2_8.q)=0.0 v(xdut.xc_2_8.qb)=1.8 v(xdut.xc_2_9.q)=0.0 v(xdut.xc_2_9.qb)=1.8 v(xdut.xc_2_10.q)=1.8 v(xdut.xc_2_10.qb)=0.0 v(xdut.xc_2_11.q)=0.0 v(xdut.xc_2_11.qb)=1.8 v(xdut.xc_2_12.q)=0.0 v(xdut.xc_2_12.qb)=1.8 v(xdut.xc_2_13.q)=0.0 v(xdut.xc_2_13.qb)=1.8 v(xdut.xc_2_14.q)=0.0 v(xdut.xc_2_14.qb)=1.8 v(xdut.xc_2_15.q)=0.0 v(xdut.xc_2_15.qb)=1.8
.ic v(xdut.xc_3_0.q)=0.0 v(xdut.xc_3_0.qb)=1.8 v(xdut.xc_3_1.q)=1.8 v(xdut.xc_3_1.qb)=0.0 v(xdut.xc_3_2.q)=1.8 v(xdut.xc_3_2.qb)=0.0 v(xdut.xc_3_3.q)=0.0 v(xdut.xc_3_3.qb)=1.8 v(xdut.xc_3_4.q)=1.8 v(xdut.xc_3_4.qb)=0.0 v(xdut.xc_3_5.q)=0.0 v(xdut.xc_3_5.qb)=1.8 v(xdut.xc_3_6.q)=0.0 v(xdut.xc_3_6.qb)=1.8 v(xdut.xc_3_7.q)=1.8 v(xdut.xc_3_7.qb)=0.0
.ic v(xdut.xc_3_8.q)=0.0 v(xdut.xc_3_8.qb)=1.8 v(xdut.xc_3_9.q)=1.8 v(xdut.xc_3_9.qb)=0.0 v(xdut.xc_3_10.q)=1.8 v(xdut.xc_3_10.qb)=0.0 v(xdut.xc_3_11.q)=0.0 v(xdut.xc_3_11.qb)=1.8 v(xdut.xc_3_12.q)=1.8 v(xdut.xc_3_12.qb)=0.0 v(xdut.xc_3_13.q)=0.0 v(xdut.xc_3_13.qb)=1.8 v(xdut.xc_3_14.q)=0.0 v(xdut.xc_3_14.qb)=1.8 v(xdut.xc_3_15.q)=0.0 v(xdut.xc_3_15.qb)=1.8
.ic v(xdut.xc_4_0.q)=1.8 v(xdut.xc_4_0.qb)=0.0 v(xdut.xc_4_1.q)=1.8 v(xdut.xc_4_1.qb)=0.0 v(xdut.xc_4_2.q)=1.8 v(xdut.xc_4_2.qb)=0.0 v(xdut.xc_4_3.q)=0.0 v(xdut.xc_4_3.qb)=1.8 v(xdut.xc_4_4.q)=1.8 v(xdut.xc_4_4.qb)=0.0 v(xdut.xc_4_5.q)=1.8 v(xdut.xc_4_5.qb)=0.0 v(xdut.xc_4_6.q)=0.0 v(xdut.xc_4_6.qb)=1.8 v(xdut.xc_4_7.q)=0.0 v(xdut.xc_4_7.qb)=1.8
.ic v(xdut.xc_4_8.q)=0.0 v(xdut.xc_4_8.qb)=1.8 v(xdut.xc_4_9.q)=1.8 v(xdut.xc_4_9.qb)=0.0 v(xdut.xc_4_10.q)=0.0 v(xdut.xc_4_10.qb)=1.8 v(xdut.xc_4_11.q)=0.0 v(xdut.xc_4_11.qb)=1.8 v(xdut.xc_4_12.q)=0.0 v(xdut.xc_4_12.qb)=1.8 v(xdut.xc_4_13.q)=0.0 v(xdut.xc_4_13.qb)=1.8 v(xdut.xc_4_14.q)=1.8 v(xdut.xc_4_14.qb)=0.0 v(xdut.xc_4_15.q)=0.0 v(xdut.xc_4_15.qb)=1.8
.ic v(xdut.xc_5_0.q)=0.0 v(xdut.xc_5_0.qb)=1.8 v(xdut.xc_5_1.q)=1.8 v(xdut.xc_5_1.qb)=0.0 v(xdut.xc_5_2.q)=0.0 v(xdut.xc_5_2.qb)=1.8 v(xdut.xc_5_3.q)=0.0 v(xdut.xc_5_3.qb)=1.8 v(xdut.xc_5_4.q)=1.8 v(xdut.xc_5_4.qb)=0.0 v(xdut.xc_5_5.q)=1.8 v(xdut.xc_5_5.qb)=0.0 v(xdut.xc_5_6.q)=0.0 v(xdut.xc_5_6.qb)=1.8 v(xdut.xc_5_7.q)=1.8 v(xdut.xc_5_7.qb)=0.0
.ic v(xdut.xc_5_8.q)=0.0 v(xdut.xc_5_8.qb)=1.8 v(xdut.xc_5_9.q)=1.8 v(xdut.xc_5_9.qb)=0.0 v(xdut.xc_5_10.q)=0.0 v(xdut.xc_5_10.qb)=1.8 v(xdut.xc_5_11.q)=0.0 v(xdut.xc_5_11.qb)=1.8 v(xdut.xc_5_12.q)=1.8 v(xdut.xc_5_12.qb)=0.0 v(xdut.xc_5_13.q)=0.0 v(xdut.xc_5_13.qb)=1.8 v(xdut.xc_5_14.q)=0.0 v(xdut.xc_5_14.qb)=1.8 v(xdut.xc_5_15.q)=1.8 v(xdut.xc_5_15.qb)=0.0
.ic v(xdut.xc_6_0.q)=0.0 v(xdut.xc_6_0.qb)=1.8 v(xdut.xc_6_1.q)=1.8 v(xdut.xc_6_1.qb)=0.0 v(xdut.xc_6_2.q)=1.8 v(xdut.xc_6_2.qb)=0.0 v(xdut.xc_6_3.q)=1.8 v(xdut.xc_6_3.qb)=0.0 v(xdut.xc_6_4.q)=1.8 v(xdut.xc_6_4.qb)=0.0 v(xdut.xc_6_5.q)=1.8 v(xdut.xc_6_5.qb)=0.0 v(xdut.xc_6_6.q)=1.8 v(xdut.xc_6_6.qb)=0.0 v(xdut.xc_6_7.q)=1.8 v(xdut.xc_6_7.qb)=0.0
.ic v(xdut.xc_6_8.q)=0.0 v(xdut.xc_6_8.qb)=1.8 v(xdut.xc_6_9.q)=0.0 v(xdut.xc_6_9.qb)=1.8 v(xdut.xc_6_10.q)=0.0 v(xdut.xc_6_10.qb)=1.8 v(xdut.xc_6_11.q)=1.8 v(xdut.xc_6_11.qb)=0.0 v(xdut.xc_6_12.q)=1.8 v(xdut.xc_6_12.qb)=0.0 v(xdut.xc_6_13.q)=1.8 v(xdut.xc_6_13.qb)=0.0 v(xdut.xc_6_14.q)=0.0 v(xdut.xc_6_14.qb)=1.8 v(xdut.xc_6_15.q)=1.8 v(xdut.xc_6_15.qb)=0.0
.ic v(xdut.xc_7_0.q)=0.0 v(xdut.xc_7_0.qb)=1.8 v(xdut.xc_7_1.q)=1.8 v(xdut.xc_7_1.qb)=0.0 v(xdut.xc_7_2.q)=0.0 v(xdut.xc_7_2.qb)=1.8 v(xdut.xc_7_3.q)=1.8 v(xdut.xc_7_3.qb)=0.0 v(xdut.xc_7_4.q)=0.0 v(xdut.xc_7_4.qb)=1.8 v(xdut.xc_7_5.q)=0.0 v(xdut.xc_7_5.qb)=1.8 v(xdut.xc_7_6.q)=1.8 v(xdut.xc_7_6.qb)=0.0 v(xdut.xc_7_7.q)=1.8 v(xdut.xc_7_7.qb)=0.0
.ic v(xdut.xc_7_8.q)=1.8 v(xdut.xc_7_8.qb)=0.0 v(xdut.xc_7_9.q)=0.0 v(xdut.xc_7_9.qb)=1.8 v(xdut.xc_7_10.q)=1.8 v(xdut.xc_7_10.qb)=0.0 v(xdut.xc_7_11.q)=1.8 v(xdut.xc_7_11.qb)=0.0 v(xdut.xc_7_12.q)=1.8 v(xdut.xc_7_12.qb)=0.0 v(xdut.xc_7_13.q)=0.0 v(xdut.xc_7_13.qb)=1.8 v(xdut.xc_7_14.q)=1.8 v(xdut.xc_7_14.qb)=0.0 v(xdut.xc_7_15.q)=1.8 v(xdut.xc_7_15.qb)=0.0
.ic v(xdut.xc_8_0.q)=1.8 v(xdut.xc_8_0.qb)=0.0 v(xdut.xc_8_1.q)=0.0 v(xdut.xc_8_1.qb)=1.8 v(xdut.xc_8_2.q)=1.8 v(xdut.xc_8_2.qb)=0.0 v(xdut.xc_8_3.q)=1.8 v(xdut.xc_8_3.qb)=0.0 v(xdut.xc_8_4.q)=1.8 v(xdut.xc_8_4.qb)=0.0 v(xdut.xc_8_5.q)=1.8 v(xdut.xc_8_5.qb)=0.0 v(xdut.xc_8_6.q)=0.0 v(xdut.xc_8_6.qb)=1.8 v(xdut.xc_8_7.q)=1.8 v(xdut.xc_8_7.qb)=0.0
.ic v(xdut.xc_8_8.q)=1.8 v(xdut.xc_8_8.qb)=0.0 v(xdut.xc_8_9.q)=1.8 v(xdut.xc_8_9.qb)=0.0 v(xdut.xc_8_10.q)=0.0 v(xdut.xc_8_10.qb)=1.8 v(xdut.xc_8_11.q)=1.8 v(xdut.xc_8_11.qb)=0.0 v(xdut.xc_8_12.q)=1.8 v(xdut.xc_8_12.qb)=0.0 v(xdut.xc_8_13.q)=0.0 v(xdut.xc_8_13.qb)=1.8 v(xdut.xc_8_14.q)=1.8 v(xdut.xc_8_14.qb)=0.0 v(xdut.xc_8_15.q)=0.0 v(xdut.xc_8_15.qb)=1.8
.ic v(xdut.xc_9_0.q)=1.8 v(xdut.xc_9_0.qb)=0.0 v(xdut.xc_9_1.q)=1.8 v(xdut.xc_9_1.qb)=0.0 v(xdut.xc_9_2.q)=0.0 v(xdut.xc_9_2.qb)=1.8 v(xdut.xc_9_3.q)=0.0 v(xdut.xc_9_3.qb)=1.8 v(xdut.xc_9_4.q)=1.8 v(xdut.xc_9_4.qb)=0.0 v(xdut.xc_9_5.q)=1.8 v(xdut.xc_9_5.qb)=0.0 v(xdut.xc_9_6.q)=0.0 v(xdut.xc_9_6.qb)=1.8 v(xdut.xc_9_7.q)=1.8 v(xdut.xc_9_7.qb)=0.0
.ic v(xdut.xc_9_8.q)=1.8 v(xdut.xc_9_8.qb)=0.0 v(xdut.xc_9_9.q)=1.8 v(xdut.xc_9_9.qb)=0.0 v(xdut.xc_9_10.q)=0.0 v(xdut.xc_9_10.qb)=1.8 v(xdut.xc_9_11.q)=0.0 v(xdut.xc_9_11.qb)=1.8 v(xdut.xc_9_12.q)=0.0 v(xdut.xc_9_12.qb)=1.8 v(xdut.xc_9_13.q)=0.0 v(xdut.xc_9_13.qb)=1.8 v(xdut.xc_9_14.q)=1.8 v(xdut.xc_9_14.qb)=0.0 v(xdut.xc_9_15.q)=0.0 v(xdut.xc_9_15.qb)=1.8
.ic v(xdut.xc_10_0.q)=1.8 v(xdut.xc_10_0.qb)=0.0 v(xdut.xc_10_1.q)=0.0 v(xdut.xc_10_1.qb)=1.8 v(xdut.xc_10_2.q)=1.8 v(xdut.xc_10_2.qb)=0.0 v(xdut.xc_10_3.q)=1.8 v(xdut.xc_10_3.qb)=0.0 v(xdut.xc_10_4.q)=1.8 v(xdut.xc_10_4.qb)=0.0 v(xdut.xc_10_5.q)=1.8 v(xdut.xc_10_5.qb)=0.0 v(xdut.xc_10_6.q)=0.0 v(xdut.xc_10_6.qb)=1.8 v(xdut.xc_10_7.q)=0.0 v(xdut.xc_10_7.qb)=1.8
.ic v(xdut.xc_10_8.q)=0.0 v(xdut.xc_10_8.qb)=1.8 v(xdut.xc_10_9.q)=1.8 v(xdut.xc_10_9.qb)=0.0 v(xdut.xc_10_10.q)=0.0 v(xdut.xc_10_10.qb)=1.8 v(xdut.xc_10_11.q)=0.0 v(xdut.xc_10_11.qb)=1.8 v(xdut.xc_10_12.q)=0.0 v(xdut.xc_10_12.qb)=1.8 v(xdut.xc_10_13.q)=1.8 v(xdut.xc_10_13.qb)=0.0 v(xdut.xc_10_14.q)=1.8 v(xdut.xc_10_14.qb)=0.0 v(xdut.xc_10_15.q)=1.8 v(xdut.xc_10_15.qb)=0.0
.ic v(xdut.xc_11_0.q)=1.8 v(xdut.xc_11_0.qb)=0.0 v(xdut.xc_11_1.q)=0.0 v(xdut.xc_11_1.qb)=1.8 v(xdut.xc_11_2.q)=0.0 v(xdut.xc_11_2.qb)=1.8 v(xdut.xc_11_3.q)=1.8 v(xdut.xc_11_3.qb)=0.0 v(xdut.xc_11_4.q)=1.8 v(xdut.xc_11_4.qb)=0.0 v(xdut.xc_11_5.q)=0.0 v(xdut.xc_11_5.qb)=1.8 v(xdut.xc_11_6.q)=1.8 v(xdut.xc_11_6.qb)=0.0 v(xdut.xc_11_7.q)=1.8 v(xdut.xc_11_7.qb)=0.0
.ic v(xdut.xc_11_8.q)=1.8 v(xdut.xc_11_8.qb)=0.0 v(xdut.xc_11_9.q)=0.0 v(xdut.xc_11_9.qb)=1.8 v(xdut.xc_11_10.q)=0.0 v(xdut.xc_11_10.qb)=1.8 v(xdut.xc_11_11.q)=1.8 v(xdut.xc_11_11.qb)=0.0 v(xdut.xc_11_12.q)=1.8 v(xdut.xc_11_12.qb)=0.0 v(xdut.xc_11_13.q)=1.8 v(xdut.xc_11_13.qb)=0.0 v(xdut.xc_11_14.q)=0.0 v(xdut.xc_11_14.qb)=1.8 v(xdut.xc_11_15.q)=1.8 v(xdut.xc_11_15.qb)=0.0
.ic v(xdut.xc_12_0.q)=1.8 v(xdut.xc_12_0.qb)=0.0 v(xdut.xc_12_1.q)=0.0 v(xdut.xc_12_1.qb)=1.8 v(xdut.xc_12_2.q)=1.8 v(xdut.xc_12_2.qb)=0.0 v(xdut.xc_12_3.q)=1.8 v(xdut.xc_12_3.qb)=0.0 v(xdut.xc_12_4.q)=1.8 v(xdut.xc_12_4.qb)=0.0 v(xdut.xc_12_5.q)=0.0 v(xdut.xc_12_5.qb)=1.8 v(xdut.xc_12_6.q)=1.8 v(xdut.xc_12_6.qb)=0.0 v(xdut.xc_12_7.q)=1.8 v(xdut.xc_12_7.qb)=0.0
.ic v(xdut.xc_12_8.q)=0.0 v(xdut.xc_12_8.qb)=1.8 v(xdut.xc_12_9.q)=0.0 v(xdut.xc_12_9.qb)=1.8 v(xdut.xc_12_10.q)=0.0 v(xdut.xc_12_10.qb)=1.8 v(xdut.xc_12_11.q)=1.8 v(xdut.xc_12_11.qb)=0.0 v(xdut.xc_12_12.q)=0.0 v(xdut.xc_12_12.qb)=1.8 v(xdut.xc_12_13.q)=0.0 v(xdut.xc_12_13.qb)=1.8 v(xdut.xc_12_14.q)=1.8 v(xdut.xc_12_14.qb)=0.0 v(xdut.xc_12_15.q)=1.8 v(xdut.xc_12_15.qb)=0.0
.ic v(xdut.xc_13_0.q)=0.0 v(xdut.xc_13_0.qb)=1.8 v(xdut.xc_13_1.q)=1.8 v(xdut.xc_13_1.qb)=0.0 v(xdut.xc_13_2.q)=0.0 v(xdut.xc_13_2.qb)=1.8 v(xdut.xc_13_3.q)=1.8 v(xdut.xc_13_3.qb)=0.0 v(xdut.xc_13_4.q)=0.0 v(xdut.xc_13_4.qb)=1.8 v(xdut.xc_13_5.q)=1.8 v(xdut.xc_13_5.qb)=0.0 v(xdut.xc_13_6.q)=1.8 v(xdut.xc_13_6.qb)=0.0 v(xdut.xc_13_7.q)=1.8 v(xdut.xc_13_7.qb)=0.0
.ic v(xdut.xc_13_8.q)=0.0 v(xdut.xc_13_8.qb)=1.8 v(xdut.xc_13_9.q)=0.0 v(xdut.xc_13_9.qb)=1.8 v(xdut.xc_13_10.q)=0.0 v(xdut.xc_13_10.qb)=1.8 v(xdut.xc_13_11.q)=1.8 v(xdut.xc_13_11.qb)=0.0 v(xdut.xc_13_12.q)=0.0 v(xdut.xc_13_12.qb)=1.8 v(xdut.xc_13_13.q)=0.0 v(xdut.xc_13_13.qb)=1.8 v(xdut.xc_13_14.q)=1.8 v(xdut.xc_13_14.qb)=0.0 v(xdut.xc_13_15.q)=0.0 v(xdut.xc_13_15.qb)=1.8
.ic v(xdut.xc_14_0.q)=1.8 v(xdut.xc_14_0.qb)=0.0 v(xdut.xc_14_1.q)=0.0 v(xdut.xc_14_1.qb)=1.8 v(xdut.xc_14_2.q)=1.8 v(xdut.xc_14_2.qb)=0.0 v(xdut.xc_14_3.q)=0.0 v(xdut.xc_14_3.qb)=1.8 v(xdut.xc_14_4.q)=1.8 v(xdut.xc_14_4.qb)=0.0 v(xdut.xc_14_5.q)=0.0 v(xdut.xc_14_5.qb)=1.8 v(xdut.xc_14_6.q)=0.0 v(xdut.xc_14_6.qb)=1.8 v(xdut.xc_14_7.q)=0.0 v(xdut.xc_14_7.qb)=1.8
.ic v(xdut.xc_14_8.q)=1.8 v(xdut.xc_14_8.qb)=0.0 v(xdut.xc_14_9.q)=0.0 v(xdut.xc_14_9.qb)=1.8 v(xdut.xc_14_10.q)=1.8 v(xdut.xc_14_10.qb)=0.0 v(xdut.xc_14_11.q)=1.8 v(xdut.xc_14_11.qb)=0.0 v(xdut.xc_14_12.q)=1.8 v(xdut.xc_14_12.qb)=0.0 v(xdut.xc_14_13.q)=0.0 v(xdut.xc_14_13.qb)=1.8 v(xdut.xc_14_14.q)=0.0 v(xdut.xc_14_14.qb)=1.8 v(xdut.xc_14_15.q)=0.0 v(xdut.xc_14_15.qb)=1.8
.ic v(xdut.xc_15_0.q)=1.8 v(xdut.xc_15_0.qb)=0.0 v(xdut.xc_15_1.q)=0.0 v(xdut.xc_15_1.qb)=1.8 v(xdut.xc_15_2.q)=0.0 v(xdut.xc_15_2.qb)=1.8 v(xdut.xc_15_3.q)=0.0 v(xdut.xc_15_3.qb)=1.8 v(xdut.xc_15_4.q)=0.0 v(xdut.xc_15_4.qb)=1.8 v(xdut.xc_15_5.q)=0.0 v(xdut.xc_15_5.qb)=1.8 v(xdut.xc_15_6.q)=0.0 v(xdut.xc_15_6.qb)=1.8 v(xdut.xc_15_7.q)=0.0 v(xdut.xc_15_7.qb)=1.8
.ic v(xdut.xc_15_8.q)=1.8 v(xdut.xc_15_8.qb)=0.0 v(xdut.xc_15_9.q)=0.0 v(xdut.xc_15_9.qb)=1.8 v(xdut.xc_15_10.q)=1.8 v(xdut.xc_15_10.qb)=0.0 v(xdut.xc_15_11.q)=0.0 v(xdut.xc_15_11.qb)=1.8 v(xdut.xc_15_12.q)=0.0 v(xdut.xc_15_12.qb)=1.8 v(xdut.xc_15_13.q)=1.8 v(xdut.xc_15_13.qb)=0.0 v(xdut.xc_15_14.q)=0.0 v(xdut.xc_15_14.qb)=1.8 v(xdut.xc_15_15.q)=1.8 v(xdut.xc_15_15.qb)=0.0
.option reltol=1e-3
.tran 2.500e-11 8.3125e-08
.save v(CLK) v(ADDR) v(RW) v(DIN) v(DOUT) v(xdut.rdqb) v(xdut.rd) v(xdut.dl) v(xdut.dlb) v(xdut.pcb) v(xdut.clkb) v(xdut.clk_ff) v(xdut.we) v(xdut.wl0) v(xdut.wl15) v(xdut.bl0) v(xdut.blb0) v(xdut.bl15) v(xdut.blb15) v(xdut.xc_0_0.q) v(xdut.xc_15_15.q) i(Vdd) i(Vddio)
.control
set wr_singlescale
set wr_vecnames
run
wrdata s1re_fmax_1.25.dat v(CLK) v(ADDR) v(RW) v(DIN) v(DOUT) v(xdut.rdqb) v(xdut.rd) v(xdut.dl) v(xdut.dlb) v(xdut.pcb) v(xdut.clkb) v(xdut.we) v(xdut.wl0) v(xdut.wl15) v(xdut.bl0) v(xdut.blb0) v(xdut.bl15) v(xdut.blb15) v(xdut.xc_0_0.q) v(xdut.xc_15_15.q) i(Vdd) i(Vddio) v(xdut.clk_ff)
.endc
.end
