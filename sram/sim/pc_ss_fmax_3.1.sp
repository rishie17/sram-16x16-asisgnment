* post-layout rand64 T=3.100 ns
.lib /foss/pdks/sky130A/libs.tech/ngspice/sky130.lib.spice ss
.include /foss/designs/sram/sim/net_pc_ss_fmax_3.1.spice
Vdd vdd 0 1.8
Vddio vddio 0 1.8
Vclk clk_src 0 PULSE(0 1.8 1.5500e-09 5.00e-11 5.00e-11 1.5000e-09 3.1000e-09)
Rclk clk_src CLK 50
Vaddr ADDR_src 0 PWL(0.0000e+00 0.00 3.1000e-09 0.00 3.1500e-09 1.80 6.2000e-09 1.80 6.2500e-09 0.00 1.5500e-08 0.00 1.5550e-08 1.80 2.7900e-08 1.80 2.7950e-08 0.00 3.1000e-08 0.00 3.1050e-08 1.80 3.7200e-08 1.80 3.7250e-08 0.00 4.0300e-08 0.00 4.0350e-08 1.80 4.3400e-08 1.80 4.3450e-08 0.00 5.5800e-08 0.00 5.5850e-08 1.80 6.5100e-08 1.80 6.5150e-08 0.00 6.8200e-08 0.00 6.8250e-08 1.80 7.1300e-08 1.80 7.1350e-08 0.00 7.4400e-08 0.00 7.4450e-08 1.80 7.7500e-08 1.80 7.7550e-08 0.00 8.0600e-08 0.00 8.0650e-08 1.80 8.3700e-08 1.80 8.3750e-08 0.00 8.6800e-08 0.00 8.6850e-08 1.80 8.9900e-08 1.80 8.9950e-08 0.00 9.9200e-08 0.00 9.9250e-08 1.80 1.0540e-07 1.80 1.0545e-07 0.00 1.0850e-07 0.00 1.0855e-07 1.80 1.1470e-07 1.80 1.1475e-07 0.00 1.2710e-07 0.00 1.2715e-07 1.80 1.3330e-07 1.80 1.3335e-07 0.00 1.4260e-07 0.00 1.4265e-07 1.80 1.4570e-07 1.80 1.4575e-07 0.00 1.5190e-07 0.00 1.5195e-07 1.80 1.5500e-07 1.80 1.5505e-07 0.00 1.5810e-07 0.00 1.5815e-07 1.80 1.6120e-07 1.80 1.6125e-07 0.00 1.6430e-07 0.00 1.6435e-07 1.80 1.6740e-07 1.80 1.6745e-07 0.00 1.7050e-07 0.00 1.7055e-07 1.80 1.7360e-07 1.80 1.7365e-07 0.00 1.7670e-07 0.00 1.7675e-07 1.80 1.7980e-07 1.80 1.7985e-07 0.00 1.8910e-07 0.00 1.8915e-07 1.80 1.9840e-07 1.80 1.9845e-07 0.00)
Raddr ADDR_src ADDR 50
Vrw RW_src 0 PWL(0.0000e+00 0.00 6.5100e-08 0.00 6.5150e-08 1.80 6.8200e-08 1.80 6.8250e-08 0.00 7.1300e-08 0.00 7.1350e-08 1.80 7.4400e-08 1.80 7.4450e-08 0.00 7.7500e-08 0.00 7.7550e-08 1.80 8.3700e-08 1.80 8.3750e-08 0.00 9.9200e-08 0.00 9.9250e-08 1.80 1.0230e-07 1.80 1.0235e-07 0.00 1.0540e-07 0.00 1.0545e-07 1.80 1.0850e-07 1.80 1.0855e-07 0.00 1.2400e-07 0.00 1.2405e-07 1.80 1.3330e-07 1.80 1.3335e-07 0.00 1.3640e-07 0.00 1.3645e-07 1.80 1.4570e-07 1.80 1.4575e-07 0.00 1.4880e-07 0.00 1.4885e-07 1.80 1.5190e-07 1.80 1.5195e-07 0.00 1.6120e-07 0.00 1.6125e-07 1.80 1.6740e-07 1.80 1.6745e-07 0.00 1.7980e-07 0.00 1.7985e-07 1.80 1.8290e-07 1.80 1.8295e-07 0.00)
Rrw RW_src RW 50
Vdin DIN_src 0 PWL(0.0000e+00 1.80 3.1000e-09 1.80 3.1500e-09 0.00 1.8600e-08 0.00 1.8650e-08 1.80 2.7900e-08 1.80 2.7950e-08 0.00 3.1000e-08 0.00 3.1050e-08 1.80 3.7200e-08 1.80 3.7250e-08 0.00 4.0300e-08 0.00 4.0350e-08 1.80 4.9600e-08 1.80 4.9650e-08 0.00 5.8900e-08 0.00 5.8950e-08 1.80 6.5100e-08 1.80 6.5150e-08 0.00 6.8200e-08 0.00 6.8250e-08 1.80 7.4400e-08 1.80 7.4450e-08 0.00 8.0600e-08 0.00 8.0650e-08 1.80 8.9900e-08 1.80 8.9950e-08 0.00 9.9200e-08 0.00 9.9250e-08 1.80 1.0850e-07 1.80 1.0855e-07 0.00 1.1470e-07 0.00 1.1475e-07 1.80 1.2090e-07 1.80 1.2095e-07 0.00 1.3020e-07 0.00 1.3025e-07 1.80 1.3640e-07 1.80 1.3645e-07 0.00 1.3950e-07 0.00 1.3955e-07 1.80 1.4260e-07 1.80 1.4265e-07 0.00 1.4570e-07 0.00 1.4575e-07 1.80 1.4880e-07 1.80 1.4885e-07 0.00 1.5190e-07 0.00 1.5195e-07 1.80 1.6120e-07 1.80 1.6125e-07 0.00 1.7360e-07 0.00 1.7365e-07 1.80 1.7670e-07 1.80 1.7675e-07 0.00 1.7980e-07 0.00 1.7985e-07 1.80 1.8600e-07 1.80 1.8605e-07 0.00 1.8910e-07 0.00 1.8915e-07 1.80 1.9530e-07 1.80 1.9535e-07 0.00)
Rdin DIN_src DIN 50
Cload DOUT 0 5.000e-12
Rbw_CLK CLK b_CLK 0.2
Lbw_CLK b_CLK p_CLK 2n
Cpad_CLK p_CLK 0 1p
Rbw_ADDR ADDR b_ADDR 0.2
Lbw_ADDR b_ADDR p_ADDR 2n
Cpad_ADDR p_ADDR 0 1p
Rbw_RW RW b_RW 0.2
Lbw_RW b_RW p_RW 2n
Cpad_RW p_RW 0 1p
Rbw_DIN DIN b_DIN 0.2
Lbw_DIN b_DIN p_DIN 2n
Cpad_DIN p_DIN 0 1p
Rbw_DOUT DOUT b_DOUT 0.2
Lbw_DOUT b_DOUT p_DOUT 2n
Cpad_DOUT p_DOUT 0 1p
Xtop p_DOUT vddio 0 vdd p_CLK p_ADDR p_RW p_DIN sram_top
.ic v(xtop.chip/core/c_0_0/q)=1.8 v(xtop.chip/core/c_0_0/qb)=0.0 v(xtop.chip/core/c_0_1/q)=1.8 v(xtop.chip/core/c_0_1/qb)=0.0 v(xtop.chip/core/c_0_2/q)=0.0 v(xtop.chip/core/c_0_2/qb)=1.8 v(xtop.chip/core/c_0_3/q)=0.0 v(xtop.chip/core/c_0_3/qb)=1.8 v(xtop.chip/core/c_0_4/q)=0.0 v(xtop.chip/core/c_0_4/qb)=1.8 v(xtop.chip/core/c_0_5/q)=0.0 v(xtop.chip/core/c_0_5/qb)=1.8 v(xtop.chip/core/c_0_6/q)=0.0 v(xtop.chip/core/c_0_6/qb)=1.8 v(xtop.chip/core/c_0_7/q)=0.0 v(xtop.chip/core/c_0_7/qb)=1.8
.ic v(xtop.chip/core/c_0_8/q)=1.8 v(xtop.chip/core/c_0_8/qb)=0.0 v(xtop.chip/core/c_0_9/q)=1.8 v(xtop.chip/core/c_0_9/qb)=0.0 v(xtop.chip/core/c_0_10/q)=0.0 v(xtop.chip/core/c_0_10/qb)=1.8 v(xtop.chip/core/c_0_11/q)=1.8 v(xtop.chip/core/c_0_11/qb)=0.0 v(xtop.chip/core/c_0_12/q)=0.0 v(xtop.chip/core/c_0_12/qb)=1.8 v(xtop.chip/core/c_0_13/q)=1.8 v(xtop.chip/core/c_0_13/qb)=0.0 v(xtop.chip/core/c_0_14/q)=0.0 v(xtop.chip/core/c_0_14/qb)=1.8 v(xtop.chip/core/c_0_15/q)=1.8 v(xtop.chip/core/c_0_15/qb)=0.0
.ic v(xtop.chip/core/c_1_0/q)=1.8 v(xtop.chip/core/c_1_0/qb)=0.0 v(xtop.chip/core/c_1_1/q)=0.0 v(xtop.chip/core/c_1_1/qb)=1.8 v(xtop.chip/core/c_1_2/q)=0.0 v(xtop.chip/core/c_1_2/qb)=1.8 v(xtop.chip/core/c_1_3/q)=1.8 v(xtop.chip/core/c_1_3/qb)=0.0 v(xtop.chip/core/c_1_4/q)=0.0 v(xtop.chip/core/c_1_4/qb)=1.8 v(xtop.chip/core/c_1_5/q)=1.8 v(xtop.chip/core/c_1_5/qb)=0.0 v(xtop.chip/core/c_1_6/q)=0.0 v(xtop.chip/core/c_1_6/qb)=1.8 v(xtop.chip/core/c_1_7/q)=0.0 v(xtop.chip/core/c_1_7/qb)=1.8
.ic v(xtop.chip/core/c_1_8/q)=1.8 v(xtop.chip/core/c_1_8/qb)=0.0 v(xtop.chip/core/c_1_9/q)=1.8 v(xtop.chip/core/c_1_9/qb)=0.0 v(xtop.chip/core/c_1_10/q)=1.8 v(xtop.chip/core/c_1_10/qb)=0.0 v(xtop.chip/core/c_1_11/q)=0.0 v(xtop.chip/core/c_1_11/qb)=1.8 v(xtop.chip/core/c_1_12/q)=1.8 v(xtop.chip/core/c_1_12/qb)=0.0 v(xtop.chip/core/c_1_13/q)=0.0 v(xtop.chip/core/c_1_13/qb)=1.8 v(xtop.chip/core/c_1_14/q)=1.8 v(xtop.chip/core/c_1_14/qb)=0.0 v(xtop.chip/core/c_1_15/q)=0.0 v(xtop.chip/core/c_1_15/qb)=1.8
.ic v(xtop.chip/core/c_2_0/q)=1.8 v(xtop.chip/core/c_2_0/qb)=0.0 v(xtop.chip/core/c_2_1/q)=0.0 v(xtop.chip/core/c_2_1/qb)=1.8 v(xtop.chip/core/c_2_2/q)=1.8 v(xtop.chip/core/c_2_2/qb)=0.0 v(xtop.chip/core/c_2_3/q)=0.0 v(xtop.chip/core/c_2_3/qb)=1.8 v(xtop.chip/core/c_2_4/q)=1.8 v(xtop.chip/core/c_2_4/qb)=0.0 v(xtop.chip/core/c_2_5/q)=0.0 v(xtop.chip/core/c_2_5/qb)=1.8 v(xtop.chip/core/c_2_6/q)=1.8 v(xtop.chip/core/c_2_6/qb)=0.0 v(xtop.chip/core/c_2_7/q)=0.0 v(xtop.chip/core/c_2_7/qb)=1.8
.ic v(xtop.chip/core/c_2_8/q)=0.0 v(xtop.chip/core/c_2_8/qb)=1.8 v(xtop.chip/core/c_2_9/q)=0.0 v(xtop.chip/core/c_2_9/qb)=1.8 v(xtop.chip/core/c_2_10/q)=1.8 v(xtop.chip/core/c_2_10/qb)=0.0 v(xtop.chip/core/c_2_11/q)=0.0 v(xtop.chip/core/c_2_11/qb)=1.8 v(xtop.chip/core/c_2_12/q)=0.0 v(xtop.chip/core/c_2_12/qb)=1.8 v(xtop.chip/core/c_2_13/q)=0.0 v(xtop.chip/core/c_2_13/qb)=1.8 v(xtop.chip/core/c_2_14/q)=0.0 v(xtop.chip/core/c_2_14/qb)=1.8 v(xtop.chip/core/c_2_15/q)=0.0 v(xtop.chip/core/c_2_15/qb)=1.8
.ic v(xtop.chip/core/c_3_0/q)=0.0 v(xtop.chip/core/c_3_0/qb)=1.8 v(xtop.chip/core/c_3_1/q)=1.8 v(xtop.chip/core/c_3_1/qb)=0.0 v(xtop.chip/core/c_3_2/q)=1.8 v(xtop.chip/core/c_3_2/qb)=0.0 v(xtop.chip/core/c_3_3/q)=0.0 v(xtop.chip/core/c_3_3/qb)=1.8 v(xtop.chip/core/c_3_4/q)=1.8 v(xtop.chip/core/c_3_4/qb)=0.0 v(xtop.chip/core/c_3_5/q)=0.0 v(xtop.chip/core/c_3_5/qb)=1.8 v(xtop.chip/core/c_3_6/q)=0.0 v(xtop.chip/core/c_3_6/qb)=1.8 v(xtop.chip/core/c_3_7/q)=1.8 v(xtop.chip/core/c_3_7/qb)=0.0
.ic v(xtop.chip/core/c_3_8/q)=0.0 v(xtop.chip/core/c_3_8/qb)=1.8 v(xtop.chip/core/c_3_9/q)=1.8 v(xtop.chip/core/c_3_9/qb)=0.0 v(xtop.chip/core/c_3_10/q)=1.8 v(xtop.chip/core/c_3_10/qb)=0.0 v(xtop.chip/core/c_3_11/q)=0.0 v(xtop.chip/core/c_3_11/qb)=1.8 v(xtop.chip/core/c_3_12/q)=1.8 v(xtop.chip/core/c_3_12/qb)=0.0 v(xtop.chip/core/c_3_13/q)=0.0 v(xtop.chip/core/c_3_13/qb)=1.8 v(xtop.chip/core/c_3_14/q)=0.0 v(xtop.chip/core/c_3_14/qb)=1.8 v(xtop.chip/core/c_3_15/q)=0.0 v(xtop.chip/core/c_3_15/qb)=1.8
.ic v(xtop.chip/core/c_4_0/q)=1.8 v(xtop.chip/core/c_4_0/qb)=0.0 v(xtop.chip/core/c_4_1/q)=1.8 v(xtop.chip/core/c_4_1/qb)=0.0 v(xtop.chip/core/c_4_2/q)=1.8 v(xtop.chip/core/c_4_2/qb)=0.0 v(xtop.chip/core/c_4_3/q)=0.0 v(xtop.chip/core/c_4_3/qb)=1.8 v(xtop.chip/core/c_4_4/q)=1.8 v(xtop.chip/core/c_4_4/qb)=0.0 v(xtop.chip/core/c_4_5/q)=1.8 v(xtop.chip/core/c_4_5/qb)=0.0 v(xtop.chip/core/c_4_6/q)=0.0 v(xtop.chip/core/c_4_6/qb)=1.8 v(xtop.chip/core/c_4_7/q)=0.0 v(xtop.chip/core/c_4_7/qb)=1.8
.ic v(xtop.chip/core/c_4_8/q)=0.0 v(xtop.chip/core/c_4_8/qb)=1.8 v(xtop.chip/core/c_4_9/q)=1.8 v(xtop.chip/core/c_4_9/qb)=0.0 v(xtop.chip/core/c_4_10/q)=0.0 v(xtop.chip/core/c_4_10/qb)=1.8 v(xtop.chip/core/c_4_11/q)=0.0 v(xtop.chip/core/c_4_11/qb)=1.8 v(xtop.chip/core/c_4_12/q)=0.0 v(xtop.chip/core/c_4_12/qb)=1.8 v(xtop.chip/core/c_4_13/q)=0.0 v(xtop.chip/core/c_4_13/qb)=1.8 v(xtop.chip/core/c_4_14/q)=1.8 v(xtop.chip/core/c_4_14/qb)=0.0 v(xtop.chip/core/c_4_15/q)=0.0 v(xtop.chip/core/c_4_15/qb)=1.8
.ic v(xtop.chip/core/c_5_0/q)=0.0 v(xtop.chip/core/c_5_0/qb)=1.8 v(xtop.chip/core/c_5_1/q)=1.8 v(xtop.chip/core/c_5_1/qb)=0.0 v(xtop.chip/core/c_5_2/q)=0.0 v(xtop.chip/core/c_5_2/qb)=1.8 v(xtop.chip/core/c_5_3/q)=0.0 v(xtop.chip/core/c_5_3/qb)=1.8 v(xtop.chip/core/c_5_4/q)=1.8 v(xtop.chip/core/c_5_4/qb)=0.0 v(xtop.chip/core/c_5_5/q)=1.8 v(xtop.chip/core/c_5_5/qb)=0.0 v(xtop.chip/core/c_5_6/q)=0.0 v(xtop.chip/core/c_5_6/qb)=1.8 v(xtop.chip/core/c_5_7/q)=1.8 v(xtop.chip/core/c_5_7/qb)=0.0
.ic v(xtop.chip/core/c_5_8/q)=0.0 v(xtop.chip/core/c_5_8/qb)=1.8 v(xtop.chip/core/c_5_9/q)=1.8 v(xtop.chip/core/c_5_9/qb)=0.0 v(xtop.chip/core/c_5_10/q)=0.0 v(xtop.chip/core/c_5_10/qb)=1.8 v(xtop.chip/core/c_5_11/q)=0.0 v(xtop.chip/core/c_5_11/qb)=1.8 v(xtop.chip/core/c_5_12/q)=1.8 v(xtop.chip/core/c_5_12/qb)=0.0 v(xtop.chip/core/c_5_13/q)=0.0 v(xtop.chip/core/c_5_13/qb)=1.8 v(xtop.chip/core/c_5_14/q)=0.0 v(xtop.chip/core/c_5_14/qb)=1.8 v(xtop.chip/core/c_5_15/q)=1.8 v(xtop.chip/core/c_5_15/qb)=0.0
.ic v(xtop.chip/core/c_6_0/q)=0.0 v(xtop.chip/core/c_6_0/qb)=1.8 v(xtop.chip/core/c_6_1/q)=1.8 v(xtop.chip/core/c_6_1/qb)=0.0 v(xtop.chip/core/c_6_2/q)=1.8 v(xtop.chip/core/c_6_2/qb)=0.0 v(xtop.chip/core/c_6_3/q)=1.8 v(xtop.chip/core/c_6_3/qb)=0.0 v(xtop.chip/core/c_6_4/q)=1.8 v(xtop.chip/core/c_6_4/qb)=0.0 v(xtop.chip/core/c_6_5/q)=1.8 v(xtop.chip/core/c_6_5/qb)=0.0 v(xtop.chip/core/c_6_6/q)=1.8 v(xtop.chip/core/c_6_6/qb)=0.0 v(xtop.chip/core/c_6_7/q)=1.8 v(xtop.chip/core/c_6_7/qb)=0.0
.ic v(xtop.chip/core/c_6_8/q)=0.0 v(xtop.chip/core/c_6_8/qb)=1.8 v(xtop.chip/core/c_6_9/q)=0.0 v(xtop.chip/core/c_6_9/qb)=1.8 v(xtop.chip/core/c_6_10/q)=0.0 v(xtop.chip/core/c_6_10/qb)=1.8 v(xtop.chip/core/c_6_11/q)=1.8 v(xtop.chip/core/c_6_11/qb)=0.0 v(xtop.chip/core/c_6_12/q)=1.8 v(xtop.chip/core/c_6_12/qb)=0.0 v(xtop.chip/core/c_6_13/q)=1.8 v(xtop.chip/core/c_6_13/qb)=0.0 v(xtop.chip/core/c_6_14/q)=0.0 v(xtop.chip/core/c_6_14/qb)=1.8 v(xtop.chip/core/c_6_15/q)=1.8 v(xtop.chip/core/c_6_15/qb)=0.0
.ic v(xtop.chip/core/c_7_0/q)=0.0 v(xtop.chip/core/c_7_0/qb)=1.8 v(xtop.chip/core/c_7_1/q)=1.8 v(xtop.chip/core/c_7_1/qb)=0.0 v(xtop.chip/core/c_7_2/q)=0.0 v(xtop.chip/core/c_7_2/qb)=1.8 v(xtop.chip/core/c_7_3/q)=1.8 v(xtop.chip/core/c_7_3/qb)=0.0 v(xtop.chip/core/c_7_4/q)=0.0 v(xtop.chip/core/c_7_4/qb)=1.8 v(xtop.chip/core/c_7_5/q)=0.0 v(xtop.chip/core/c_7_5/qb)=1.8 v(xtop.chip/core/c_7_6/q)=1.8 v(xtop.chip/core/c_7_6/qb)=0.0 v(xtop.chip/core/c_7_7/q)=1.8 v(xtop.chip/core/c_7_7/qb)=0.0
.ic v(xtop.chip/core/c_7_8/q)=1.8 v(xtop.chip/core/c_7_8/qb)=0.0 v(xtop.chip/core/c_7_9/q)=0.0 v(xtop.chip/core/c_7_9/qb)=1.8 v(xtop.chip/core/c_7_10/q)=1.8 v(xtop.chip/core/c_7_10/qb)=0.0 v(xtop.chip/core/c_7_11/q)=1.8 v(xtop.chip/core/c_7_11/qb)=0.0 v(xtop.chip/core/c_7_12/q)=1.8 v(xtop.chip/core/c_7_12/qb)=0.0 v(xtop.chip/core/c_7_13/q)=0.0 v(xtop.chip/core/c_7_13/qb)=1.8 v(xtop.chip/core/c_7_14/q)=1.8 v(xtop.chip/core/c_7_14/qb)=0.0 v(xtop.chip/core/c_7_15/q)=1.8 v(xtop.chip/core/c_7_15/qb)=0.0
.ic v(xtop.chip/core/c_8_0/q)=1.8 v(xtop.chip/core/c_8_0/qb)=0.0 v(xtop.chip/core/c_8_1/q)=0.0 v(xtop.chip/core/c_8_1/qb)=1.8 v(xtop.chip/core/c_8_2/q)=1.8 v(xtop.chip/core/c_8_2/qb)=0.0 v(xtop.chip/core/c_8_3/q)=1.8 v(xtop.chip/core/c_8_3/qb)=0.0 v(xtop.chip/core/c_8_4/q)=1.8 v(xtop.chip/core/c_8_4/qb)=0.0 v(xtop.chip/core/c_8_5/q)=1.8 v(xtop.chip/core/c_8_5/qb)=0.0 v(xtop.chip/core/c_8_6/q)=0.0 v(xtop.chip/core/c_8_6/qb)=1.8 v(xtop.chip/core/c_8_7/q)=1.8 v(xtop.chip/core/c_8_7/qb)=0.0
.ic v(xtop.chip/core/c_8_8/q)=1.8 v(xtop.chip/core/c_8_8/qb)=0.0 v(xtop.chip/core/c_8_9/q)=1.8 v(xtop.chip/core/c_8_9/qb)=0.0 v(xtop.chip/core/c_8_10/q)=0.0 v(xtop.chip/core/c_8_10/qb)=1.8 v(xtop.chip/core/c_8_11/q)=1.8 v(xtop.chip/core/c_8_11/qb)=0.0 v(xtop.chip/core/c_8_12/q)=1.8 v(xtop.chip/core/c_8_12/qb)=0.0 v(xtop.chip/core/c_8_13/q)=0.0 v(xtop.chip/core/c_8_13/qb)=1.8 v(xtop.chip/core/c_8_14/q)=1.8 v(xtop.chip/core/c_8_14/qb)=0.0 v(xtop.chip/core/c_8_15/q)=0.0 v(xtop.chip/core/c_8_15/qb)=1.8
.ic v(xtop.chip/core/c_9_0/q)=1.8 v(xtop.chip/core/c_9_0/qb)=0.0 v(xtop.chip/core/c_9_1/q)=1.8 v(xtop.chip/core/c_9_1/qb)=0.0 v(xtop.chip/core/c_9_2/q)=0.0 v(xtop.chip/core/c_9_2/qb)=1.8 v(xtop.chip/core/c_9_3/q)=0.0 v(xtop.chip/core/c_9_3/qb)=1.8 v(xtop.chip/core/c_9_4/q)=1.8 v(xtop.chip/core/c_9_4/qb)=0.0 v(xtop.chip/core/c_9_5/q)=1.8 v(xtop.chip/core/c_9_5/qb)=0.0 v(xtop.chip/core/c_9_6/q)=0.0 v(xtop.chip/core/c_9_6/qb)=1.8 v(xtop.chip/core/c_9_7/q)=1.8 v(xtop.chip/core/c_9_7/qb)=0.0
.ic v(xtop.chip/core/c_9_8/q)=1.8 v(xtop.chip/core/c_9_8/qb)=0.0 v(xtop.chip/core/c_9_9/q)=1.8 v(xtop.chip/core/c_9_9/qb)=0.0 v(xtop.chip/core/c_9_10/q)=0.0 v(xtop.chip/core/c_9_10/qb)=1.8 v(xtop.chip/core/c_9_11/q)=0.0 v(xtop.chip/core/c_9_11/qb)=1.8 v(xtop.chip/core/c_9_12/q)=0.0 v(xtop.chip/core/c_9_12/qb)=1.8 v(xtop.chip/core/c_9_13/q)=0.0 v(xtop.chip/core/c_9_13/qb)=1.8 v(xtop.chip/core/c_9_14/q)=1.8 v(xtop.chip/core/c_9_14/qb)=0.0 v(xtop.chip/core/c_9_15/q)=0.0 v(xtop.chip/core/c_9_15/qb)=1.8
.ic v(xtop.chip/core/c_10_0/q)=1.8 v(xtop.chip/core/c_10_0/qb)=0.0 v(xtop.chip/core/c_10_1/q)=0.0 v(xtop.chip/core/c_10_1/qb)=1.8 v(xtop.chip/core/c_10_2/q)=1.8 v(xtop.chip/core/c_10_2/qb)=0.0 v(xtop.chip/core/c_10_3/q)=1.8 v(xtop.chip/core/c_10_3/qb)=0.0 v(xtop.chip/core/c_10_4/q)=1.8 v(xtop.chip/core/c_10_4/qb)=0.0 v(xtop.chip/core/c_10_5/q)=1.8 v(xtop.chip/core/c_10_5/qb)=0.0 v(xtop.chip/core/c_10_6/q)=0.0 v(xtop.chip/core/c_10_6/qb)=1.8 v(xtop.chip/core/c_10_7/q)=0.0 v(xtop.chip/core/c_10_7/qb)=1.8
.ic v(xtop.chip/core/c_10_8/q)=0.0 v(xtop.chip/core/c_10_8/qb)=1.8 v(xtop.chip/core/c_10_9/q)=1.8 v(xtop.chip/core/c_10_9/qb)=0.0 v(xtop.chip/core/c_10_10/q)=0.0 v(xtop.chip/core/c_10_10/qb)=1.8 v(xtop.chip/core/c_10_11/q)=0.0 v(xtop.chip/core/c_10_11/qb)=1.8 v(xtop.chip/core/c_10_12/q)=0.0 v(xtop.chip/core/c_10_12/qb)=1.8 v(xtop.chip/core/c_10_13/q)=1.8 v(xtop.chip/core/c_10_13/qb)=0.0 v(xtop.chip/core/c_10_14/q)=1.8 v(xtop.chip/core/c_10_14/qb)=0.0 v(xtop.chip/core/c_10_15/q)=1.8 v(xtop.chip/core/c_10_15/qb)=0.0
.ic v(xtop.chip/core/c_11_0/q)=1.8 v(xtop.chip/core/c_11_0/qb)=0.0 v(xtop.chip/core/c_11_1/q)=0.0 v(xtop.chip/core/c_11_1/qb)=1.8 v(xtop.chip/core/c_11_2/q)=0.0 v(xtop.chip/core/c_11_2/qb)=1.8 v(xtop.chip/core/c_11_3/q)=1.8 v(xtop.chip/core/c_11_3/qb)=0.0 v(xtop.chip/core/c_11_4/q)=1.8 v(xtop.chip/core/c_11_4/qb)=0.0 v(xtop.chip/core/c_11_5/q)=0.0 v(xtop.chip/core/c_11_5/qb)=1.8 v(xtop.chip/core/c_11_6/q)=1.8 v(xtop.chip/core/c_11_6/qb)=0.0 v(xtop.chip/core/c_11_7/q)=1.8 v(xtop.chip/core/c_11_7/qb)=0.0
.ic v(xtop.chip/core/c_11_8/q)=1.8 v(xtop.chip/core/c_11_8/qb)=0.0 v(xtop.chip/core/c_11_9/q)=0.0 v(xtop.chip/core/c_11_9/qb)=1.8 v(xtop.chip/core/c_11_10/q)=0.0 v(xtop.chip/core/c_11_10/qb)=1.8 v(xtop.chip/core/c_11_11/q)=1.8 v(xtop.chip/core/c_11_11/qb)=0.0 v(xtop.chip/core/c_11_12/q)=1.8 v(xtop.chip/core/c_11_12/qb)=0.0 v(xtop.chip/core/c_11_13/q)=1.8 v(xtop.chip/core/c_11_13/qb)=0.0 v(xtop.chip/core/c_11_14/q)=0.0 v(xtop.chip/core/c_11_14/qb)=1.8 v(xtop.chip/core/c_11_15/q)=1.8 v(xtop.chip/core/c_11_15/qb)=0.0
.ic v(xtop.chip/core/c_12_0/q)=1.8 v(xtop.chip/core/c_12_0/qb)=0.0 v(xtop.chip/core/c_12_1/q)=0.0 v(xtop.chip/core/c_12_1/qb)=1.8 v(xtop.chip/core/c_12_2/q)=1.8 v(xtop.chip/core/c_12_2/qb)=0.0 v(xtop.chip/core/c_12_3/q)=1.8 v(xtop.chip/core/c_12_3/qb)=0.0 v(xtop.chip/core/c_12_4/q)=1.8 v(xtop.chip/core/c_12_4/qb)=0.0 v(xtop.chip/core/c_12_5/q)=0.0 v(xtop.chip/core/c_12_5/qb)=1.8 v(xtop.chip/core/c_12_6/q)=1.8 v(xtop.chip/core/c_12_6/qb)=0.0 v(xtop.chip/core/c_12_7/q)=1.8 v(xtop.chip/core/c_12_7/qb)=0.0
.ic v(xtop.chip/core/c_12_8/q)=0.0 v(xtop.chip/core/c_12_8/qb)=1.8 v(xtop.chip/core/c_12_9/q)=0.0 v(xtop.chip/core/c_12_9/qb)=1.8 v(xtop.chip/core/c_12_10/q)=0.0 v(xtop.chip/core/c_12_10/qb)=1.8 v(xtop.chip/core/c_12_11/q)=1.8 v(xtop.chip/core/c_12_11/qb)=0.0 v(xtop.chip/core/c_12_12/q)=0.0 v(xtop.chip/core/c_12_12/qb)=1.8 v(xtop.chip/core/c_12_13/q)=0.0 v(xtop.chip/core/c_12_13/qb)=1.8 v(xtop.chip/core/c_12_14/q)=1.8 v(xtop.chip/core/c_12_14/qb)=0.0 v(xtop.chip/core/c_12_15/q)=1.8 v(xtop.chip/core/c_12_15/qb)=0.0
.ic v(xtop.chip/core/c_13_0/q)=0.0 v(xtop.chip/core/c_13_0/qb)=1.8 v(xtop.chip/core/c_13_1/q)=1.8 v(xtop.chip/core/c_13_1/qb)=0.0 v(xtop.chip/core/c_13_2/q)=0.0 v(xtop.chip/core/c_13_2/qb)=1.8 v(xtop.chip/core/c_13_3/q)=1.8 v(xtop.chip/core/c_13_3/qb)=0.0 v(xtop.chip/core/c_13_4/q)=0.0 v(xtop.chip/core/c_13_4/qb)=1.8 v(xtop.chip/core/c_13_5/q)=1.8 v(xtop.chip/core/c_13_5/qb)=0.0 v(xtop.chip/core/c_13_6/q)=1.8 v(xtop.chip/core/c_13_6/qb)=0.0 v(xtop.chip/core/c_13_7/q)=1.8 v(xtop.chip/core/c_13_7/qb)=0.0
.ic v(xtop.chip/core/c_13_8/q)=0.0 v(xtop.chip/core/c_13_8/qb)=1.8 v(xtop.chip/core/c_13_9/q)=0.0 v(xtop.chip/core/c_13_9/qb)=1.8 v(xtop.chip/core/c_13_10/q)=0.0 v(xtop.chip/core/c_13_10/qb)=1.8 v(xtop.chip/core/c_13_11/q)=1.8 v(xtop.chip/core/c_13_11/qb)=0.0 v(xtop.chip/core/c_13_12/q)=0.0 v(xtop.chip/core/c_13_12/qb)=1.8 v(xtop.chip/core/c_13_13/q)=0.0 v(xtop.chip/core/c_13_13/qb)=1.8 v(xtop.chip/core/c_13_14/q)=1.8 v(xtop.chip/core/c_13_14/qb)=0.0 v(xtop.chip/core/c_13_15/q)=0.0 v(xtop.chip/core/c_13_15/qb)=1.8
.ic v(xtop.chip/core/c_14_0/q)=1.8 v(xtop.chip/core/c_14_0/qb)=0.0 v(xtop.chip/core/c_14_1/q)=0.0 v(xtop.chip/core/c_14_1/qb)=1.8 v(xtop.chip/core/c_14_2/q)=1.8 v(xtop.chip/core/c_14_2/qb)=0.0 v(xtop.chip/core/c_14_3/q)=0.0 v(xtop.chip/core/c_14_3/qb)=1.8 v(xtop.chip/core/c_14_4/q)=1.8 v(xtop.chip/core/c_14_4/qb)=0.0 v(xtop.chip/core/c_14_5/q)=0.0 v(xtop.chip/core/c_14_5/qb)=1.8 v(xtop.chip/core/c_14_6/q)=0.0 v(xtop.chip/core/c_14_6/qb)=1.8 v(xtop.chip/core/c_14_7/q)=0.0 v(xtop.chip/core/c_14_7/qb)=1.8
.ic v(xtop.chip/core/c_14_8/q)=1.8 v(xtop.chip/core/c_14_8/qb)=0.0 v(xtop.chip/core/c_14_9/q)=0.0 v(xtop.chip/core/c_14_9/qb)=1.8 v(xtop.chip/core/c_14_10/q)=1.8 v(xtop.chip/core/c_14_10/qb)=0.0 v(xtop.chip/core/c_14_11/q)=1.8 v(xtop.chip/core/c_14_11/qb)=0.0 v(xtop.chip/core/c_14_12/q)=1.8 v(xtop.chip/core/c_14_12/qb)=0.0 v(xtop.chip/core/c_14_13/q)=0.0 v(xtop.chip/core/c_14_13/qb)=1.8 v(xtop.chip/core/c_14_14/q)=0.0 v(xtop.chip/core/c_14_14/qb)=1.8 v(xtop.chip/core/c_14_15/q)=0.0 v(xtop.chip/core/c_14_15/qb)=1.8
.ic v(xtop.chip/core/c_15_0/q)=1.8 v(xtop.chip/core/c_15_0/qb)=0.0 v(xtop.chip/core/c_15_1/q)=0.0 v(xtop.chip/core/c_15_1/qb)=1.8 v(xtop.chip/core/c_15_2/q)=0.0 v(xtop.chip/core/c_15_2/qb)=1.8 v(xtop.chip/core/c_15_3/q)=0.0 v(xtop.chip/core/c_15_3/qb)=1.8 v(xtop.chip/core/c_15_4/q)=0.0 v(xtop.chip/core/c_15_4/qb)=1.8 v(xtop.chip/core/c_15_5/q)=0.0 v(xtop.chip/core/c_15_5/qb)=1.8 v(xtop.chip/core/c_15_6/q)=0.0 v(xtop.chip/core/c_15_6/qb)=1.8 v(xtop.chip/core/c_15_7/q)=0.0 v(xtop.chip/core/c_15_7/qb)=1.8
.ic v(xtop.chip/core/c_15_8/q)=1.8 v(xtop.chip/core/c_15_8/qb)=0.0 v(xtop.chip/core/c_15_9/q)=0.0 v(xtop.chip/core/c_15_9/qb)=1.8 v(xtop.chip/core/c_15_10/q)=1.8 v(xtop.chip/core/c_15_10/qb)=0.0 v(xtop.chip/core/c_15_11/q)=0.0 v(xtop.chip/core/c_15_11/qb)=1.8 v(xtop.chip/core/c_15_12/q)=0.0 v(xtop.chip/core/c_15_12/qb)=1.8 v(xtop.chip/core/c_15_13/q)=1.8 v(xtop.chip/core/c_15_13/qb)=0.0 v(xtop.chip/core/c_15_14/q)=0.0 v(xtop.chip/core/c_15_14/qb)=1.8 v(xtop.chip/core/c_15_15/q)=1.8 v(xtop.chip/core/c_15_15/qb)=0.0
.option reltol=1e-3
.tran 6.200e-11 2.0615e-07
.save v(CLK) v(ADDR) v(RW) v(DIN) v(DOUT) v(xtop.chip/ob1/a) v(xtop.chip/xck_a2/y) i(Vdd) i(Vddio)
.control
set wr_singlescale
set wr_vecnames
run
wrdata pc_ss_fmax_3.1.dat v(CLK) v(ADDR) v(RW) v(DIN) v(DOUT) v(xtop.chip/ob1/a) v(xtop.chip/xck_a2/y) i(Vdd) i(Vddio)
.endc
.end
