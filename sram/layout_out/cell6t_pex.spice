* NGSPICE file created from cell6t.ext - technology: sky130A

.subckt cell6t BL BLB WL VDD GND Q QB
X0 BLB WL QB GND sky130_fd_pr__nfet_01v8 ad=0.2184 pd=1.88 as=0.1837 ps=1.33 w=0.42 l=0.15
X1 GND QB Q GND sky130_fd_pr__nfet_01v8 ad=0.2205 pd=1.33 as=0.1837 ps=1.33 w=0.63 l=0.15
X2 VDD QB Q VDD sky130_fd_pr__pfet_01v8 ad=0.147 pd=1.12 as=0.2142 ps=1.86 w=0.42 l=0.15
X3 QB Q VDD VDD sky130_fd_pr__pfet_01v8 ad=0.2184 pd=1.88 as=0.147 ps=1.12 w=0.42 l=0.15
X4 Q WL BL GND sky130_fd_pr__nfet_01v8 ad=0.1837 pd=1.33 as=0.2184 ps=1.88 w=0.42 l=0.15
X5 QB Q GND GND sky130_fd_pr__nfet_01v8 ad=0.1837 pd=1.33 as=0.2205 ps=1.33 w=0.63 l=0.15
C0 BLB WL 0.01015f
C1 BLB Q 0.01204f
C2 BLB QB 0.03341f
C3 BL BLB 0.03559f
C4 WL Q 0.0147f
C5 WL QB 0.0129f
C6 BL WL 0.01019f
C7 Q QB 0.14296f
C8 BL Q 0.03316f
C9 BL QB 0.01207f
C10 BLB VDD 0.07919f
C11 WL VDD 0.0099f
C12 Q VDD 0.07848f
C13 QB VDD 0.11112f
C14 BL VDD 0.07915f
C15 BLB GND 0.61869f
C16 BL GND 0.36152f
C17 QB GND 0.29246f
C18 VDD GND 1.02303f
.ends
